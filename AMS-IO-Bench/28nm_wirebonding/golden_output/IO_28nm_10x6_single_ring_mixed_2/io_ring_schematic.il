pdb3ac_h_gMaster = dbOpenCellView("tphn28hpcpgv18" "PDB3AC_H_G" "symbol")
dbCreateInst(cv pdb3ac_h_gMaster "VINP_left0" '(0 20.8125) "R270")
schCreateWire(cv "route" "full" '((0.000 21.000) (-0.750 21.000)) 0 0 0 nil nil)
schCreateWireLabel(cv nil '(-0.250 21.000) "VINP" "lowerRight" "R0" "stick" 0.0625 nil)
schCreatePin(cv nil "VINP" "inputOutput" nil '(-0.750 21.000) "R0")
schCreateWire(cv "route" "full" '((0.875 21.062) (1.625 21.062)) 0 0 0 nil nil)
schCreateWireLabel(cv nil '(1.125 21.062) "AVSS" "lowerLeft" "R0" "stick" 0.0625 nil)
schCreateWire(cv "route" "full" '((0.875 20.688) (1.625 20.688)) 0 0 0 nil nil)
schCreateWireLabel(cv nil '(1.125 20.688) "GIOL" "lowerLeft" "R0" "stick" 0.0625 nil)
schCreateWire(cv "route" "full" '((0.875 21.438) (1.625 21.438)) 0 0 0 nil nil)
schCreateWireLabel(cv nil '(1.125 21.438) "AVDD" "lowerLeft" "R0" "stick" 0.0625 nil)
dbCreateInst(cv pdb3ac_h_gMaster "VINN_left1" '(0 18.8125) "R270")
schCreateWire(cv "route" "full" '((0.000 19.000) (-0.750 19.000)) 0 0 0 nil nil)
schCreateWireLabel(cv nil '(-0.250 19.000) "VINN" "lowerRight" "R0" "stick" 0.0625 nil)
schCreatePin(cv nil "VINN" "inputOutput" nil '(-0.750 19.000) "R0")
schCreateWire(cv "route" "full" '((0.875 19.062) (1.625 19.062)) 0 0 0 nil nil)
schCreateWireLabel(cv nil '(1.125 19.062) "AVSS" "lowerLeft" "R0" "stick" 0.0625 nil)
schCreateWire(cv "route" "full" '((0.875 18.688) (1.625 18.688)) 0 0 0 nil nil)
schCreateWireLabel(cv nil '(1.125 18.688) "GIOL" "lowerLeft" "R0" "stick" 0.0625 nil)
schCreateWire(cv "route" "full" '((0.875 19.438) (1.625 19.438)) 0 0 0 nil nil)
schCreateWireLabel(cv nil '(1.125 19.438) "AVDD" "lowerLeft" "R0" "stick" 0.0625 nil)
dbCreateInst(cv pdb3ac_h_gMaster "VIP_left2" '(0 16.8125) "R270")
schCreateWire(cv "route" "full" '((0.000 17.000) (-0.750 17.000)) 0 0 0 nil nil)
schCreateWireLabel(cv nil '(-0.250 17.000) "VIP" "lowerRight" "R0" "stick" 0.0625 nil)
schCreatePin(cv nil "VIP" "inputOutput" nil '(-0.750 17.000) "R0")
schCreateWire(cv "route" "full" '((0.875 17.062) (1.625 17.062)) 0 0 0 nil nil)
schCreateWireLabel(cv nil '(1.125 17.062) "AVSS" "lowerLeft" "R0" "stick" 0.0625 nil)
schCreateWire(cv "route" "full" '((0.875 16.688) (1.625 16.688)) 0 0 0 nil nil)
schCreateWireLabel(cv nil '(1.125 16.688) "GIOL" "lowerLeft" "R0" "stick" 0.0625 nil)
schCreateWire(cv "route" "full" '((0.875 17.438) (1.625 17.438)) 0 0 0 nil nil)
schCreateWireLabel(cv nil '(1.125 17.438) "AVDD" "lowerLeft" "R0" "stick" 0.0625 nil)
dbCreateInst(cv pdb3ac_h_gMaster "VIM_left3" '(0 14.8125) "R270")
schCreateWire(cv "route" "full" '((0.000 15.001) (-0.750 15.001)) 0 0 0 nil nil)
schCreateWireLabel(cv nil '(-0.250 15.001) "VIM" "lowerRight" "R0" "stick" 0.0625 nil)
schCreatePin(cv nil "VIM" "inputOutput" nil '(-0.750 15.001) "R0")
schCreateWire(cv "route" "full" '((0.875 15.062) (1.625 15.062)) 0 0 0 nil nil)
schCreateWireLabel(cv nil '(1.125 15.062) "AVSS" "lowerLeft" "R0" "stick" 0.0625 nil)
schCreateWire(cv "route" "full" '((0.875 14.688) (1.625 14.688)) 0 0 0 nil nil)
schCreateWireLabel(cv nil '(1.125 14.688) "GIOL" "lowerLeft" "R0" "stick" 0.0625 nil)
schCreateWire(cv "route" "full" '((0.875 15.438) (1.625 15.438)) 0 0 0 nil nil)
schCreateWireLabel(cv nil '(1.125 15.438) "AVDD" "lowerLeft" "R0" "stick" 0.0625 nil)
dbCreateInst(cv pdb3ac_h_gMaster "VCM_left4" '(0 12.8125) "R270")
schCreateWire(cv "route" "full" '((0.000 13.001) (-0.750 13.001)) 0 0 0 nil nil)
schCreateWireLabel(cv nil '(-0.250 13.001) "VCM" "lowerRight" "R0" "stick" 0.0625 nil)
schCreatePin(cv nil "VCM" "inputOutput" nil '(-0.750 13.001) "R0")
schCreateWire(cv "route" "full" '((0.875 13.062) (1.625 13.062)) 0 0 0 nil nil)
schCreateWireLabel(cv nil '(1.125 13.062) "AVSS" "lowerLeft" "R0" "stick" 0.0625 nil)
schCreateWire(cv "route" "full" '((0.875 12.688) (1.625 12.688)) 0 0 0 nil nil)
schCreateWireLabel(cv nil '(1.125 12.688) "GIOL" "lowerLeft" "R0" "stick" 0.0625 nil)
schCreateWire(cv "route" "full" '((0.875 13.438) (1.625 13.438)) 0 0 0 nil nil)
schCreateWireLabel(cv nil '(1.125 13.438) "AVDD" "lowerLeft" "R0" "stick" 0.0625 nil)
dbCreateInst(cv pdb3ac_h_gMaster "VREF_left5" '(0 10.8125) "R270")
schCreateWire(cv "route" "full" '((0.000 11.001) (-0.750 11.001)) 0 0 0 nil nil)
schCreateWireLabel(cv nil '(-0.250 11.001) "VREF" "lowerRight" "R0" "stick" 0.0625 nil)
schCreatePin(cv nil "VREF" "inputOutput" nil '(-0.750 11.001) "R0")
schCreateWire(cv "route" "full" '((0.875 11.062) (1.625 11.062)) 0 0 0 nil nil)
schCreateWireLabel(cv nil '(1.125 11.062) "AVSS" "lowerLeft" "R0" "stick" 0.0625 nil)
schCreateWire(cv "route" "full" '((0.875 10.688) (1.625 10.688)) 0 0 0 nil nil)
schCreateWireLabel(cv nil '(1.125 10.688) "GIOL" "lowerLeft" "R0" "stick" 0.0625 nil)
schCreateWire(cv "route" "full" '((0.875 11.438) (1.625 11.438)) 0 0 0 nil nil)
schCreateWireLabel(cv nil '(1.125 11.438) "AVDD" "lowerLeft" "R0" "stick" 0.0625 nil)
pvdd3ac_h_gMaster = dbOpenCellView("tphn28hpcpgv18" "PVDD3AC_H_G" "symbol")
dbCreateInst(cv pvdd3ac_h_gMaster "AVDD_left6" '(0 8.8125) "R270")
schCreateWire(cv "route" "full" '((0.875 9.438) (1.625 9.438)) 0 0 0 nil nil)
schCreateWireLabel(cv nil '(1.125 9.438) "AVDD_CORE" "lowerLeft" "R0" "stick" 0.0625 nil)
schCreatePin(cv nil "AVDD_CORE" "inputOutput" nil '(1.625 9.438) "R180")
schCreateWire(cv "route" "full" '((0.875 9.062) (1.625 9.062)) 0 0 0 nil nil)
schCreateWireLabel(cv nil '(1.125 9.062) "AVSS" "lowerLeft" "R0" "stick" 0.0625 nil)
schCreateWire(cv "route" "full" '((0.875 8.688) (1.625 8.688)) 0 0 0 nil nil)
schCreateWireLabel(cv nil '(1.125 8.688) "GIOL" "lowerLeft" "R0" "stick" 0.0625 nil)
schCreateWire(cv "route" "full" '((0.000 9.001) (-0.750 9.001)) 0 0 0 nil nil)
schCreateWireLabel(cv nil '(-0.250 9.001) "AVDD" "lowerRight" "R0" "stick" 0.0625 nil)
schCreatePin(cv nil "AVDD" "inputOutput" nil '(-0.750 9.001) "R0")
pvss3ac_h_gMaster = dbOpenCellView("tphn28hpcpgv18" "PVSS3AC_H_G" "symbol")
dbCreateInst(cv pvss3ac_h_gMaster "AVSS_left7" '(0 6.8125) "R270")
schCreateWire(cv "route" "full" '((0.000 7.000) (-0.750 7.000)) 0 0 0 nil nil)
schCreateWireLabel(cv nil '(-0.250 7.000) "AVSS" "lowerRight" "R0" "stick" 0.0625 nil)
schCreatePin(cv nil "AVSS" "inputOutput" nil '(-0.750 7.000) "R0")
schCreateWire(cv "route" "full" '((0.875 6.688) (1.625 6.688)) 0 0 0 nil nil)
schCreateWireLabel(cv nil '(1.125 6.688) "GIOL" "lowerLeft" "R0" "stick" 0.0625 nil)
schCreateWire(cv "route" "full" '((0.875 7.438) (1.625 7.438)) 0 0 0 nil nil)
schCreateWireLabel(cv nil '(1.125 7.438) "AVSS_CORE" "lowerLeft" "R0" "stick" 0.0625 nil)
schCreatePin(cv nil "AVSS_CORE" "inputOutput" nil '(1.625 7.438) "R180")
schCreateWire(cv "route" "full" '((0.875 7.062) (1.625 7.062)) 0 0 0 nil nil)
schCreateWireLabel(cv nil '(1.125 7.062) "AVDD" "lowerLeft" "R0" "stick" 0.0625 nil)
pddw16sdgz_h_gMaster = dbOpenCellView("tphn28hpcpgv18" "PDDW16SDGZ_H_G" "symbol")
dbCreateInst(cv pddw16sdgz_h_gMaster "D0_left8" '(0 5.6875) "R270")
schCreateWire(cv "route" "full" '((1.000 5.562) (1.750 5.562)) 0 0 0 nil nil)
schCreateWireLabel(cv nil '(1.250 5.562) "VIOL" "lowerLeft" "R0" "stick" 0.0625 nil)
noConnMaster = dbOpenCellView("basic" "noConn" "symbol")
schCreateWire(cv "route" "full" '((1.000 5.438) (1.750 5.438)) 0 0 0 nil nil)
dbCreateInst(cv noConnMaster "noConn_D0_left8_C" '(1.750 5.438) "R90")
schCreateWire(cv "route" "full" '((1.000 5.812) (1.750 5.812)) 0 0 0 nil nil)
schCreateWireLabel(cv nil '(1.250 5.812) "GIOL" "lowerLeft" "R0" "stick" 0.0625 nil)
schCreateWire(cv "route" "full" '((1.000 5.938) (1.750 5.938)) 0 0 0 nil nil)
schCreateWireLabel(cv nil '(1.250 5.938) "D0_CORE" "lowerLeft" "R0" "stick" 0.0625 nil)
schCreatePin(cv nil "D0_CORE" "inputOutput" nil '(1.750 5.938) "R180")
schCreateWire(cv "route" "full" '((0.000 5.000) (-0.750 5.000)) 0 0 0 nil nil)
schCreateWireLabel(cv nil '(-0.250 5.000) "D0" "lowerRight" "R0" "stick" 0.0625 nil)
schCreatePin(cv nil "D0" "inputOutput" nil '(-0.750 5.000) "R0")
schCreateWire(cv "route" "full" '((1.000 5.312) (1.750 5.312)) 0 0 0 nil nil)
schCreateWireLabel(cv nil '(1.250 5.312) "POC" "lowerLeft" "R0" "stick" 0.0625 nil)
schCreateWire(cv "route" "full" '((1.000 5.125) (1.750 5.125)) 0 0 0 nil nil)
schCreateWireLabel(cv nil '(1.250 5.125) "VIOL" "lowerLeft" "R0" "stick" 0.0625 nil)
schCreateWire(cv "route" "full" '((1.000 4.938) (1.750 4.938)) 0 0 0 nil nil)
schCreateWireLabel(cv nil '(1.250 4.938) "GIOL" "lowerLeft" "R0" "stick" 0.0625 nil)
schCreateWire(cv "route" "full" '((1.000 4.750) (1.750 4.750)) 0 0 0 nil nil)
schCreateWireLabel(cv nil '(1.250 4.750) "VIOH" "lowerLeft" "R0" "stick" 0.0625 nil)
schCreateWire(cv "route" "full" '((1.000 4.375) (1.750 4.375)) 0 0 0 nil nil)
schCreateWireLabel(cv nil '(1.250 4.375) "GIOH" "lowerLeft" "R0" "stick" 0.0625 nil)
dbCreateInst(cv pddw16sdgz_h_gMaster "D1_left9" '(0 3.6875) "R270")
schCreateWire(cv "route" "full" '((1.000 3.562) (1.750 3.562)) 0 0 0 nil nil)
schCreateWireLabel(cv nil '(1.250 3.562) "VIOL" "lowerLeft" "R0" "stick" 0.0625 nil)
schCreateWire(cv "route" "full" '((1.000 3.438) (1.750 3.438)) 0 0 0 nil nil)
dbCreateInst(cv noConnMaster "noConn_D1_left9_C" '(1.750 3.438) "R90")
schCreateWire(cv "route" "full" '((1.000 3.812) (1.750 3.812)) 0 0 0 nil nil)
schCreateWireLabel(cv nil '(1.250 3.812) "GIOL" "lowerLeft" "R0" "stick" 0.0625 nil)
schCreateWire(cv "route" "full" '((1.000 3.938) (1.750 3.938)) 0 0 0 nil nil)
schCreateWireLabel(cv nil '(1.250 3.938) "D1_CORE" "lowerLeft" "R0" "stick" 0.0625 nil)
schCreatePin(cv nil "D1_CORE" "inputOutput" nil '(1.750 3.938) "R180")
schCreateWire(cv "route" "full" '((0.000 3.000) (-0.750 3.000)) 0 0 0 nil nil)
schCreateWireLabel(cv nil '(-0.250 3.000) "D1" "lowerRight" "R0" "stick" 0.0625 nil)
schCreatePin(cv nil "D1" "inputOutput" nil '(-0.750 3.000) "R0")
schCreateWire(cv "route" "full" '((1.000 3.312) (1.750 3.312)) 0 0 0 nil nil)
schCreateWireLabel(cv nil '(1.250 3.312) "POC" "lowerLeft" "R0" "stick" 0.0625 nil)
schCreateWire(cv "route" "full" '((1.000 3.125) (1.750 3.125)) 0 0 0 nil nil)
schCreateWireLabel(cv nil '(1.250 3.125) "VIOL" "lowerLeft" "R0" "stick" 0.0625 nil)
schCreateWire(cv "route" "full" '((1.000 2.938) (1.750 2.938)) 0 0 0 nil nil)
schCreateWireLabel(cv nil '(1.250 2.938) "GIOL" "lowerLeft" "R0" "stick" 0.0625 nil)
schCreateWire(cv "route" "full" '((1.000 2.750) (1.750 2.750)) 0 0 0 nil nil)
schCreateWireLabel(cv nil '(1.250 2.750) "VIOH" "lowerLeft" "R0" "stick" 0.0625 nil)
schCreateWire(cv "route" "full" '((1.000 2.375) (1.750 2.375)) 0 0 0 nil nil)
schCreateWireLabel(cv nil '(1.250 2.375) "GIOH" "lowerLeft" "R0" "stick" 0.0625 nil)
pddw16sdgz_v_gMaster = dbOpenCellView("tphn28hpcpgv18" "PDDW16SDGZ_V_G" "symbol")
dbCreateInst(cv pddw16sdgz_v_gMaster "D2_bottom0" '(2.3125 0) "R0")
schCreateWire(cv "route" "full" '((2.438 1.000) (2.438 1.750)) 0 0 0 nil nil)
schCreateWireLabel(cv nil '(2.438 1.250) "VIOL" "lowerLeft" "R90" "stick" 0.0625 nil)
schCreateWire(cv "route" "full" '((2.562 1.000) (2.562 1.750)) 0 0 0 nil nil)
dbCreateInst(cv noConnMaster "noConn_D2_bottom0_C" '(2.562 1.750) "R180")
schCreateWire(cv "route" "full" '((2.188 1.000) (2.188 1.750)) 0 0 0 nil nil)
schCreateWireLabel(cv nil '(2.188 1.250) "GIOL" "lowerLeft" "R90" "stick" 0.0625 nil)
schCreateWire(cv "route" "full" '((2.062 1.000) (2.062 1.750)) 0 0 0 nil nil)
schCreateWireLabel(cv nil '(2.062 1.250) "D2_CORE" "lowerLeft" "R90" "stick" 0.0625 nil)
schCreatePin(cv nil "D2_CORE" "inputOutput" nil '(2.062 1.750) "R270")
schCreateWire(cv "route" "full" '((3.000 0.000) (3.000 -0.750)) 0 0 0 nil nil)
schCreateWireLabel(cv nil '(3.000 -0.250) "D2" "lowerRight" "R90" "stick" 0.0625 nil)
schCreatePin(cv nil "D2" "inputOutput" nil '(3.000 -0.750) "R90")
schCreateWire(cv "route" "full" '((2.688 1.000) (2.688 1.750)) 0 0 0 nil nil)
schCreateWireLabel(cv nil '(2.688 1.250) "POC" "lowerLeft" "R90" "stick" 0.0625 nil)
schCreateWire(cv "route" "full" '((2.875 1.000) (2.875 1.750)) 0 0 0 nil nil)
schCreateWireLabel(cv nil '(2.875 1.250) "VIOL" "lowerLeft" "R90" "stick" 0.0625 nil)
schCreateWire(cv "route" "full" '((3.062 1.000) (3.062 1.750)) 0 0 0 nil nil)
schCreateWireLabel(cv nil '(3.062 1.250) "GIOL" "lowerLeft" "R90" "stick" 0.0625 nil)
schCreateWire(cv "route" "full" '((3.250 1.000) (3.250 1.750)) 0 0 0 nil nil)
schCreateWireLabel(cv nil '(3.250 1.250) "VIOH" "lowerLeft" "R90" "stick" 0.0625 nil)
schCreateWire(cv "route" "full" '((3.625 1.000) (3.625 1.750)) 0 0 0 nil nil)
schCreateWireLabel(cv nil '(3.625 1.250) "GIOH" "lowerLeft" "R90" "stick" 0.0625 nil)
dbCreateInst(cv pddw16sdgz_v_gMaster "D3_bottom1" '(4.3125 0) "R0")
schCreateWire(cv "route" "full" '((4.438 1.000) (4.438 1.750)) 0 0 0 nil nil)
schCreateWireLabel(cv nil '(4.438 1.250) "VIOL" "lowerLeft" "R90" "stick" 0.0625 nil)
schCreateWire(cv "route" "full" '((4.562 1.000) (4.562 1.750)) 0 0 0 nil nil)
dbCreateInst(cv noConnMaster "noConn_D3_bottom1_C" '(4.562 1.750) "R180")
schCreateWire(cv "route" "full" '((4.188 1.000) (4.188 1.750)) 0 0 0 nil nil)
schCreateWireLabel(cv nil '(4.188 1.250) "GIOL" "lowerLeft" "R90" "stick" 0.0625 nil)
schCreateWire(cv "route" "full" '((4.062 1.000) (4.062 1.750)) 0 0 0 nil nil)
schCreateWireLabel(cv nil '(4.062 1.250) "D3_CORE" "lowerLeft" "R90" "stick" 0.0625 nil)
schCreatePin(cv nil "D3_CORE" "inputOutput" nil '(4.062 1.750) "R270")
schCreateWire(cv "route" "full" '((5.000 0.000) (5.000 -0.750)) 0 0 0 nil nil)
schCreateWireLabel(cv nil '(5.000 -0.250) "D3" "lowerRight" "R90" "stick" 0.0625 nil)
schCreatePin(cv nil "D3" "inputOutput" nil '(5.000 -0.750) "R90")
schCreateWire(cv "route" "full" '((4.688 1.000) (4.688 1.750)) 0 0 0 nil nil)
schCreateWireLabel(cv nil '(4.688 1.250) "POC" "lowerLeft" "R90" "stick" 0.0625 nil)
schCreateWire(cv "route" "full" '((4.875 1.000) (4.875 1.750)) 0 0 0 nil nil)
schCreateWireLabel(cv nil '(4.875 1.250) "VIOL" "lowerLeft" "R90" "stick" 0.0625 nil)
schCreateWire(cv "route" "full" '((5.062 1.000) (5.062 1.750)) 0 0 0 nil nil)
schCreateWireLabel(cv nil '(5.062 1.250) "GIOL" "lowerLeft" "R90" "stick" 0.0625 nil)
schCreateWire(cv "route" "full" '((5.250 1.000) (5.250 1.750)) 0 0 0 nil nil)
schCreateWireLabel(cv nil '(5.250 1.250) "VIOH" "lowerLeft" "R90" "stick" 0.0625 nil)
schCreateWire(cv "route" "full" '((5.625 1.000) (5.625 1.750)) 0 0 0 nil nil)
schCreateWireLabel(cv nil '(5.625 1.250) "GIOH" "lowerLeft" "R90" "stick" 0.0625 nil)
dbCreateInst(cv pddw16sdgz_v_gMaster "D4_bottom2" '(6.3125 0) "R0")
schCreateWire(cv "route" "full" '((6.438 1.000) (6.438 1.750)) 0 0 0 nil nil)
schCreateWireLabel(cv nil '(6.438 1.250) "VIOL" "lowerLeft" "R90" "stick" 0.0625 nil)
schCreateWire(cv "route" "full" '((6.562 1.000) (6.562 1.750)) 0 0 0 nil nil)
dbCreateInst(cv noConnMaster "noConn_D4_bottom2_C" '(6.562 1.750) "R180")
schCreateWire(cv "route" "full" '((6.188 1.000) (6.188 1.750)) 0 0 0 nil nil)
schCreateWireLabel(cv nil '(6.188 1.250) "GIOL" "lowerLeft" "R90" "stick" 0.0625 nil)
schCreateWire(cv "route" "full" '((6.062 1.000) (6.062 1.750)) 0 0 0 nil nil)
schCreateWireLabel(cv nil '(6.062 1.250) "D4_CORE" "lowerLeft" "R90" "stick" 0.0625 nil)
schCreatePin(cv nil "D4_CORE" "inputOutput" nil '(6.062 1.750) "R270")
schCreateWire(cv "route" "full" '((7.000 0.000) (7.000 -0.750)) 0 0 0 nil nil)
schCreateWireLabel(cv nil '(7.000 -0.250) "D4" "lowerRight" "R90" "stick" 0.0625 nil)
schCreatePin(cv nil "D4" "inputOutput" nil '(7.000 -0.750) "R90")
schCreateWire(cv "route" "full" '((6.688 1.000) (6.688 1.750)) 0 0 0 nil nil)
schCreateWireLabel(cv nil '(6.688 1.250) "POC" "lowerLeft" "R90" "stick" 0.0625 nil)
schCreateWire(cv "route" "full" '((6.875 1.000) (6.875 1.750)) 0 0 0 nil nil)
schCreateWireLabel(cv nil '(6.875 1.250) "VIOL" "lowerLeft" "R90" "stick" 0.0625 nil)
schCreateWire(cv "route" "full" '((7.062 1.000) (7.062 1.750)) 0 0 0 nil nil)
schCreateWireLabel(cv nil '(7.062 1.250) "GIOL" "lowerLeft" "R90" "stick" 0.0625 nil)
schCreateWire(cv "route" "full" '((7.250 1.000) (7.250 1.750)) 0 0 0 nil nil)
schCreateWireLabel(cv nil '(7.250 1.250) "VIOH" "lowerLeft" "R90" "stick" 0.0625 nil)
schCreateWire(cv "route" "full" '((7.625 1.000) (7.625 1.750)) 0 0 0 nil nil)
schCreateWireLabel(cv nil '(7.625 1.250) "GIOH" "lowerLeft" "R90" "stick" 0.0625 nil)
dbCreateInst(cv pddw16sdgz_v_gMaster "D5_bottom3" '(8.3125 0) "R0")
schCreateWire(cv "route" "full" '((8.438 1.000) (8.438 1.750)) 0 0 0 nil nil)
schCreateWireLabel(cv nil '(8.438 1.250) "VIOL" "lowerLeft" "R90" "stick" 0.0625 nil)
schCreateWire(cv "route" "full" '((8.562 1.000) (8.562 1.750)) 0 0 0 nil nil)
dbCreateInst(cv noConnMaster "noConn_D5_bottom3_C" '(8.562 1.750) "R180")
schCreateWire(cv "route" "full" '((8.188 1.000) (8.188 1.750)) 0 0 0 nil nil)
schCreateWireLabel(cv nil '(8.188 1.250) "GIOL" "lowerLeft" "R90" "stick" 0.0625 nil)
schCreateWire(cv "route" "full" '((8.062 1.000) (8.062 1.750)) 0 0 0 nil nil)
schCreateWireLabel(cv nil '(8.062 1.250) "D5_CORE" "lowerLeft" "R90" "stick" 0.0625 nil)
schCreatePin(cv nil "D5_CORE" "inputOutput" nil '(8.062 1.750) "R270")
schCreateWire(cv "route" "full" '((9.001 0.000) (9.001 -0.750)) 0 0 0 nil nil)
schCreateWireLabel(cv nil '(9.001 -0.250) "D5" "lowerRight" "R90" "stick" 0.0625 nil)
schCreatePin(cv nil "D5" "inputOutput" nil '(9.001 -0.750) "R90")
schCreateWire(cv "route" "full" '((8.688 1.000) (8.688 1.750)) 0 0 0 nil nil)
schCreateWireLabel(cv nil '(8.688 1.250) "POC" "lowerLeft" "R90" "stick" 0.0625 nil)
schCreateWire(cv "route" "full" '((8.874 1.000) (8.874 1.750)) 0 0 0 nil nil)
schCreateWireLabel(cv nil '(8.874 1.250) "VIOL" "lowerLeft" "R90" "stick" 0.0625 nil)
schCreateWire(cv "route" "full" '((9.062 1.000) (9.062 1.750)) 0 0 0 nil nil)
schCreateWireLabel(cv nil '(9.062 1.250) "GIOL" "lowerLeft" "R90" "stick" 0.0625 nil)
schCreateWire(cv "route" "full" '((9.251 1.000) (9.251 1.750)) 0 0 0 nil nil)
schCreateWireLabel(cv nil '(9.251 1.250) "VIOH" "lowerLeft" "R90" "stick" 0.0625 nil)
schCreateWire(cv "route" "full" '((9.624 1.000) (9.624 1.750)) 0 0 0 nil nil)
schCreateWireLabel(cv nil '(9.624 1.250) "GIOH" "lowerLeft" "R90" "stick" 0.0625 nil)
dbCreateInst(cv pddw16sdgz_v_gMaster "D6_bottom4" '(10.3125 0) "R0")
schCreateWire(cv "route" "full" '((10.438 1.000) (10.438 1.750)) 0 0 0 nil nil)
schCreateWireLabel(cv nil '(10.438 1.250) "VIOL" "lowerLeft" "R90" "stick" 0.0625 nil)
schCreateWire(cv "route" "full" '((10.562 1.000) (10.562 1.750)) 0 0 0 nil nil)
dbCreateInst(cv noConnMaster "noConn_D6_bottom4_C" '(10.562 1.750) "R180")
schCreateWire(cv "route" "full" '((10.188 1.000) (10.188 1.750)) 0 0 0 nil nil)
schCreateWireLabel(cv nil '(10.188 1.250) "GIOL" "lowerLeft" "R90" "stick" 0.0625 nil)
schCreateWire(cv "route" "full" '((10.062 1.000) (10.062 1.750)) 0 0 0 nil nil)
schCreateWireLabel(cv nil '(10.062 1.250) "D6_CORE" "lowerLeft" "R90" "stick" 0.0625 nil)
schCreatePin(cv nil "D6_CORE" "inputOutput" nil '(10.062 1.750) "R270")
schCreateWire(cv "route" "full" '((11.001 0.000) (11.001 -0.750)) 0 0 0 nil nil)
schCreateWireLabel(cv nil '(11.001 -0.250) "D6" "lowerRight" "R90" "stick" 0.0625 nil)
schCreatePin(cv nil "D6" "inputOutput" nil '(11.001 -0.750) "R90")
schCreateWire(cv "route" "full" '((10.688 1.000) (10.688 1.750)) 0 0 0 nil nil)
schCreateWireLabel(cv nil '(10.688 1.250) "POC" "lowerLeft" "R90" "stick" 0.0625 nil)
schCreateWire(cv "route" "full" '((10.874 1.000) (10.874 1.750)) 0 0 0 nil nil)
schCreateWireLabel(cv nil '(10.874 1.250) "VIOL" "lowerLeft" "R90" "stick" 0.0625 nil)
schCreateWire(cv "route" "full" '((11.062 1.000) (11.062 1.750)) 0 0 0 nil nil)
schCreateWireLabel(cv nil '(11.062 1.250) "GIOL" "lowerLeft" "R90" "stick" 0.0625 nil)
schCreateWire(cv "route" "full" '((11.251 1.000) (11.251 1.750)) 0 0 0 nil nil)
schCreateWireLabel(cv nil '(11.251 1.250) "VIOH" "lowerLeft" "R90" "stick" 0.0625 nil)
schCreateWire(cv "route" "full" '((11.624 1.000) (11.624 1.750)) 0 0 0 nil nil)
schCreateWireLabel(cv nil '(11.624 1.250) "GIOH" "lowerLeft" "R90" "stick" 0.0625 nil)
dbCreateInst(cv pddw16sdgz_v_gMaster "D7_bottom5" '(12.3125 0) "R0")
schCreateWire(cv "route" "full" '((12.438 1.000) (12.438 1.750)) 0 0 0 nil nil)
schCreateWireLabel(cv nil '(12.438 1.250) "VIOL" "lowerLeft" "R90" "stick" 0.0625 nil)
schCreateWire(cv "route" "full" '((12.562 1.000) (12.562 1.750)) 0 0 0 nil nil)
dbCreateInst(cv noConnMaster "noConn_D7_bottom5_C" '(12.562 1.750) "R180")
schCreateWire(cv "route" "full" '((12.188 1.000) (12.188 1.750)) 0 0 0 nil nil)
schCreateWireLabel(cv nil '(12.188 1.250) "GIOL" "lowerLeft" "R90" "stick" 0.0625 nil)
schCreateWire(cv "route" "full" '((12.062 1.000) (12.062 1.750)) 0 0 0 nil nil)
schCreateWireLabel(cv nil '(12.062 1.250) "D7_CORE" "lowerLeft" "R90" "stick" 0.0625 nil)
schCreatePin(cv nil "D7_CORE" "inputOutput" nil '(12.062 1.750) "R270")
schCreateWire(cv "route" "full" '((13.001 0.000) (13.001 -0.750)) 0 0 0 nil nil)
schCreateWireLabel(cv nil '(13.001 -0.250) "D7" "lowerRight" "R90" "stick" 0.0625 nil)
schCreatePin(cv nil "D7" "inputOutput" nil '(13.001 -0.750) "R90")
schCreateWire(cv "route" "full" '((12.688 1.000) (12.688 1.750)) 0 0 0 nil nil)
schCreateWireLabel(cv nil '(12.688 1.250) "POC" "lowerLeft" "R90" "stick" 0.0625 nil)
schCreateWire(cv "route" "full" '((12.874 1.000) (12.874 1.750)) 0 0 0 nil nil)
schCreateWireLabel(cv nil '(12.874 1.250) "VIOL" "lowerLeft" "R90" "stick" 0.0625 nil)
schCreateWire(cv "route" "full" '((13.062 1.000) (13.062 1.750)) 0 0 0 nil nil)
schCreateWireLabel(cv nil '(13.062 1.250) "GIOL" "lowerLeft" "R90" "stick" 0.0625 nil)
schCreateWire(cv "route" "full" '((13.251 1.000) (13.251 1.750)) 0 0 0 nil nil)
schCreateWireLabel(cv nil '(13.251 1.250) "VIOH" "lowerLeft" "R90" "stick" 0.0625 nil)
schCreateWire(cv "route" "full" '((13.624 1.000) (13.624 1.750)) 0 0 0 nil nil)
schCreateWireLabel(cv nil '(13.624 1.250) "GIOH" "lowerLeft" "R90" "stick" 0.0625 nil)
dbCreateInst(cv pddw16sdgz_h_gMaster "D8_right0" '(16.0 2.3125) "R90")
schCreateWire(cv "route" "full" '((15.000 2.438) (14.250 2.438)) 0 0 0 nil nil)
schCreateWireLabel(cv nil '(14.750 2.438) "VIOL" "lowerRight" "R0" "stick" 0.0625 nil)
schCreateWire(cv "route" "full" '((15.000 2.562) (14.250 2.562)) 0 0 0 nil nil)
dbCreateInst(cv noConnMaster "noConn_D8_right0_C" '(14.250 2.562) "R270")
schCreateWire(cv "route" "full" '((15.000 2.188) (14.250 2.188)) 0 0 0 nil nil)
schCreateWireLabel(cv nil '(14.750 2.188) "GIOL" "lowerRight" "R0" "stick" 0.0625 nil)
schCreateWire(cv "route" "full" '((15.000 2.062) (14.250 2.062)) 0 0 0 nil nil)
schCreateWireLabel(cv nil '(14.750 2.062) "D8_CORE" "lowerRight" "R0" "stick" 0.0625 nil)
schCreatePin(cv nil "D8_CORE" "inputOutput" nil '(14.250 2.062) "R0")
schCreateWire(cv "route" "full" '((16.000 3.000) (16.750 3.000)) 0 0 0 nil nil)
schCreateWireLabel(cv nil '(16.250 3.000) "D8" "lowerLeft" "R0" "stick" 0.0625 nil)
schCreatePin(cv nil "D8" "inputOutput" nil '(16.750 3.000) "R180")
schCreateWire(cv "route" "full" '((15.000 2.688) (14.250 2.688)) 0 0 0 nil nil)
schCreateWireLabel(cv nil '(14.750 2.688) "POC" "lowerRight" "R0" "stick" 0.0625 nil)
schCreateWire(cv "route" "full" '((15.000 2.875) (14.250 2.875)) 0 0 0 nil nil)
schCreateWireLabel(cv nil '(14.750 2.875) "VIOL" "lowerRight" "R0" "stick" 0.0625 nil)
schCreateWire(cv "route" "full" '((15.000 3.062) (14.250 3.062)) 0 0 0 nil nil)
schCreateWireLabel(cv nil '(14.750 3.062) "GIOL" "lowerRight" "R0" "stick" 0.0625 nil)
schCreateWire(cv "route" "full" '((15.000 3.250) (14.250 3.250)) 0 0 0 nil nil)
schCreateWireLabel(cv nil '(14.750 3.250) "VIOH" "lowerRight" "R0" "stick" 0.0625 nil)
schCreateWire(cv "route" "full" '((15.000 3.625) (14.250 3.625)) 0 0 0 nil nil)
schCreateWireLabel(cv nil '(14.750 3.625) "GIOH" "lowerRight" "R0" "stick" 0.0625 nil)
dbCreateInst(cv pddw16sdgz_h_gMaster "D9_right1" '(16.0 4.3125) "R90")
schCreateWire(cv "route" "full" '((15.000 4.438) (14.250 4.438)) 0 0 0 nil nil)
schCreateWireLabel(cv nil '(14.750 4.438) "VIOL" "lowerRight" "R0" "stick" 0.0625 nil)
schCreateWire(cv "route" "full" '((15.000 4.562) (14.250 4.562)) 0 0 0 nil nil)
dbCreateInst(cv noConnMaster "noConn_D9_right1_C" '(14.250 4.562) "R270")
schCreateWire(cv "route" "full" '((15.000 4.188) (14.250 4.188)) 0 0 0 nil nil)
schCreateWireLabel(cv nil '(14.750 4.188) "GIOL" "lowerRight" "R0" "stick" 0.0625 nil)
schCreateWire(cv "route" "full" '((15.000 4.062) (14.250 4.062)) 0 0 0 nil nil)
schCreateWireLabel(cv nil '(14.750 4.062) "D9_CORE" "lowerRight" "R0" "stick" 0.0625 nil)
schCreatePin(cv nil "D9_CORE" "inputOutput" nil '(14.250 4.062) "R0")
schCreateWire(cv "route" "full" '((16.000 5.000) (16.750 5.000)) 0 0 0 nil nil)
schCreateWireLabel(cv nil '(16.250 5.000) "D9" "lowerLeft" "R0" "stick" 0.0625 nil)
schCreatePin(cv nil "D9" "inputOutput" nil '(16.750 5.000) "R180")
schCreateWire(cv "route" "full" '((15.000 4.688) (14.250 4.688)) 0 0 0 nil nil)
schCreateWireLabel(cv nil '(14.750 4.688) "POC" "lowerRight" "R0" "stick" 0.0625 nil)
schCreateWire(cv "route" "full" '((15.000 4.875) (14.250 4.875)) 0 0 0 nil nil)
schCreateWireLabel(cv nil '(14.750 4.875) "VIOL" "lowerRight" "R0" "stick" 0.0625 nil)
schCreateWire(cv "route" "full" '((15.000 5.062) (14.250 5.062)) 0 0 0 nil nil)
schCreateWireLabel(cv nil '(14.750 5.062) "GIOL" "lowerRight" "R0" "stick" 0.0625 nil)
schCreateWire(cv "route" "full" '((15.000 5.250) (14.250 5.250)) 0 0 0 nil nil)
schCreateWireLabel(cv nil '(14.750 5.250) "VIOH" "lowerRight" "R0" "stick" 0.0625 nil)
schCreateWire(cv "route" "full" '((15.000 5.625) (14.250 5.625)) 0 0 0 nil nil)
schCreateWireLabel(cv nil '(14.750 5.625) "GIOH" "lowerRight" "R0" "stick" 0.0625 nil)
dbCreateInst(cv pddw16sdgz_h_gMaster "D10_right2" '(16.0 6.3125) "R90")
schCreateWire(cv "route" "full" '((15.000 6.438) (14.250 6.438)) 0 0 0 nil nil)
schCreateWireLabel(cv nil '(14.750 6.438) "VIOL" "lowerRight" "R0" "stick" 0.0625 nil)
schCreateWire(cv "route" "full" '((15.000 6.562) (14.250 6.562)) 0 0 0 nil nil)
dbCreateInst(cv noConnMaster "noConn_D10_right2_C" '(14.250 6.562) "R270")
schCreateWire(cv "route" "full" '((15.000 6.188) (14.250 6.188)) 0 0 0 nil nil)
schCreateWireLabel(cv nil '(14.750 6.188) "GIOL" "lowerRight" "R0" "stick" 0.0625 nil)
schCreateWire(cv "route" "full" '((15.000 6.062) (14.250 6.062)) 0 0 0 nil nil)
schCreateWireLabel(cv nil '(14.750 6.062) "D10_CORE" "lowerRight" "R0" "stick" 0.0625 nil)
schCreatePin(cv nil "D10_CORE" "inputOutput" nil '(14.250 6.062) "R0")
schCreateWire(cv "route" "full" '((16.000 7.000) (16.750 7.000)) 0 0 0 nil nil)
schCreateWireLabel(cv nil '(16.250 7.000) "D10" "lowerLeft" "R0" "stick" 0.0625 nil)
schCreatePin(cv nil "D10" "inputOutput" nil '(16.750 7.000) "R180")
schCreateWire(cv "route" "full" '((15.000 6.688) (14.250 6.688)) 0 0 0 nil nil)
schCreateWireLabel(cv nil '(14.750 6.688) "POC" "lowerRight" "R0" "stick" 0.0625 nil)
schCreateWire(cv "route" "full" '((15.000 6.875) (14.250 6.875)) 0 0 0 nil nil)
schCreateWireLabel(cv nil '(14.750 6.875) "VIOL" "lowerRight" "R0" "stick" 0.0625 nil)
schCreateWire(cv "route" "full" '((15.000 7.062) (14.250 7.062)) 0 0 0 nil nil)
schCreateWireLabel(cv nil '(14.750 7.062) "GIOL" "lowerRight" "R0" "stick" 0.0625 nil)
schCreateWire(cv "route" "full" '((15.000 7.250) (14.250 7.250)) 0 0 0 nil nil)
schCreateWireLabel(cv nil '(14.750 7.250) "VIOH" "lowerRight" "R0" "stick" 0.0625 nil)
schCreateWire(cv "route" "full" '((15.000 7.625) (14.250 7.625)) 0 0 0 nil nil)
schCreateWireLabel(cv nil '(14.750 7.625) "GIOH" "lowerRight" "R0" "stick" 0.0625 nil)
dbCreateInst(cv pddw16sdgz_h_gMaster "D11_right3" '(16.0 8.3125) "R90")
schCreateWire(cv "route" "full" '((15.000 8.438) (14.250 8.438)) 0 0 0 nil nil)
schCreateWireLabel(cv nil '(14.750 8.438) "VIOL" "lowerRight" "R0" "stick" 0.0625 nil)
schCreateWire(cv "route" "full" '((15.000 8.562) (14.250 8.562)) 0 0 0 nil nil)
dbCreateInst(cv noConnMaster "noConn_D11_right3_C" '(14.250 8.562) "R270")
schCreateWire(cv "route" "full" '((15.000 8.188) (14.250 8.188)) 0 0 0 nil nil)
schCreateWireLabel(cv nil '(14.750 8.188) "GIOL" "lowerRight" "R0" "stick" 0.0625 nil)
schCreateWire(cv "route" "full" '((15.000 8.062) (14.250 8.062)) 0 0 0 nil nil)
schCreateWireLabel(cv nil '(14.750 8.062) "D11_CORE" "lowerRight" "R0" "stick" 0.0625 nil)
schCreatePin(cv nil "D11_CORE" "inputOutput" nil '(14.250 8.062) "R0")
schCreateWire(cv "route" "full" '((16.000 9.001) (16.750 9.001)) 0 0 0 nil nil)
schCreateWireLabel(cv nil '(16.250 9.001) "D11" "lowerLeft" "R0" "stick" 0.0625 nil)
schCreatePin(cv nil "D11" "inputOutput" nil '(16.750 9.001) "R180")
schCreateWire(cv "route" "full" '((15.000 8.688) (14.250 8.688)) 0 0 0 nil nil)
schCreateWireLabel(cv nil '(14.750 8.688) "POC" "lowerRight" "R0" "stick" 0.0625 nil)
schCreateWire(cv "route" "full" '((15.000 8.874) (14.250 8.874)) 0 0 0 nil nil)
schCreateWireLabel(cv nil '(14.750 8.874) "VIOL" "lowerRight" "R0" "stick" 0.0625 nil)
schCreateWire(cv "route" "full" '((15.000 9.062) (14.250 9.062)) 0 0 0 nil nil)
schCreateWireLabel(cv nil '(14.750 9.062) "GIOL" "lowerRight" "R0" "stick" 0.0625 nil)
schCreateWire(cv "route" "full" '((15.000 9.251) (14.250 9.251)) 0 0 0 nil nil)
schCreateWireLabel(cv nil '(14.750 9.251) "VIOH" "lowerRight" "R0" "stick" 0.0625 nil)
schCreateWire(cv "route" "full" '((15.000 9.624) (14.250 9.624)) 0 0 0 nil nil)
schCreateWireLabel(cv nil '(14.750 9.624) "GIOH" "lowerRight" "R0" "stick" 0.0625 nil)
dbCreateInst(cv pddw16sdgz_h_gMaster "D12_right4" '(16.0 10.3125) "R90")
schCreateWire(cv "route" "full" '((15.000 10.438) (14.250 10.438)) 0 0 0 nil nil)
schCreateWireLabel(cv nil '(14.750 10.438) "VIOL" "lowerRight" "R0" "stick" 0.0625 nil)
schCreateWire(cv "route" "full" '((15.000 10.562) (14.250 10.562)) 0 0 0 nil nil)
dbCreateInst(cv noConnMaster "noConn_D12_right4_C" '(14.250 10.562) "R270")
schCreateWire(cv "route" "full" '((15.000 10.188) (14.250 10.188)) 0 0 0 nil nil)
schCreateWireLabel(cv nil '(14.750 10.188) "GIOL" "lowerRight" "R0" "stick" 0.0625 nil)
schCreateWire(cv "route" "full" '((15.000 10.062) (14.250 10.062)) 0 0 0 nil nil)
schCreateWireLabel(cv nil '(14.750 10.062) "D12_CORE" "lowerRight" "R0" "stick" 0.0625 nil)
schCreatePin(cv nil "D12_CORE" "inputOutput" nil '(14.250 10.062) "R0")
schCreateWire(cv "route" "full" '((16.000 11.001) (16.750 11.001)) 0 0 0 nil nil)
schCreateWireLabel(cv nil '(16.250 11.001) "D12" "lowerLeft" "R0" "stick" 0.0625 nil)
schCreatePin(cv nil "D12" "inputOutput" nil '(16.750 11.001) "R180")
schCreateWire(cv "route" "full" '((15.000 10.688) (14.250 10.688)) 0 0 0 nil nil)
schCreateWireLabel(cv nil '(14.750 10.688) "POC" "lowerRight" "R0" "stick" 0.0625 nil)
schCreateWire(cv "route" "full" '((15.000 10.874) (14.250 10.874)) 0 0 0 nil nil)
schCreateWireLabel(cv nil '(14.750 10.874) "VIOL" "lowerRight" "R0" "stick" 0.0625 nil)
schCreateWire(cv "route" "full" '((15.000 11.062) (14.250 11.062)) 0 0 0 nil nil)
schCreateWireLabel(cv nil '(14.750 11.062) "GIOL" "lowerRight" "R0" "stick" 0.0625 nil)
schCreateWire(cv "route" "full" '((15.000 11.251) (14.250 11.251)) 0 0 0 nil nil)
schCreateWireLabel(cv nil '(14.750 11.251) "VIOH" "lowerRight" "R0" "stick" 0.0625 nil)
schCreateWire(cv "route" "full" '((15.000 11.624) (14.250 11.624)) 0 0 0 nil nil)
schCreateWireLabel(cv nil '(14.750 11.624) "GIOH" "lowerRight" "R0" "stick" 0.0625 nil)
dbCreateInst(cv pddw16sdgz_h_gMaster "D13_right5" '(16.0 12.3125) "R90")
schCreateWire(cv "route" "full" '((15.000 12.438) (14.250 12.438)) 0 0 0 nil nil)
schCreateWireLabel(cv nil '(14.750 12.438) "VIOL" "lowerRight" "R0" "stick" 0.0625 nil)
schCreateWire(cv "route" "full" '((15.000 12.562) (14.250 12.562)) 0 0 0 nil nil)
dbCreateInst(cv noConnMaster "noConn_D13_right5_C" '(14.250 12.562) "R270")
schCreateWire(cv "route" "full" '((15.000 12.188) (14.250 12.188)) 0 0 0 nil nil)
schCreateWireLabel(cv nil '(14.750 12.188) "GIOL" "lowerRight" "R0" "stick" 0.0625 nil)
schCreateWire(cv "route" "full" '((15.000 12.062) (14.250 12.062)) 0 0 0 nil nil)
schCreateWireLabel(cv nil '(14.750 12.062) "D13_CORE" "lowerRight" "R0" "stick" 0.0625 nil)
schCreatePin(cv nil "D13_CORE" "inputOutput" nil '(14.250 12.062) "R0")
schCreateWire(cv "route" "full" '((16.000 13.001) (16.750 13.001)) 0 0 0 nil nil)
schCreateWireLabel(cv nil '(16.250 13.001) "D13" "lowerLeft" "R0" "stick" 0.0625 nil)
schCreatePin(cv nil "D13" "inputOutput" nil '(16.750 13.001) "R180")
schCreateWire(cv "route" "full" '((15.000 12.688) (14.250 12.688)) 0 0 0 nil nil)
schCreateWireLabel(cv nil '(14.750 12.688) "POC" "lowerRight" "R0" "stick" 0.0625 nil)
schCreateWire(cv "route" "full" '((15.000 12.874) (14.250 12.874)) 0 0 0 nil nil)
schCreateWireLabel(cv nil '(14.750 12.874) "VIOL" "lowerRight" "R0" "stick" 0.0625 nil)
schCreateWire(cv "route" "full" '((15.000 13.062) (14.250 13.062)) 0 0 0 nil nil)
schCreateWireLabel(cv nil '(14.750 13.062) "GIOL" "lowerRight" "R0" "stick" 0.0625 nil)
schCreateWire(cv "route" "full" '((15.000 13.251) (14.250 13.251)) 0 0 0 nil nil)
schCreateWireLabel(cv nil '(14.750 13.251) "VIOH" "lowerRight" "R0" "stick" 0.0625 nil)
schCreateWire(cv "route" "full" '((15.000 13.624) (14.250 13.624)) 0 0 0 nil nil)
schCreateWireLabel(cv nil '(14.750 13.624) "GIOH" "lowerRight" "R0" "stick" 0.0625 nil)
dbCreateInst(cv pddw16sdgz_h_gMaster "D14_right6" '(16.0 14.3125) "R90")
schCreateWire(cv "route" "full" '((15.000 14.438) (14.250 14.438)) 0 0 0 nil nil)
schCreateWireLabel(cv nil '(14.750 14.438) "VIOL" "lowerRight" "R0" "stick" 0.0625 nil)
schCreateWire(cv "route" "full" '((15.000 14.562) (14.250 14.562)) 0 0 0 nil nil)
dbCreateInst(cv noConnMaster "noConn_D14_right6_C" '(14.250 14.562) "R270")
schCreateWire(cv "route" "full" '((15.000 14.188) (14.250 14.188)) 0 0 0 nil nil)
schCreateWireLabel(cv nil '(14.750 14.188) "GIOL" "lowerRight" "R0" "stick" 0.0625 nil)
schCreateWire(cv "route" "full" '((15.000 14.062) (14.250 14.062)) 0 0 0 nil nil)
schCreateWireLabel(cv nil '(14.750 14.062) "D14_CORE" "lowerRight" "R0" "stick" 0.0625 nil)
schCreatePin(cv nil "D14_CORE" "inputOutput" nil '(14.250 14.062) "R0")
schCreateWire(cv "route" "full" '((16.000 15.001) (16.750 15.001)) 0 0 0 nil nil)
schCreateWireLabel(cv nil '(16.250 15.001) "D14" "lowerLeft" "R0" "stick" 0.0625 nil)
schCreatePin(cv nil "D14" "inputOutput" nil '(16.750 15.001) "R180")
schCreateWire(cv "route" "full" '((15.000 14.688) (14.250 14.688)) 0 0 0 nil nil)
schCreateWireLabel(cv nil '(14.750 14.688) "POC" "lowerRight" "R0" "stick" 0.0625 nil)
schCreateWire(cv "route" "full" '((15.000 14.874) (14.250 14.874)) 0 0 0 nil nil)
schCreateWireLabel(cv nil '(14.750 14.874) "VIOL" "lowerRight" "R0" "stick" 0.0625 nil)
schCreateWire(cv "route" "full" '((15.000 15.062) (14.250 15.062)) 0 0 0 nil nil)
schCreateWireLabel(cv nil '(14.750 15.062) "GIOL" "lowerRight" "R0" "stick" 0.0625 nil)
schCreateWire(cv "route" "full" '((15.000 15.251) (14.250 15.251)) 0 0 0 nil nil)
schCreateWireLabel(cv nil '(14.750 15.251) "VIOH" "lowerRight" "R0" "stick" 0.0625 nil)
schCreateWire(cv "route" "full" '((15.000 15.624) (14.250 15.624)) 0 0 0 nil nil)
schCreateWireLabel(cv nil '(14.750 15.624) "GIOH" "lowerRight" "R0" "stick" 0.0625 nil)
dbCreateInst(cv pddw16sdgz_h_gMaster "D15_right7" '(16.0 16.3125) "R90")
schCreateWire(cv "route" "full" '((15.000 16.438) (14.250 16.438)) 0 0 0 nil nil)
schCreateWireLabel(cv nil '(14.750 16.438) "VIOL" "lowerRight" "R0" "stick" 0.0625 nil)
schCreateWire(cv "route" "full" '((15.000 16.562) (14.250 16.562)) 0 0 0 nil nil)
dbCreateInst(cv noConnMaster "noConn_D15_right7_C" '(14.250 16.562) "R270")
schCreateWire(cv "route" "full" '((15.000 16.188) (14.250 16.188)) 0 0 0 nil nil)
schCreateWireLabel(cv nil '(14.750 16.188) "GIOL" "lowerRight" "R0" "stick" 0.0625 nil)
schCreateWire(cv "route" "full" '((15.000 16.062) (14.250 16.062)) 0 0 0 nil nil)
schCreateWireLabel(cv nil '(14.750 16.062) "D15_CORE" "lowerRight" "R0" "stick" 0.0625 nil)
schCreatePin(cv nil "D15_CORE" "inputOutput" nil '(14.250 16.062) "R0")
schCreateWire(cv "route" "full" '((16.000 17.000) (16.750 17.000)) 0 0 0 nil nil)
schCreateWireLabel(cv nil '(16.250 17.000) "D15" "lowerLeft" "R0" "stick" 0.0625 nil)
schCreatePin(cv nil "D15" "inputOutput" nil '(16.750 17.000) "R180")
schCreateWire(cv "route" "full" '((15.000 16.688) (14.250 16.688)) 0 0 0 nil nil)
schCreateWireLabel(cv nil '(14.750 16.688) "POC" "lowerRight" "R0" "stick" 0.0625 nil)
schCreateWire(cv "route" "full" '((15.000 16.875) (14.250 16.875)) 0 0 0 nil nil)
schCreateWireLabel(cv nil '(14.750 16.875) "VIOL" "lowerRight" "R0" "stick" 0.0625 nil)
schCreateWire(cv "route" "full" '((15.000 17.062) (14.250 17.062)) 0 0 0 nil nil)
schCreateWireLabel(cv nil '(14.750 17.062) "GIOL" "lowerRight" "R0" "stick" 0.0625 nil)
schCreateWire(cv "route" "full" '((15.000 17.250) (14.250 17.250)) 0 0 0 nil nil)
schCreateWireLabel(cv nil '(14.750 17.250) "VIOH" "lowerRight" "R0" "stick" 0.0625 nil)
schCreateWire(cv "route" "full" '((15.000 17.625) (14.250 17.625)) 0 0 0 nil nil)
schCreateWireLabel(cv nil '(14.750 17.625) "GIOH" "lowerRight" "R0" "stick" 0.0625 nil)
dbCreateInst(cv pddw16sdgz_h_gMaster "D16_right8" '(16.0 18.3125) "R90")
schCreateWire(cv "route" "full" '((15.000 18.438) (14.250 18.438)) 0 0 0 nil nil)
schCreateWireLabel(cv nil '(14.750 18.438) "VIOL" "lowerRight" "R0" "stick" 0.0625 nil)
schCreateWire(cv "route" "full" '((15.000 18.562) (14.250 18.562)) 0 0 0 nil nil)
dbCreateInst(cv noConnMaster "noConn_D16_right8_C" '(14.250 18.562) "R270")
schCreateWire(cv "route" "full" '((15.000 18.188) (14.250 18.188)) 0 0 0 nil nil)
schCreateWireLabel(cv nil '(14.750 18.188) "GIOL" "lowerRight" "R0" "stick" 0.0625 nil)
schCreateWire(cv "route" "full" '((15.000 18.062) (14.250 18.062)) 0 0 0 nil nil)
schCreateWireLabel(cv nil '(14.750 18.062) "D16_CORE" "lowerRight" "R0" "stick" 0.0625 nil)
schCreatePin(cv nil "D16_CORE" "inputOutput" nil '(14.250 18.062) "R0")
schCreateWire(cv "route" "full" '((16.000 19.000) (16.750 19.000)) 0 0 0 nil nil)
schCreateWireLabel(cv nil '(16.250 19.000) "D16" "lowerLeft" "R0" "stick" 0.0625 nil)
schCreatePin(cv nil "D16" "inputOutput" nil '(16.750 19.000) "R180")
schCreateWire(cv "route" "full" '((15.000 18.688) (14.250 18.688)) 0 0 0 nil nil)
schCreateWireLabel(cv nil '(14.750 18.688) "POC" "lowerRight" "R0" "stick" 0.0625 nil)
schCreateWire(cv "route" "full" '((15.000 18.875) (14.250 18.875)) 0 0 0 nil nil)
schCreateWireLabel(cv nil '(14.750 18.875) "VIOL" "lowerRight" "R0" "stick" 0.0625 nil)
schCreateWire(cv "route" "full" '((15.000 19.062) (14.250 19.062)) 0 0 0 nil nil)
schCreateWireLabel(cv nil '(14.750 19.062) "GIOL" "lowerRight" "R0" "stick" 0.0625 nil)
schCreateWire(cv "route" "full" '((15.000 19.250) (14.250 19.250)) 0 0 0 nil nil)
schCreateWireLabel(cv nil '(14.750 19.250) "VIOH" "lowerRight" "R0" "stick" 0.0625 nil)
schCreateWire(cv "route" "full" '((15.000 19.625) (14.250 19.625)) 0 0 0 nil nil)
schCreateWireLabel(cv nil '(14.750 19.625) "GIOH" "lowerRight" "R0" "stick" 0.0625 nil)
dbCreateInst(cv pddw16sdgz_h_gMaster "D17_right9" '(16.0 20.3125) "R90")
schCreateWire(cv "route" "full" '((15.000 20.438) (14.250 20.438)) 0 0 0 nil nil)
schCreateWireLabel(cv nil '(14.750 20.438) "VIOL" "lowerRight" "R0" "stick" 0.0625 nil)
schCreateWire(cv "route" "full" '((15.000 20.562) (14.250 20.562)) 0 0 0 nil nil)
dbCreateInst(cv noConnMaster "noConn_D17_right9_C" '(14.250 20.562) "R270")
schCreateWire(cv "route" "full" '((15.000 20.188) (14.250 20.188)) 0 0 0 nil nil)
schCreateWireLabel(cv nil '(14.750 20.188) "GIOL" "lowerRight" "R0" "stick" 0.0625 nil)
schCreateWire(cv "route" "full" '((15.000 20.062) (14.250 20.062)) 0 0 0 nil nil)
schCreateWireLabel(cv nil '(14.750 20.062) "D17_CORE" "lowerRight" "R0" "stick" 0.0625 nil)
schCreatePin(cv nil "D17_CORE" "inputOutput" nil '(14.250 20.062) "R0")
schCreateWire(cv "route" "full" '((16.000 21.000) (16.750 21.000)) 0 0 0 nil nil)
schCreateWireLabel(cv nil '(16.250 21.000) "D17" "lowerLeft" "R0" "stick" 0.0625 nil)
schCreatePin(cv nil "D17" "inputOutput" nil '(16.750 21.000) "R180")
schCreateWire(cv "route" "full" '((15.000 20.688) (14.250 20.688)) 0 0 0 nil nil)
schCreateWireLabel(cv nil '(14.750 20.688) "POC" "lowerRight" "R0" "stick" 0.0625 nil)
schCreateWire(cv "route" "full" '((15.000 20.875) (14.250 20.875)) 0 0 0 nil nil)
schCreateWireLabel(cv nil '(14.750 20.875) "VIOL" "lowerRight" "R0" "stick" 0.0625 nil)
schCreateWire(cv "route" "full" '((15.000 21.062) (14.250 21.062)) 0 0 0 nil nil)
schCreateWireLabel(cv nil '(14.750 21.062) "GIOL" "lowerRight" "R0" "stick" 0.0625 nil)
schCreateWire(cv "route" "full" '((15.000 21.250) (14.250 21.250)) 0 0 0 nil nil)
schCreateWireLabel(cv nil '(14.750 21.250) "VIOH" "lowerRight" "R0" "stick" 0.0625 nil)
schCreateWire(cv "route" "full" '((15.000 21.625) (14.250 21.625)) 0 0 0 nil nil)
schCreateWireLabel(cv nil '(14.750 21.625) "GIOH" "lowerRight" "R0" "stick" 0.0625 nil)
dbCreateInst(cv pddw16sdgz_v_gMaster "SDI_top0" '(13.6875 24.0) "R180")
schCreateWire(cv "route" "full" '((13.562 23.000) (13.562 22.250)) 0 0 0 nil nil)
schCreateWireLabel(cv nil '(13.562 22.750) "GIOL" "lowerRight" "R90" "stick" 0.0625 nil)
schCreateWire(cv "route" "full" '((13.438 23.000) (13.438 22.250)) 0 0 0 nil nil)
schCreateWireLabel(cv nil '(13.438 22.750) "SDI_CORE" "lowerRight" "R90" "stick" 0.0625 nil)
schCreatePin(cv nil "SDI_CORE" "inputOutput" nil '(13.438 22.250) "R90")
schCreateWire(cv "route" "full" '((13.812 23.000) (13.812 22.250)) 0 0 0 nil nil)
schCreateWireLabel(cv nil '(13.812 22.750) "VIOL" "lowerRight" "R90" "stick" 0.0625 nil)
schCreateWire(cv "route" "full" '((13.938 23.000) (13.938 22.250)) 0 0 0 nil nil)
schCreateWireLabel(cv nil '(13.938 22.750) "GIOL" "lowerRight" "R90" "stick" 0.0625 nil)
schCreateWire(cv "route" "full" '((12.999 24.000) (12.999 24.750)) 0 0 0 nil nil)
schCreateWireLabel(cv nil '(12.999 24.250) "SDI" "lowerLeft" "R90" "stick" 0.0625 nil)
schCreatePin(cv nil "SDI" "inputOutput" nil '(12.999 24.750) "R270")
schCreateWire(cv "route" "full" '((13.312 23.000) (13.312 22.250)) 0 0 0 nil nil)
schCreateWireLabel(cv nil '(13.312 22.750) "POC" "lowerRight" "R90" "stick" 0.0625 nil)
schCreateWire(cv "route" "full" '((13.126 23.000) (13.126 22.250)) 0 0 0 nil nil)
schCreateWireLabel(cv nil '(13.126 22.750) "VIOL" "lowerRight" "R90" "stick" 0.0625 nil)
schCreateWire(cv "route" "full" '((12.938 23.000) (12.938 22.250)) 0 0 0 nil nil)
schCreateWireLabel(cv nil '(12.938 22.750) "GIOL" "lowerRight" "R90" "stick" 0.0625 nil)
schCreateWire(cv "route" "full" '((12.749 23.000) (12.749 22.250)) 0 0 0 nil nil)
schCreateWireLabel(cv nil '(12.749 22.750) "VIOH" "lowerRight" "R90" "stick" 0.0625 nil)
schCreateWire(cv "route" "full" '((12.376 23.000) (12.376 22.250)) 0 0 0 nil nil)
schCreateWireLabel(cv nil '(12.376 22.750) "GIOH" "lowerRight" "R90" "stick" 0.0625 nil)
dbCreateInst(cv pddw16sdgz_v_gMaster "SDO_top1" '(11.6875 24.0) "R180")
schCreateWire(cv "route" "full" '((11.562 23.000) (11.562 22.250)) 0 0 0 nil nil)
schCreateWireLabel(cv nil '(11.562 22.750) "VIOL" "lowerRight" "R90" "stick" 0.0625 nil)
schCreateWire(cv "route" "full" '((11.438 23.000) (11.438 22.250)) 0 0 0 nil nil)
dbCreateInst(cv noConnMaster "noConn_SDO_top1_C" '(11.438 22.250) "R0")
schCreateWire(cv "route" "full" '((11.812 23.000) (11.812 22.250)) 0 0 0 nil nil)
schCreateWireLabel(cv nil '(11.812 22.750) "GIOL" "lowerRight" "R90" "stick" 0.0625 nil)
schCreateWire(cv "route" "full" '((11.938 23.000) (11.938 22.250)) 0 0 0 nil nil)
schCreateWireLabel(cv nil '(11.938 22.750) "SDO_CORE" "lowerRight" "R90" "stick" 0.0625 nil)
schCreatePin(cv nil "SDO_CORE" "inputOutput" nil '(11.938 22.250) "R90")
schCreateWire(cv "route" "full" '((10.999 24.000) (10.999 24.750)) 0 0 0 nil nil)
schCreateWireLabel(cv nil '(10.999 24.250) "SDO" "lowerLeft" "R90" "stick" 0.0625 nil)
schCreatePin(cv nil "SDO" "inputOutput" nil '(10.999 24.750) "R270")
schCreateWire(cv "route" "full" '((11.312 23.000) (11.312 22.250)) 0 0 0 nil nil)
schCreateWireLabel(cv nil '(11.312 22.750) "POC" "lowerRight" "R90" "stick" 0.0625 nil)
schCreateWire(cv "route" "full" '((11.126 23.000) (11.126 22.250)) 0 0 0 nil nil)
schCreateWireLabel(cv nil '(11.126 22.750) "VIOL" "lowerRight" "R90" "stick" 0.0625 nil)
schCreateWire(cv "route" "full" '((10.938 23.000) (10.938 22.250)) 0 0 0 nil nil)
schCreateWireLabel(cv nil '(10.938 22.750) "GIOL" "lowerRight" "R90" "stick" 0.0625 nil)
schCreateWire(cv "route" "full" '((10.749 23.000) (10.749 22.250)) 0 0 0 nil nil)
schCreateWireLabel(cv nil '(10.749 22.750) "VIOH" "lowerRight" "R90" "stick" 0.0625 nil)
schCreateWire(cv "route" "full" '((10.376 23.000) (10.376 22.250)) 0 0 0 nil nil)
schCreateWireLabel(cv nil '(10.376 22.750) "GIOH" "lowerRight" "R90" "stick" 0.0625 nil)
pvdd1dgz_v_gMaster = dbOpenCellView("tphn28hpcpgv18" "PVDD1DGZ_V_G" "symbol")
dbCreateInst(cv pvdd1dgz_v_gMaster "VIOL_top2" '(10.0 24.0) "R180")
schCreateWire(cv "route" "full" '((9.625 23.000) (9.625 22.250)) 0 0 0 nil nil)
schCreateWireLabel(cv nil '(9.625 22.750) "POC" "lowerRight" "R90" "stick" 0.0625 nil)
schCreateWire(cv "route" "full" '((9.000 24.000) (9.000 24.750)) 0 0 0 nil nil)
schCreateWireLabel(cv nil '(9.000 24.250) "VIOL" "lowerLeft" "R90" "stick" 0.0625 nil)
schCreatePin(cv nil "VIOL" "inputOutput" nil '(9.000 24.750) "R270")
schCreateWire(cv "route" "full" '((9.250 23.000) (9.250 22.250)) 0 0 0 nil nil)
schCreateWireLabel(cv nil '(9.250 22.750) "GIOL" "lowerRight" "R90" "stick" 0.0625 nil)
schCreateWire(cv "route" "full" '((9.062 23.000) (9.062 22.250)) 0 0 0 nil nil)
schCreateWireLabel(cv nil '(9.062 22.750) "VIOH" "lowerRight" "R90" "stick" 0.0625 nil)
schCreateWire(cv "route" "full" '((8.688 23.000) (8.688 22.250)) 0 0 0 nil nil)
schCreateWireLabel(cv nil '(8.688 22.750) "GIOH" "lowerRight" "R90" "stick" 0.0625 nil)
pvss1dgz_v_gMaster = dbOpenCellView("tphn28hpcpgv18" "PVSS1DGZ_V_G" "symbol")
dbCreateInst(cv pvss1dgz_v_gMaster "GIOL_top3" '(8.0 24.0) "R180")
schCreateWire(cv "route" "full" '((7.625 23.000) (7.625 22.250)) 0 0 0 nil nil)
schCreateWireLabel(cv nil '(7.625 22.750) "POC" "lowerRight" "R90" "stick" 0.0625 nil)
schCreateWire(cv "route" "full" '((7.438 23.000) (7.438 22.250)) 0 0 0 nil nil)
schCreateWireLabel(cv nil '(7.438 22.750) "VIOL" "lowerRight" "R90" "stick" 0.0625 nil)
schCreateWire(cv "route" "full" '((7.000 24.000) (7.000 24.750)) 0 0 0 nil nil)
schCreateWireLabel(cv nil '(7.000 24.250) "GIOL" "lowerLeft" "R90" "stick" 0.0625 nil)
schCreatePin(cv nil "GIOL" "inputOutput" nil '(7.000 24.750) "R270")
schCreateWire(cv "route" "full" '((7.062 23.000) (7.062 22.250)) 0 0 0 nil nil)
schCreateWireLabel(cv nil '(7.062 22.750) "VIOH" "lowerRight" "R90" "stick" 0.0625 nil)
schCreateWire(cv "route" "full" '((6.688 23.000) (6.688 22.250)) 0 0 0 nil nil)
schCreateWireLabel(cv nil '(6.688 22.750) "GIOH" "lowerRight" "R90" "stick" 0.0625 nil)
pvdd2poc_v_gMaster = dbOpenCellView("tphn28hpcpgv18" "PVDD2POC_V_G" "symbol")
dbCreateInst(cv pvdd2poc_v_gMaster "VIOH_top4" '(6.0 24.0) "R180")
schCreateWire(cv "route" "full" '((5.625 23.000) (5.625 22.250)) 0 0 0 nil nil)
schCreateWireLabel(cv nil '(5.625 22.750) "POC" "lowerRight" "R90" "stick" 0.0625 nil)
schCreateWire(cv "route" "full" '((5.438 23.000) (5.438 22.250)) 0 0 0 nil nil)
schCreateWireLabel(cv nil '(5.438 22.750) "VIOL" "lowerRight" "R90" "stick" 0.0625 nil)
schCreateWire(cv "route" "full" '((5.250 23.000) (5.250 22.250)) 0 0 0 nil nil)
schCreateWireLabel(cv nil '(5.250 22.750) "GIOL" "lowerRight" "R90" "stick" 0.0625 nil)
schCreateWire(cv "route" "full" '((5.000 24.000) (5.000 24.750)) 0 0 0 nil nil)
schCreateWireLabel(cv nil '(5.000 24.250) "VIOH" "lowerLeft" "R90" "stick" 0.0625 nil)
schCreatePin(cv nil "VIOH" "inputOutput" nil '(5.000 24.750) "R270")
schCreateWire(cv "route" "full" '((4.688 23.000) (4.688 22.250)) 0 0 0 nil nil)
schCreateWireLabel(cv nil '(4.688 22.750) "GIOH" "lowerRight" "R90" "stick" 0.0625 nil)
pvss2dgz_v_gMaster = dbOpenCellView("tphn28hpcpgv18" "PVSS2DGZ_V_G" "symbol")
dbCreateInst(cv pvss2dgz_v_gMaster "GIOH_top5" '(4.0 24.0) "R180")
schCreateWire(cv "route" "full" '((3.625 23.000) (3.625 22.250)) 0 0 0 nil nil)
schCreateWireLabel(cv nil '(3.625 22.750) "POC" "lowerRight" "R90" "stick" 0.0625 nil)
schCreateWire(cv "route" "full" '((3.438 23.000) (3.438 22.250)) 0 0 0 nil nil)
schCreateWireLabel(cv nil '(3.438 22.750) "VIOL" "lowerRight" "R90" "stick" 0.0625 nil)
schCreateWire(cv "route" "full" '((3.250 23.000) (3.250 22.250)) 0 0 0 nil nil)
schCreateWireLabel(cv nil '(3.250 22.750) "GIOL" "lowerRight" "R90" "stick" 0.0625 nil)
schCreateWire(cv "route" "full" '((3.062 23.000) (3.062 22.250)) 0 0 0 nil nil)
schCreateWireLabel(cv nil '(3.062 22.750) "VIOH" "lowerRight" "R90" "stick" 0.0625 nil)
schCreateWire(cv "route" "full" '((3.000 24.000) (3.000 24.750)) 0 0 0 nil nil)
schCreateWireLabel(cv nil '(3.000 24.250) "GIOH" "lowerLeft" "R90" "stick" 0.0625 nil)
schCreatePin(cv nil "GIOH" "inputOutput" nil '(3.000 24.750) "R270")
schCheck(cv)
dbSave(cv)
t
