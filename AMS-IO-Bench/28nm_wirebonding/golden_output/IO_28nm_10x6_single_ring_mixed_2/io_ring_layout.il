; Generated Layout Script with Dual Ring Support

; ==================== All Components (Sorted by Placement Order) ====================
dbCreateParamInstByMasterName(cv "tphn28hpcpgv18" "PDDW16SDGZ_H_G" "layout" "D1_left_9" list(0 150) "R270")
dbCreateParamInstByMasterName(cv "PAD" "PAD60GU" "layout" "pad60gu_D1_left_9" list(0 150) "R270")
dbCreateParamInstByMasterName(cv "tphn28hpcpgv18" "PDDW16SDGZ_H_G" "layout" "D0_left_8" list(0 210) "R270")
dbCreateParamInstByMasterName(cv "PAD" "PAD60GU" "layout" "pad60gu_D0_left_8" list(0 210) "R270")
dbCreateParamInstByMasterName(cv "tphn28hpcpgv18" "PVSS3AC_H_G" "layout" "AVSS_left_7" list(0 270) "R270")
dbCreateParamInstByMasterName(cv "PAD" "PAD60GU" "layout" "pad60gu_AVSS_left_7" list(0 270) "R270")
dbCreateParamInstByMasterName(cv "tphn28hpcpgv18" "PVDD3AC_H_G" "layout" "AVDD_left_6" list(0 330) "R270")
dbCreateParamInstByMasterName(cv "PAD" "PAD60GU" "layout" "pad60gu_AVDD_left_6" list(0 330) "R270")
dbCreateParamInstByMasterName(cv "tphn28hpcpgv18" "PDB3AC_H_G" "layout" "VREF_left_5" list(0 390) "R270")
dbCreateParamInstByMasterName(cv "PAD" "PAD60GU" "layout" "pad60gu_VREF_left_5" list(0 390) "R270")
dbCreateParamInstByMasterName(cv "tphn28hpcpgv18" "PDB3AC_H_G" "layout" "VCM_left_4" list(0 450) "R270")
dbCreateParamInstByMasterName(cv "PAD" "PAD60GU" "layout" "pad60gu_VCM_left_4" list(0 450) "R270")
dbCreateParamInstByMasterName(cv "tphn28hpcpgv18" "PDB3AC_H_G" "layout" "VIM_left_3" list(0 510) "R270")
dbCreateParamInstByMasterName(cv "PAD" "PAD60GU" "layout" "pad60gu_VIM_left_3" list(0 510) "R270")
dbCreateParamInstByMasterName(cv "tphn28hpcpgv18" "PDB3AC_H_G" "layout" "VIP_left_2" list(0 570) "R270")
dbCreateParamInstByMasterName(cv "PAD" "PAD60GU" "layout" "pad60gu_VIP_left_2" list(0 570) "R270")
dbCreateParamInstByMasterName(cv "tphn28hpcpgv18" "PDB3AC_H_G" "layout" "VINN_left_1" list(0 630) "R270")
dbCreateParamInstByMasterName(cv "PAD" "PAD60GU" "layout" "pad60gu_VINN_left_1" list(0 630) "R270")
dbCreateParamInstByMasterName(cv "tphn28hpcpgv18" "PDB3AC_H_G" "layout" "VINP_left_0" list(0 690) "R270")
dbCreateParamInstByMasterName(cv "PAD" "PAD60GU" "layout" "pad60gu_VINP_left_0" list(0 690) "R270")
dbCreateParamInstByMasterName(cv "tphn28hpcpgv18" "PCORNERA_G" "layout" "CORNER_TL_top_left" list(0 820) "R270")
dbCreateParamInstByMasterName(cv "tphn28hpcpgv18" "PDDW16SDGZ_V_G" "layout" "D7_bottom_5" list(430 0) "R0")
dbCreateParamInstByMasterName(cv "PAD" "PAD60GU" "layout" "pad60gu_D7_bottom_5" list(430 0) "R0")
dbCreateParamInstByMasterName(cv "tphn28hpcpgv18" "PDDW16SDGZ_V_G" "layout" "D6_bottom_4" list(370 0) "R0")
dbCreateParamInstByMasterName(cv "PAD" "PAD60GU" "layout" "pad60gu_D6_bottom_4" list(370 0) "R0")
dbCreateParamInstByMasterName(cv "tphn28hpcpgv18" "PDDW16SDGZ_V_G" "layout" "D5_bottom_3" list(310 0) "R0")
dbCreateParamInstByMasterName(cv "PAD" "PAD60GU" "layout" "pad60gu_D5_bottom_3" list(310 0) "R0")
dbCreateParamInstByMasterName(cv "tphn28hpcpgv18" "PDDW16SDGZ_V_G" "layout" "D4_bottom_2" list(250 0) "R0")
dbCreateParamInstByMasterName(cv "PAD" "PAD60GU" "layout" "pad60gu_D4_bottom_2" list(250 0) "R0")
dbCreateParamInstByMasterName(cv "tphn28hpcpgv18" "PDDW16SDGZ_V_G" "layout" "D3_bottom_1" list(190 0) "R0")
dbCreateParamInstByMasterName(cv "PAD" "PAD60GU" "layout" "pad60gu_D3_bottom_1" list(190 0) "R0")
dbCreateParamInstByMasterName(cv "tphn28hpcpgv18" "PDDW16SDGZ_V_G" "layout" "D2_bottom_0" list(130 0) "R0")
dbCreateParamInstByMasterName(cv "PAD" "PAD60GU" "layout" "pad60gu_D2_bottom_0" list(130 0) "R0")
dbCreateParamInstByMasterName(cv "tphn28hpcpgv18" "PCORNER_G" "layout" "CORNER_BL_bottom_left" list(0 0) "R0")
dbCreateParamInstByMasterName(cv "tphn28hpcpgv18" "PDDW16SDGZ_H_G" "layout" "D17_right_9" list(580 670) "R90")
dbCreateParamInstByMasterName(cv "PAD" "PAD60GU" "layout" "pad60gu_D17_right_9" list(580 670) "R90")
dbCreateParamInstByMasterName(cv "tphn28hpcpgv18" "PDDW16SDGZ_H_G" "layout" "D16_right_8" list(580 610) "R90")
dbCreateParamInstByMasterName(cv "PAD" "PAD60GU" "layout" "pad60gu_D16_right_8" list(580 610) "R90")
dbCreateParamInstByMasterName(cv "tphn28hpcpgv18" "PDDW16SDGZ_H_G" "layout" "D15_right_7" list(580 550) "R90")
dbCreateParamInstByMasterName(cv "PAD" "PAD60GU" "layout" "pad60gu_D15_right_7" list(580 550) "R90")
dbCreateParamInstByMasterName(cv "tphn28hpcpgv18" "PDDW16SDGZ_H_G" "layout" "D14_right_6" list(580 490) "R90")
dbCreateParamInstByMasterName(cv "PAD" "PAD60GU" "layout" "pad60gu_D14_right_6" list(580 490) "R90")
dbCreateParamInstByMasterName(cv "tphn28hpcpgv18" "PDDW16SDGZ_H_G" "layout" "D13_right_5" list(580 430) "R90")
dbCreateParamInstByMasterName(cv "PAD" "PAD60GU" "layout" "pad60gu_D13_right_5" list(580 430) "R90")
dbCreateParamInstByMasterName(cv "tphn28hpcpgv18" "PDDW16SDGZ_H_G" "layout" "D12_right_4" list(580 370) "R90")
dbCreateParamInstByMasterName(cv "PAD" "PAD60GU" "layout" "pad60gu_D12_right_4" list(580 370) "R90")
dbCreateParamInstByMasterName(cv "tphn28hpcpgv18" "PDDW16SDGZ_H_G" "layout" "D11_right_3" list(580 310) "R90")
dbCreateParamInstByMasterName(cv "PAD" "PAD60GU" "layout" "pad60gu_D11_right_3" list(580 310) "R90")
dbCreateParamInstByMasterName(cv "tphn28hpcpgv18" "PDDW16SDGZ_H_G" "layout" "D10_right_2" list(580 250) "R90")
dbCreateParamInstByMasterName(cv "PAD" "PAD60GU" "layout" "pad60gu_D10_right_2" list(580 250) "R90")
dbCreateParamInstByMasterName(cv "tphn28hpcpgv18" "PDDW16SDGZ_H_G" "layout" "D9_right_1" list(580 190) "R90")
dbCreateParamInstByMasterName(cv "PAD" "PAD60GU" "layout" "pad60gu_D9_right_1" list(580 190) "R90")
dbCreateParamInstByMasterName(cv "tphn28hpcpgv18" "PDDW16SDGZ_H_G" "layout" "D8_right_0" list(580 130) "R90")
dbCreateParamInstByMasterName(cv "PAD" "PAD60GU" "layout" "pad60gu_D8_right_0" list(580 130) "R90")
dbCreateParamInstByMasterName(cv "tphn28hpcpgv18" "PCORNER_G" "layout" "CORNER_BR_bottom_right" list(580 0) "R90")
dbCreateParamInstByMasterName(cv "tphn28hpcpgv18" "PVSS2DGZ_V_G" "layout" "GIOH_top_5" list(150 820) "R180")
dbCreateParamInstByMasterName(cv "PAD" "PAD60GU" "layout" "pad60gu_GIOH_top_5" list(150 820) "R180")
dbCreateParamInstByMasterName(cv "tphn28hpcpgv18" "PVDD2POC_V_G" "layout" "VIOH_top_4" list(210 820) "R180")
dbCreateParamInstByMasterName(cv "PAD" "PAD60GU" "layout" "pad60gu_VIOH_top_4" list(210 820) "R180")
dbCreateParamInstByMasterName(cv "tphn28hpcpgv18" "PVSS1DGZ_V_G" "layout" "GIOL_top_3" list(270 820) "R180")
dbCreateParamInstByMasterName(cv "PAD" "PAD60GU" "layout" "pad60gu_GIOL_top_3" list(270 820) "R180")
dbCreateParamInstByMasterName(cv "tphn28hpcpgv18" "PVDD1DGZ_V_G" "layout" "VIOL_top_2" list(330 820) "R180")
dbCreateParamInstByMasterName(cv "PAD" "PAD60GU" "layout" "pad60gu_VIOL_top_2" list(330 820) "R180")
dbCreateParamInstByMasterName(cv "tphn28hpcpgv18" "PDDW16SDGZ_V_G" "layout" "SDO_top_1" list(390 820) "R180")
dbCreateParamInstByMasterName(cv "PAD" "PAD60GU" "layout" "pad60gu_SDO_top_1" list(390 820) "R180")
dbCreateParamInstByMasterName(cv "tphn28hpcpgv18" "PDDW16SDGZ_V_G" "layout" "SDI_top_0" list(450 820) "R180")
dbCreateParamInstByMasterName(cv "PAD" "PAD60GU" "layout" "pad60gu_SDI_top_0" list(450 820) "R180")
dbCreateParamInstByMasterName(cv "tphn28hpcpgv18" "PCORNER_G" "layout" "CORNER_TR_top_right" list(580 820) "R180")

; ==================== Filler Components ====================
dbCreateParamInstByMasterName(cv "tphn28hpcpgv18" "PFILLER20_G" "layout" "sep_bottom_right_corner" list(450 0) "R0")
dbCreateParamInstByMasterName(cv "tphn28hpcpgv18" "PFILLER20_G" "layout" "filler_bottom_left_corner" list(110 0) "R0")
dbCreateParamInstByMasterName(cv "tphn28hpcpgv18" "PFILLER20_G" "layout" "filler_R0_1_1" list(410 0) "R0")
dbCreateParamInstByMasterName(cv "tphn28hpcpgv18" "PFILLER20_G" "layout" "filler_R0_1_2" list(390 0) "R0")
dbCreateParamInstByMasterName(cv "tphn28hpcpgv18" "PFILLER20_G" "layout" "filler_R0_2_1" list(350 0) "R0")
dbCreateParamInstByMasterName(cv "tphn28hpcpgv18" "PFILLER20_G" "layout" "filler_R0_2_2" list(330 0) "R0")
dbCreateParamInstByMasterName(cv "tphn28hpcpgv18" "PFILLER20_G" "layout" "filler_R0_3_1" list(290 0) "R0")
dbCreateParamInstByMasterName(cv "tphn28hpcpgv18" "PFILLER20_G" "layout" "filler_R0_3_2" list(270 0) "R0")
dbCreateParamInstByMasterName(cv "tphn28hpcpgv18" "PFILLER20_G" "layout" "filler_R0_4_1" list(230 0) "R0")
dbCreateParamInstByMasterName(cv "tphn28hpcpgv18" "PFILLER20_G" "layout" "filler_R0_4_2" list(210 0) "R0")
dbCreateParamInstByMasterName(cv "tphn28hpcpgv18" "PFILLER20_G" "layout" "filler_R0_5_1" list(170 0) "R0")
dbCreateParamInstByMasterName(cv "tphn28hpcpgv18" "PFILLER20_G" "layout" "filler_R0_5_2" list(150 0) "R0")
dbCreateParamInstByMasterName(cv "tphn28hpcpgv18" "PFILLER20_G" "layout" "filler_right_top_corner" list(580 690) "R90")
dbCreateParamInstByMasterName(cv "tphn28hpcpgv18" "PFILLER20_G" "layout" "filler_right_bottom_corner" list(580 110) "R90")
dbCreateParamInstByMasterName(cv "tphn28hpcpgv18" "PFILLER20_G" "layout" "filler_R90_1_1" list(580 650) "R90")
dbCreateParamInstByMasterName(cv "tphn28hpcpgv18" "PFILLER20_G" "layout" "filler_R90_1_2" list(580 630) "R90")
dbCreateParamInstByMasterName(cv "tphn28hpcpgv18" "PFILLER20_G" "layout" "filler_R90_2_1" list(580 590) "R90")
dbCreateParamInstByMasterName(cv "tphn28hpcpgv18" "PFILLER20_G" "layout" "filler_R90_2_2" list(580 570) "R90")
dbCreateParamInstByMasterName(cv "tphn28hpcpgv18" "PFILLER20_G" "layout" "filler_R90_3_1" list(580 530) "R90")
dbCreateParamInstByMasterName(cv "tphn28hpcpgv18" "PFILLER20_G" "layout" "filler_R90_3_2" list(580 510) "R90")
dbCreateParamInstByMasterName(cv "tphn28hpcpgv18" "PFILLER20_G" "layout" "filler_R90_4_1" list(580 470) "R90")
dbCreateParamInstByMasterName(cv "tphn28hpcpgv18" "PFILLER20_G" "layout" "filler_R90_4_2" list(580 450) "R90")
dbCreateParamInstByMasterName(cv "tphn28hpcpgv18" "PFILLER20_G" "layout" "filler_R90_5_1" list(580 410) "R90")
dbCreateParamInstByMasterName(cv "tphn28hpcpgv18" "PFILLER20_G" "layout" "filler_R90_5_2" list(580 390) "R90")
dbCreateParamInstByMasterName(cv "tphn28hpcpgv18" "PFILLER20_G" "layout" "filler_R90_6_1" list(580 350) "R90")
dbCreateParamInstByMasterName(cv "tphn28hpcpgv18" "PFILLER20_G" "layout" "filler_R90_6_2" list(580 330) "R90")
dbCreateParamInstByMasterName(cv "tphn28hpcpgv18" "PFILLER20_G" "layout" "filler_R90_7_1" list(580 290) "R90")
dbCreateParamInstByMasterName(cv "tphn28hpcpgv18" "PFILLER20_G" "layout" "filler_R90_7_2" list(580 270) "R90")
dbCreateParamInstByMasterName(cv "tphn28hpcpgv18" "PFILLER20_G" "layout" "filler_R90_8_1" list(580 230) "R90")
dbCreateParamInstByMasterName(cv "tphn28hpcpgv18" "PFILLER20_G" "layout" "filler_R90_8_2" list(580 210) "R90")
dbCreateParamInstByMasterName(cv "tphn28hpcpgv18" "PFILLER20_G" "layout" "filler_R90_9_1" list(580 170) "R90")
dbCreateParamInstByMasterName(cv "tphn28hpcpgv18" "PFILLER20_G" "layout" "filler_R90_9_2" list(580 150) "R90")
dbCreateParamInstByMasterName(cv "tphn28hpcpgv18" "PRCUTA_G" "layout" "sep_top_left_corner" list(130 820) "R180")
dbCreateParamInstByMasterName(cv "tphn28hpcpgv18" "PFILLER20_G" "layout" "filler_top_right_corner" list(470 820) "R180")
dbCreateParamInstByMasterName(cv "tphn28hpcpgv18" "PFILLER20_G" "layout" "filler_R180_1_1" list(170 820) "R180")
dbCreateParamInstByMasterName(cv "tphn28hpcpgv18" "PFILLER20_G" "layout" "filler_R180_1_2" list(190 820) "R180")
dbCreateParamInstByMasterName(cv "tphn28hpcpgv18" "PFILLER20_G" "layout" "filler_R180_2_1" list(230 820) "R180")
dbCreateParamInstByMasterName(cv "tphn28hpcpgv18" "PFILLER20_G" "layout" "filler_R180_2_2" list(250 820) "R180")
dbCreateParamInstByMasterName(cv "tphn28hpcpgv18" "PFILLER20_G" "layout" "filler_R180_3_1" list(290 820) "R180")
dbCreateParamInstByMasterName(cv "tphn28hpcpgv18" "PFILLER20_G" "layout" "filler_R180_3_2" list(310 820) "R180")
dbCreateParamInstByMasterName(cv "tphn28hpcpgv18" "PFILLER20_G" "layout" "filler_R180_4_1" list(350 820) "R180")
dbCreateParamInstByMasterName(cv "tphn28hpcpgv18" "PFILLER20_G" "layout" "filler_R180_4_2" list(370 820) "R180")
dbCreateParamInstByMasterName(cv "tphn28hpcpgv18" "PFILLER20_G" "layout" "filler_R180_5_1" list(410 820) "R180")
dbCreateParamInstByMasterName(cv "tphn28hpcpgv18" "PFILLER20_G" "layout" "filler_R180_5_2" list(430 820) "R180")
dbCreateParamInstByMasterName(cv "tphn28hpcpgv18" "PFILLER20_G" "layout" "filler_left_bottom_corner" list(0 130) "R270")
dbCreateParamInstByMasterName(cv "tphn28hpcpgv18" "PRCUTA_G" "layout" "sep_left_top_corner" list(0 710) "R270")
dbCreateParamInstByMasterName(cv "tphn28hpcpgv18" "PFILLER20_G" "layout" "filler_R270_1_1" list(0 170) "R270")
dbCreateParamInstByMasterName(cv "tphn28hpcpgv18" "PFILLER20_G" "layout" "filler_R270_1_2" list(0 190) "R270")
dbCreateParamInstByMasterName(cv "tphn28hpcpgv18" "PRCUTA_G" "layout" "filler_R270_2_1" list(0 230) "R270")
dbCreateParamInstByMasterName(cv "tphn28hpcpgv18" "PRCUTA_G" "layout" "filler_R270_2_2" list(0 250) "R270")
dbCreateParamInstByMasterName(cv "tphn28hpcpgv18" "PFILLER20A_G" "layout" "filler_R270_3_1" list(0 290) "R270")
dbCreateParamInstByMasterName(cv "tphn28hpcpgv18" "PFILLER20A_G" "layout" "filler_R270_3_2" list(0 310) "R270")
dbCreateParamInstByMasterName(cv "tphn28hpcpgv18" "PFILLER20A_G" "layout" "filler_R270_4_1" list(0 350) "R270")
dbCreateParamInstByMasterName(cv "tphn28hpcpgv18" "PFILLER20A_G" "layout" "filler_R270_4_2" list(0 370) "R270")
dbCreateParamInstByMasterName(cv "tphn28hpcpgv18" "PFILLER20A_G" "layout" "filler_R270_5_1" list(0 410) "R270")
dbCreateParamInstByMasterName(cv "tphn28hpcpgv18" "PFILLER20A_G" "layout" "filler_R270_5_2" list(0 430) "R270")
dbCreateParamInstByMasterName(cv "tphn28hpcpgv18" "PFILLER20A_G" "layout" "filler_R270_6_1" list(0 470) "R270")
dbCreateParamInstByMasterName(cv "tphn28hpcpgv18" "PFILLER20A_G" "layout" "filler_R270_6_2" list(0 490) "R270")
dbCreateParamInstByMasterName(cv "tphn28hpcpgv18" "PFILLER20A_G" "layout" "filler_R270_7_1" list(0 530) "R270")
dbCreateParamInstByMasterName(cv "tphn28hpcpgv18" "PFILLER20A_G" "layout" "filler_R270_7_2" list(0 550) "R270")
dbCreateParamInstByMasterName(cv "tphn28hpcpgv18" "PFILLER20A_G" "layout" "filler_R270_8_1" list(0 590) "R270")
dbCreateParamInstByMasterName(cv "tphn28hpcpgv18" "PFILLER20A_G" "layout" "filler_R270_8_2" list(0 610) "R270")
dbCreateParamInstByMasterName(cv "tphn28hpcpgv18" "PFILLER20A_G" "layout" "filler_R270_9_1" list(0 650) "R270")
dbCreateParamInstByMasterName(cv "tphn28hpcpgv18" "PFILLER20A_G" "layout" "filler_R270_9_2" list(0 670) "R270")

; ==================== Digital IO Features (with Inner Pad Support) ====================
dbCreatePath(cv list("M3" "drawing") list(list(130 110.5) list(450 110.5)) 0.2)
dbCreatePath(cv list("M3" "drawing") list(list(130 109.24) list(450 109.24)) 0.2)
dbCreatePath(cv list("M3" "drawing") list(list(469.5 130) list(469.5 690)) 0.2)
dbCreatePath(cv list("M3" "drawing") list(list(470.76 130) list(470.76 690)) 0.2)
dbCreatePath(cv list("M3" "drawing") list(list(130 709.5) list(450 709.5)) 0.2)
dbCreatePath(cv list("M3" "drawing") list(list(130 710.76) list(450 710.76)) 0.2)
dbCreatePath(cv list("M3" "drawing") list(list(110.5 130) list(110.5 210)) 0.2)
dbCreatePath(cv list("M3" "drawing") list(list(109.24 130) list(109.24 210)) 0.2)
dbCreatePath(cv list("M3" "drawing") list(list(130 709.5) list(110.5 709.5)) 0.2 "extendExtend")
dbCreatePath(cv list("M3" "drawing") list(list(110.5 709.5) list(110.5 210)) 0.2 "extendExtend")
dbCreatePath(cv list("M3" "drawing") list(list(130 710.76) list(109.24 710.76)) 0.2 "extendExtend")
dbCreatePath(cv list("M3" "drawing") list(list(109.24 710.76) list(109.24 210)) 0.2 "extendExtend")
dbCreatePath(cv list("M3" "drawing") list(list(450 709.5) list(469.5 709.5)) 0.2 "extendExtend")
dbCreatePath(cv list("M3" "drawing") list(list(469.5 709.5) list(469.5 690)) 0.2 "extendExtend")
dbCreatePath(cv list("M3" "drawing") list(list(450 710.76) list(470.76 710.76)) 0.2 "extendExtend")
dbCreatePath(cv list("M3" "drawing") list(list(470.76 710.76) list(470.76 690)) 0.2 "extendExtend")
dbCreatePath(cv list("M3" "drawing") list(list(130 110.5) list(110.5 110.5)) 0.2 "extendExtend")
dbCreatePath(cv list("M3" "drawing") list(list(110.5 110.5) list(110.5 130)) 0.2 "extendExtend")
dbCreatePath(cv list("M3" "drawing") list(list(130 109.24) list(109.24 109.24)) 0.2 "extendExtend")
dbCreatePath(cv list("M3" "drawing") list(list(109.24 109.24) list(109.24 130)) 0.2 "extendExtend")
dbCreatePath(cv list("M3" "drawing") list(list(450 110.5) list(469.5 110.5)) 0.2 "extendExtend")
dbCreatePath(cv list("M3" "drawing") list(list(469.5 110.5) list(469.5 130)) 0.2 "extendExtend")
dbCreatePath(cv list("M3" "drawing") list(list(450 109.24) list(470.76 109.24)) 0.2 "extendExtend")
dbCreatePath(cv list("M3" "drawing") list(list(470.76 109.24) list(470.76 130)) 0.2 "extendExtend")
dbCreatePath(cv list("M3" "drawing") list(list(327.655 709.88) list(327.655 709.5)) 0.2)
tech = techGetTechFile(cv)
viaParams = list(list("cutRows" 2) list("cutColumns" 4))
viaDefId = techFindViaDefByName(tech "M3_M2")
newVia = dbCreateVia(cv viaDefId list(327.655 709.88) "R180" viaParams)
dbCreatePath(cv list("M3" "drawing") list(list(267.61 709.88) list(267.61 710.76)) 0.2)
tech = techGetTechFile(cv)
viaParams = list(list("cutRows" 2) list("cutColumns" 4))
viaDefId = techFindViaDefByName(tech "M3_M2")
newVia = dbCreateVia(cv viaDefId list(267.61 709.88) "R180" viaParams)
dbCreatePath(cv list("M3" "drawing") list(list(109.875 199.8) list(110.5 199.8)) 0.26)
dbCreatePath(cv list("M3" "drawing") list(list(109.875 204.1) list(109.24 204.1)) 0.26)
dbCreateLabel(cv list("M4" "pin") list(109.875 208.275) "D0_CORE" "centerLeft" "R0" "roman" 2)
dbCreatePath(cv list("M3" "drawing") list(list(109.875 139.8) list(110.5 139.8)) 0.26)
dbCreatePath(cv list("M3" "drawing") list(list(109.875 144.1) list(109.24 144.1)) 0.26)
dbCreateLabel(cv list("M4" "pin") list(109.875 148.275) "D1_CORE" "centerLeft" "R0" "roman" 2)
dbCreatePath(cv list("M3" "drawing") list(list(140.2 109.875) list(140.2 110.5)) 0.26)
dbCreatePath(cv list("M3" "drawing") list(list(135.9 109.875) list(135.9 109.24)) 0.26)
dbCreateLabel(cv list("M4" "pin") list(131.725 109.875) "D2_CORE" "centerLeft" "R90" "roman" 2)
dbCreatePath(cv list("M3" "drawing") list(list(200.2 109.875) list(200.2 110.5)) 0.26)
dbCreatePath(cv list("M3" "drawing") list(list(195.9 109.875) list(195.9 109.24)) 0.26)
dbCreateLabel(cv list("M4" "pin") list(191.725 109.875) "D3_CORE" "centerLeft" "R90" "roman" 2)
dbCreatePath(cv list("M3" "drawing") list(list(260.2 109.875) list(260.2 110.5)) 0.26)
dbCreatePath(cv list("M3" "drawing") list(list(255.9 109.875) list(255.9 109.24)) 0.26)
dbCreateLabel(cv list("M4" "pin") list(251.725 109.875) "D4_CORE" "centerLeft" "R90" "roman" 2)
dbCreatePath(cv list("M3" "drawing") list(list(320.2 109.875) list(320.2 110.5)) 0.26)
dbCreatePath(cv list("M3" "drawing") list(list(315.9 109.875) list(315.9 109.24)) 0.26)
dbCreateLabel(cv list("M4" "pin") list(311.725 109.875) "D5_CORE" "centerLeft" "R90" "roman" 2)
dbCreatePath(cv list("M3" "drawing") list(list(380.2 109.875) list(380.2 110.5)) 0.26)
dbCreatePath(cv list("M3" "drawing") list(list(375.9 109.875) list(375.9 109.24)) 0.26)
dbCreateLabel(cv list("M4" "pin") list(371.725 109.875) "D6_CORE" "centerLeft" "R90" "roman" 2)
dbCreatePath(cv list("M3" "drawing") list(list(440.2 109.875) list(440.2 110.5)) 0.26)
dbCreatePath(cv list("M3" "drawing") list(list(435.9 109.875) list(435.9 109.24)) 0.26)
dbCreateLabel(cv list("M4" "pin") list(431.725 109.875) "D7_CORE" "centerLeft" "R90" "roman" 2)
dbCreatePath(cv list("M3" "drawing") list(list(469.5 140.2) list(470.125 140.2)) 0.26)
dbCreatePath(cv list("M3" "drawing") list(list(470.76 135.9) list(470.125 135.9)) 0.26)
dbCreateLabel(cv list("M4" "pin") list(470.125 131.725) "D8_CORE" "centerRight" "R0" "roman" 2)
dbCreatePath(cv list("M3" "drawing") list(list(469.5 200.2) list(470.125 200.2)) 0.26)
dbCreatePath(cv list("M3" "drawing") list(list(470.76 195.9) list(470.125 195.9)) 0.26)
dbCreateLabel(cv list("M4" "pin") list(470.125 191.725) "D9_CORE" "centerRight" "R0" "roman" 2)
dbCreatePath(cv list("M3" "drawing") list(list(469.5 260.2) list(470.125 260.2)) 0.26)
dbCreatePath(cv list("M3" "drawing") list(list(470.76 255.9) list(470.125 255.9)) 0.26)
dbCreateLabel(cv list("M4" "pin") list(470.125 251.725) "D10_CORE" "centerRight" "R0" "roman" 2)
dbCreatePath(cv list("M3" "drawing") list(list(469.5 320.2) list(470.125 320.2)) 0.26)
dbCreatePath(cv list("M3" "drawing") list(list(470.76 315.9) list(470.125 315.9)) 0.26)
dbCreateLabel(cv list("M4" "pin") list(470.125 311.725) "D11_CORE" "centerRight" "R0" "roman" 2)
dbCreatePath(cv list("M3" "drawing") list(list(469.5 380.2) list(470.125 380.2)) 0.26)
dbCreatePath(cv list("M3" "drawing") list(list(470.76 375.9) list(470.125 375.9)) 0.26)
dbCreateLabel(cv list("M4" "pin") list(470.125 371.725) "D12_CORE" "centerRight" "R0" "roman" 2)
dbCreatePath(cv list("M3" "drawing") list(list(469.5 440.2) list(470.125 440.2)) 0.26)
dbCreatePath(cv list("M3" "drawing") list(list(470.76 435.9) list(470.125 435.9)) 0.26)
dbCreateLabel(cv list("M4" "pin") list(470.125 431.725) "D13_CORE" "centerRight" "R0" "roman" 2)
dbCreatePath(cv list("M3" "drawing") list(list(469.5 500.2) list(470.125 500.2)) 0.26)
dbCreatePath(cv list("M3" "drawing") list(list(470.76 495.9) list(470.125 495.9)) 0.26)
dbCreateLabel(cv list("M4" "pin") list(470.125 491.725) "D14_CORE" "centerRight" "R0" "roman" 2)
dbCreatePath(cv list("M3" "drawing") list(list(469.5 560.2) list(470.125 560.2)) 0.26)
dbCreatePath(cv list("M3" "drawing") list(list(470.76 555.9) list(470.125 555.9)) 0.26)
dbCreateLabel(cv list("M4" "pin") list(470.125 551.725) "D15_CORE" "centerRight" "R0" "roman" 2)
dbCreatePath(cv list("M3" "drawing") list(list(469.5 620.2) list(470.125 620.2)) 0.26)
dbCreatePath(cv list("M3" "drawing") list(list(470.76 615.9) list(470.125 615.9)) 0.26)
dbCreateLabel(cv list("M4" "pin") list(470.125 611.725) "D16_CORE" "centerRight" "R0" "roman" 2)
dbCreatePath(cv list("M3" "drawing") list(list(469.5 680.2) list(470.125 680.2)) 0.26)
dbCreatePath(cv list("M3" "drawing") list(list(470.76 675.9) list(470.125 675.9)) 0.26)
dbCreateLabel(cv list("M4" "pin") list(470.125 671.725) "D17_CORE" "centerRight" "R0" "roman" 2)
dbCreatePath(cv list("M3" "drawing") list(list(439.8 710.125) list(439.8 710.76)) 0.26)
dbCreatePath(cv list("M3" "drawing") list(list(448.275 710.125) list(448.275 710.76)) 0.26)
dbCreatePath(cv list("M3" "drawing") list(list(444.1 710.125) list(444.1 709.5)) 0.26)
dbCreateLabel(cv list("M4" "pin") list(435.67 710.125) "SDI_CORE" "centerRight" "R90" "roman" 2)
dbCreatePath(cv list("M3" "drawing") list(list(379.8 710.125) list(379.8 709.5)) 0.26)
dbCreatePath(cv list("M3" "drawing") list(list(384.1 710.125) list(384.1 710.76)) 0.26)
dbCreateLabel(cv list("M4" "pin") list(388.275 710.125) "SDO_CORE" "centerRight" "R90" "roman" 2)

; ==================== Pin Labels (with Inner Pad Support) ====================
dbCreateLabel(cv list("AP" "pin") list(-11 680) "VINP" "centerRight" "R0" "roman" 10)
dbCreateLabel(cv list("AP" "pin") list(-11 620) "VINN" "centerRight" "R0" "roman" 10)
dbCreateLabel(cv list("AP" "pin") list(-11 560) "VIP" "centerRight" "R0" "roman" 10)
dbCreateLabel(cv list("AP" "pin") list(-11 500) "VIM" "centerRight" "R0" "roman" 10)
dbCreateLabel(cv list("AP" "pin") list(-11 440) "VCM" "centerRight" "R0" "roman" 10)
dbCreateLabel(cv list("AP" "pin") list(-11 380) "VREF" "centerRight" "R0" "roman" 10)
dbCreateLabel(cv list("AP" "pin") list(-11 320) "AVDD" "centerRight" "R0" "roman" 10)
dbCreateLabel(cv list("M2" "pin") list(109.9 320) "AVDD_CORE" "centerLeft" "R0" "roman" 2)
dbCreateLabel(cv list("AP" "pin") list(-11 260) "AVSS" "centerRight" "R0" "roman" 10)
dbCreateLabel(cv list("M2" "pin") list(109.9 260) "AVSS_CORE" "centerLeft" "R0" "roman" 2)
dbCreateLabel(cv list("AP" "pin") list(-11 200) "D0" "centerRight" "R0" "roman" 10)
dbCreateLabel(cv list("AP" "pin") list(-11 140) "D1" "centerRight" "R0" "roman" 10)
dbCreateLabel(cv list("AP" "pin") list(140 -11) "D2" "centerRight" "R90" "roman" 10)
dbCreateLabel(cv list("AP" "pin") list(200 -11) "D3" "centerRight" "R90" "roman" 10)
dbCreateLabel(cv list("AP" "pin") list(260 -11) "D4" "centerRight" "R90" "roman" 10)
dbCreateLabel(cv list("AP" "pin") list(320 -11) "D5" "centerRight" "R90" "roman" 10)
dbCreateLabel(cv list("AP" "pin") list(380 -11) "D6" "centerRight" "R90" "roman" 10)
dbCreateLabel(cv list("AP" "pin") list(440 -11) "D7" "centerRight" "R90" "roman" 10)
dbCreateLabel(cv list("AP" "pin") list(591 140) "D8" "centerLeft" "R0" "roman" 10)
dbCreateLabel(cv list("AP" "pin") list(591 200) "D9" "centerLeft" "R0" "roman" 10)
dbCreateLabel(cv list("AP" "pin") list(591 260) "D10" "centerLeft" "R0" "roman" 10)
dbCreateLabel(cv list("AP" "pin") list(591 320) "D11" "centerLeft" "R0" "roman" 10)
dbCreateLabel(cv list("AP" "pin") list(591 380) "D12" "centerLeft" "R0" "roman" 10)
dbCreateLabel(cv list("AP" "pin") list(591 440) "D13" "centerLeft" "R0" "roman" 10)
dbCreateLabel(cv list("AP" "pin") list(591 500) "D14" "centerLeft" "R0" "roman" 10)
dbCreateLabel(cv list("AP" "pin") list(591 560) "D15" "centerLeft" "R0" "roman" 10)
dbCreateLabel(cv list("AP" "pin") list(591 620) "D16" "centerLeft" "R0" "roman" 10)
dbCreateLabel(cv list("AP" "pin") list(591 680) "D17" "centerLeft" "R0" "roman" 10)
dbCreateLabel(cv list("AP" "pin") list(440 831) "SDI" "centerLeft" "R90" "roman" 10)
dbCreateLabel(cv list("AP" "pin") list(380 831) "SDO" "centerLeft" "R90" "roman" 10)
dbCreateLabel(cv list("AP" "pin") list(320 831) "VIOL" "centerLeft" "R90" "roman" 10)
dbCreateLabel(cv list("AP" "pin") list(260 831) "GIOL" "centerLeft" "R90" "roman" 10)
dbCreateLabel(cv list("AP" "pin") list(200 831) "VIOH" "centerLeft" "R90" "roman" 10)
dbCreateLabel(cv list("AP" "pin") list(140 831) "GIOH" "centerLeft" "R90" "roman" 10)

dbSave(cv)
t
