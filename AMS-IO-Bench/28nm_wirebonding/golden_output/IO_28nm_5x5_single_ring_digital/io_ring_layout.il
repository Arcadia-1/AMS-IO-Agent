; Generated Layout Script with Dual Ring Support

; ==================== All Components (Sorted by Placement Order) ====================
dbCreateParamInstByMasterName(cv "tphn28hpcpgv18" "PDDW16SDGZ_H_G" "layout" "D4_left_4" list(0 150) "R270")
dbCreateParamInstByMasterName(cv "PAD" "PAD60GU" "layout" "pad60gu_D4_left_4" list(0 150) "R270")
dbCreateParamInstByMasterName(cv "tphn28hpcpgv18" "PDDW16SDGZ_H_G" "layout" "D3_left_3" list(0 210) "R270")
dbCreateParamInstByMasterName(cv "PAD" "PAD60GU" "layout" "pad60gu_D3_left_3" list(0 210) "R270")
dbCreateParamInstByMasterName(cv "tphn28hpcpgv18" "PDDW16SDGZ_H_G" "layout" "D2_left_2" list(0 270) "R270")
dbCreateParamInstByMasterName(cv "PAD" "PAD60GU" "layout" "pad60gu_D2_left_2" list(0 270) "R270")
dbCreateParamInstByMasterName(cv "tphn28hpcpgv18" "PDDW16SDGZ_H_G" "layout" "D1_left_1" list(0 330) "R270")
dbCreateParamInstByMasterName(cv "PAD" "PAD60GU" "layout" "pad60gu_D1_left_1" list(0 330) "R270")
dbCreateParamInstByMasterName(cv "tphn28hpcpgv18" "PDDW16SDGZ_H_G" "layout" "D0_left_0" list(0 390) "R270")
dbCreateParamInstByMasterName(cv "PAD" "PAD60GU" "layout" "pad60gu_D0_left_0" list(0 390) "R270")
dbCreateParamInstByMasterName(cv "tphn28hpcpgv18" "PCORNER_G" "layout" "CORNER_TOPLEFT_top_left" list(0 520) "R270")
dbCreateParamInstByMasterName(cv "tphn28hpcpgv18" "PDDW16SDGZ_V_G" "layout" "D9_bottom_4" list(370 0) "R0")
dbCreateParamInstByMasterName(cv "PAD" "PAD60GU" "layout" "pad60gu_D9_bottom_4" list(370 0) "R0")
dbCreateParamInstByMasterName(cv "tphn28hpcpgv18" "PDDW16SDGZ_V_G" "layout" "D8_bottom_3" list(310 0) "R0")
dbCreateParamInstByMasterName(cv "PAD" "PAD60GU" "layout" "pad60gu_D8_bottom_3" list(310 0) "R0")
dbCreateParamInstByMasterName(cv "tphn28hpcpgv18" "PDDW16SDGZ_V_G" "layout" "D7_bottom_2" list(250 0) "R0")
dbCreateParamInstByMasterName(cv "PAD" "PAD60GU" "layout" "pad60gu_D7_bottom_2" list(250 0) "R0")
dbCreateParamInstByMasterName(cv "tphn28hpcpgv18" "PDDW16SDGZ_V_G" "layout" "D6_bottom_1" list(190 0) "R0")
dbCreateParamInstByMasterName(cv "PAD" "PAD60GU" "layout" "pad60gu_D6_bottom_1" list(190 0) "R0")
dbCreateParamInstByMasterName(cv "tphn28hpcpgv18" "PDDW16SDGZ_V_G" "layout" "D5_bottom_0" list(130 0) "R0")
dbCreateParamInstByMasterName(cv "PAD" "PAD60GU" "layout" "pad60gu_D5_bottom_0" list(130 0) "R0")
dbCreateParamInstByMasterName(cv "tphn28hpcpgv18" "PCORNER_G" "layout" "CORNER_BOTTOMLEFT_bottom_left" list(0 0) "R0")
dbCreateParamInstByMasterName(cv "tphn28hpcpgv18" "PDDW16SDGZ_H_G" "layout" "D14_right_4" list(520 370) "R90")
dbCreateParamInstByMasterName(cv "PAD" "PAD60GU" "layout" "pad60gu_D14_right_4" list(520 370) "R90")
dbCreateParamInstByMasterName(cv "tphn28hpcpgv18" "PDDW16SDGZ_H_G" "layout" "D13_right_3" list(520 310) "R90")
dbCreateParamInstByMasterName(cv "PAD" "PAD60GU" "layout" "pad60gu_D13_right_3" list(520 310) "R90")
dbCreateParamInstByMasterName(cv "tphn28hpcpgv18" "PDDW16SDGZ_H_G" "layout" "D12_right_2" list(520 250) "R90")
dbCreateParamInstByMasterName(cv "PAD" "PAD60GU" "layout" "pad60gu_D12_right_2" list(520 250) "R90")
dbCreateParamInstByMasterName(cv "tphn28hpcpgv18" "PDDW16SDGZ_H_G" "layout" "D11_right_1" list(520 190) "R90")
dbCreateParamInstByMasterName(cv "PAD" "PAD60GU" "layout" "pad60gu_D11_right_1" list(520 190) "R90")
dbCreateParamInstByMasterName(cv "tphn28hpcpgv18" "PDDW16SDGZ_H_G" "layout" "D10_right_0" list(520 130) "R90")
dbCreateParamInstByMasterName(cv "PAD" "PAD60GU" "layout" "pad60gu_D10_right_0" list(520 130) "R90")
dbCreateParamInstByMasterName(cv "tphn28hpcpgv18" "PCORNER_G" "layout" "CORNER_BOTTOMRIGHT_bottom_right" list(520 0) "R90")
dbCreateParamInstByMasterName(cv "tphn28hpcpgv18" "PVSS2DGZ_V_G" "layout" "GIOH_top_4" list(150 520) "R180")
dbCreateParamInstByMasterName(cv "PAD" "PAD60GU" "layout" "pad60gu_GIOH_top_4" list(150 520) "R180")
dbCreateParamInstByMasterName(cv "tphn28hpcpgv18" "PVDD2POC_V_G" "layout" "VIOH_top_3" list(210 520) "R180")
dbCreateParamInstByMasterName(cv "PAD" "PAD60GU" "layout" "pad60gu_VIOH_top_3" list(210 520) "R180")
dbCreateParamInstByMasterName(cv "tphn28hpcpgv18" "PVSS1DGZ_V_G" "layout" "GIOL_top_2" list(270 520) "R180")
dbCreateParamInstByMasterName(cv "PAD" "PAD60GU" "layout" "pad60gu_GIOL_top_2" list(270 520) "R180")
dbCreateParamInstByMasterName(cv "tphn28hpcpgv18" "PVDD1DGZ_V_G" "layout" "VIOL_top_1" list(330 520) "R180")
dbCreateParamInstByMasterName(cv "PAD" "PAD60GU" "layout" "pad60gu_VIOL_top_1" list(330 520) "R180")
dbCreateParamInstByMasterName(cv "tphn28hpcpgv18" "PDDW16SDGZ_V_G" "layout" "D15_top_0" list(390 520) "R180")
dbCreateParamInstByMasterName(cv "PAD" "PAD60GU" "layout" "pad60gu_D15_top_0" list(390 520) "R180")
dbCreateParamInstByMasterName(cv "tphn28hpcpgv18" "PCORNER_G" "layout" "CORNER_TOPRIGHT_top_right" list(520 520) "R180")

; ==================== Filler Components ====================
dbCreateParamInstByMasterName(cv "tphn28hpcpgv18" "PFILLER20_G" "layout" "sep_bottom_right_corner" list(390 0) "R0")
dbCreateParamInstByMasterName(cv "tphn28hpcpgv18" "PFILLER20_G" "layout" "filler_bottom_left_corner" list(110 0) "R0")
dbCreateParamInstByMasterName(cv "tphn28hpcpgv18" "PFILLER20_G" "layout" "filler_R0_1_1" list(350 0) "R0")
dbCreateParamInstByMasterName(cv "tphn28hpcpgv18" "PFILLER20_G" "layout" "filler_R0_1_2" list(330 0) "R0")
dbCreateParamInstByMasterName(cv "tphn28hpcpgv18" "PFILLER20_G" "layout" "filler_R0_2_1" list(290 0) "R0")
dbCreateParamInstByMasterName(cv "tphn28hpcpgv18" "PFILLER20_G" "layout" "filler_R0_2_2" list(270 0) "R0")
dbCreateParamInstByMasterName(cv "tphn28hpcpgv18" "PFILLER20_G" "layout" "filler_R0_3_1" list(230 0) "R0")
dbCreateParamInstByMasterName(cv "tphn28hpcpgv18" "PFILLER20_G" "layout" "filler_R0_3_2" list(210 0) "R0")
dbCreateParamInstByMasterName(cv "tphn28hpcpgv18" "PFILLER20_G" "layout" "filler_R0_4_1" list(170 0) "R0")
dbCreateParamInstByMasterName(cv "tphn28hpcpgv18" "PFILLER20_G" "layout" "filler_R0_4_2" list(150 0) "R0")
dbCreateParamInstByMasterName(cv "tphn28hpcpgv18" "PFILLER20_G" "layout" "filler_right_top_corner" list(520 390) "R90")
dbCreateParamInstByMasterName(cv "tphn28hpcpgv18" "PFILLER20_G" "layout" "filler_right_bottom_corner" list(520 110) "R90")
dbCreateParamInstByMasterName(cv "tphn28hpcpgv18" "PFILLER20_G" "layout" "filler_R90_1_1" list(520 350) "R90")
dbCreateParamInstByMasterName(cv "tphn28hpcpgv18" "PFILLER20_G" "layout" "filler_R90_1_2" list(520 330) "R90")
dbCreateParamInstByMasterName(cv "tphn28hpcpgv18" "PFILLER20_G" "layout" "filler_R90_2_1" list(520 290) "R90")
dbCreateParamInstByMasterName(cv "tphn28hpcpgv18" "PFILLER20_G" "layout" "filler_R90_2_2" list(520 270) "R90")
dbCreateParamInstByMasterName(cv "tphn28hpcpgv18" "PFILLER20_G" "layout" "filler_R90_3_1" list(520 230) "R90")
dbCreateParamInstByMasterName(cv "tphn28hpcpgv18" "PFILLER20_G" "layout" "filler_R90_3_2" list(520 210) "R90")
dbCreateParamInstByMasterName(cv "tphn28hpcpgv18" "PFILLER20_G" "layout" "filler_R90_4_1" list(520 170) "R90")
dbCreateParamInstByMasterName(cv "tphn28hpcpgv18" "PFILLER20_G" "layout" "filler_R90_4_2" list(520 150) "R90")
dbCreateParamInstByMasterName(cv "tphn28hpcpgv18" "PFILLER20_G" "layout" "sep_top_left_corner" list(130 520) "R180")
dbCreateParamInstByMasterName(cv "tphn28hpcpgv18" "PFILLER20_G" "layout" "filler_top_right_corner" list(410 520) "R180")
dbCreateParamInstByMasterName(cv "tphn28hpcpgv18" "PFILLER20_G" "layout" "filler_R180_1_1" list(170 520) "R180")
dbCreateParamInstByMasterName(cv "tphn28hpcpgv18" "PFILLER20_G" "layout" "filler_R180_1_2" list(190 520) "R180")
dbCreateParamInstByMasterName(cv "tphn28hpcpgv18" "PFILLER20_G" "layout" "filler_R180_2_1" list(230 520) "R180")
dbCreateParamInstByMasterName(cv "tphn28hpcpgv18" "PFILLER20_G" "layout" "filler_R180_2_2" list(250 520) "R180")
dbCreateParamInstByMasterName(cv "tphn28hpcpgv18" "PFILLER20_G" "layout" "filler_R180_3_1" list(290 520) "R180")
dbCreateParamInstByMasterName(cv "tphn28hpcpgv18" "PFILLER20_G" "layout" "filler_R180_3_2" list(310 520) "R180")
dbCreateParamInstByMasterName(cv "tphn28hpcpgv18" "PFILLER20_G" "layout" "filler_R180_4_1" list(350 520) "R180")
dbCreateParamInstByMasterName(cv "tphn28hpcpgv18" "PFILLER20_G" "layout" "filler_R180_4_2" list(370 520) "R180")
dbCreateParamInstByMasterName(cv "tphn28hpcpgv18" "PFILLER20_G" "layout" "filler_left_bottom_corner" list(0 130) "R270")
dbCreateParamInstByMasterName(cv "tphn28hpcpgv18" "PFILLER20_G" "layout" "sep_left_top_corner" list(0 410) "R270")
dbCreateParamInstByMasterName(cv "tphn28hpcpgv18" "PFILLER20_G" "layout" "filler_R270_1_1" list(0 170) "R270")
dbCreateParamInstByMasterName(cv "tphn28hpcpgv18" "PFILLER20_G" "layout" "filler_R270_1_2" list(0 190) "R270")
dbCreateParamInstByMasterName(cv "tphn28hpcpgv18" "PFILLER20_G" "layout" "filler_R270_2_1" list(0 230) "R270")
dbCreateParamInstByMasterName(cv "tphn28hpcpgv18" "PFILLER20_G" "layout" "filler_R270_2_2" list(0 250) "R270")
dbCreateParamInstByMasterName(cv "tphn28hpcpgv18" "PFILLER20_G" "layout" "filler_R270_3_1" list(0 290) "R270")
dbCreateParamInstByMasterName(cv "tphn28hpcpgv18" "PFILLER20_G" "layout" "filler_R270_3_2" list(0 310) "R270")
dbCreateParamInstByMasterName(cv "tphn28hpcpgv18" "PFILLER20_G" "layout" "filler_R270_4_1" list(0 350) "R270")
dbCreateParamInstByMasterName(cv "tphn28hpcpgv18" "PFILLER20_G" "layout" "filler_R270_4_2" list(0 370) "R270")

; ==================== Digital IO Features (with Inner Pad Support) ====================
dbCreatePath(cv list("M3" "drawing") list(list(130 110.5) list(390 110.5)) 0.2)
dbCreatePath(cv list("M3" "drawing") list(list(130 109.24) list(390 109.24)) 0.2)
dbCreatePath(cv list("M3" "drawing") list(list(409.5 130) list(409.5 390)) 0.2)
dbCreatePath(cv list("M3" "drawing") list(list(410.76 130) list(410.76 390)) 0.2)
dbCreatePath(cv list("M3" "drawing") list(list(130 409.5) list(390 409.5)) 0.2)
dbCreatePath(cv list("M3" "drawing") list(list(130 410.76) list(390 410.76)) 0.2)
dbCreatePath(cv list("M3" "drawing") list(list(110.5 130) list(110.5 390)) 0.2)
dbCreatePath(cv list("M3" "drawing") list(list(109.24 130) list(109.24 390)) 0.2)
dbCreatePath(cv list("M3" "drawing") list(list(130 409.5) list(110.5 409.5)) 0.2 "extendExtend")
dbCreatePath(cv list("M3" "drawing") list(list(110.5 409.5) list(110.5 390)) 0.2 "extendExtend")
dbCreatePath(cv list("M3" "drawing") list(list(130 410.76) list(109.24 410.76)) 0.2 "extendExtend")
dbCreatePath(cv list("M3" "drawing") list(list(109.24 410.76) list(109.24 390)) 0.2 "extendExtend")
dbCreatePath(cv list("M3" "drawing") list(list(390 409.5) list(409.5 409.5)) 0.2 "extendExtend")
dbCreatePath(cv list("M3" "drawing") list(list(409.5 409.5) list(409.5 390)) 0.2 "extendExtend")
dbCreatePath(cv list("M3" "drawing") list(list(390 410.76) list(410.76 410.76)) 0.2 "extendExtend")
dbCreatePath(cv list("M3" "drawing") list(list(410.76 410.76) list(410.76 390)) 0.2 "extendExtend")
dbCreatePath(cv list("M3" "drawing") list(list(130 110.5) list(110.5 110.5)) 0.2 "extendExtend")
dbCreatePath(cv list("M3" "drawing") list(list(110.5 110.5) list(110.5 130)) 0.2 "extendExtend")
dbCreatePath(cv list("M3" "drawing") list(list(130 109.24) list(109.24 109.24)) 0.2 "extendExtend")
dbCreatePath(cv list("M3" "drawing") list(list(109.24 109.24) list(109.24 130)) 0.2 "extendExtend")
dbCreatePath(cv list("M3" "drawing") list(list(390 110.5) list(409.5 110.5)) 0.2 "extendExtend")
dbCreatePath(cv list("M3" "drawing") list(list(409.5 110.5) list(409.5 130)) 0.2 "extendExtend")
dbCreatePath(cv list("M3" "drawing") list(list(390 109.24) list(410.76 109.24)) 0.2 "extendExtend")
dbCreatePath(cv list("M3" "drawing") list(list(410.76 109.24) list(410.76 130)) 0.2 "extendExtend")
dbCreatePath(cv list("M3" "drawing") list(list(327.655 409.88) list(327.655 409.5)) 0.2)
tech = techGetTechFile(cv)
viaParams = list(list("cutRows" 2) list("cutColumns" 4))
viaDefId = techFindViaDefByName(tech "M3_M2")
newVia = dbCreateVia(cv viaDefId list(327.655 409.88) "R180" viaParams)
dbCreatePath(cv list("M3" "drawing") list(list(267.61 409.88) list(267.61 410.76)) 0.2)
tech = techGetTechFile(cv)
viaParams = list(list("cutRows" 2) list("cutColumns" 4))
viaDefId = techFindViaDefByName(tech "M3_M2")
newVia = dbCreateVia(cv viaDefId list(267.61 409.88) "R180" viaParams)
dbCreatePath(cv list("M3" "drawing") list(list(109.875 379.8) list(110.5 379.8)) 0.26)
dbCreatePath(cv list("M3" "drawing") list(list(109.875 384.1) list(109.24 384.1)) 0.26)
dbCreateLabel(cv list("M4" "pin") list(109.875 388.275) "D0_CORE" "centerLeft" "R0" "roman" 2)
dbCreatePath(cv list("M3" "drawing") list(list(109.875 319.8) list(110.5 319.8)) 0.26)
dbCreatePath(cv list("M3" "drawing") list(list(109.875 324.1) list(109.24 324.1)) 0.26)
dbCreateLabel(cv list("M4" "pin") list(109.875 328.275) "D1_CORE" "centerLeft" "R0" "roman" 2)
dbCreatePath(cv list("M3" "drawing") list(list(109.875 259.8) list(110.5 259.8)) 0.26)
dbCreatePath(cv list("M3" "drawing") list(list(109.875 264.1) list(109.24 264.1)) 0.26)
dbCreateLabel(cv list("M4" "pin") list(109.875 268.275) "D2_CORE" "centerLeft" "R0" "roman" 2)
dbCreatePath(cv list("M3" "drawing") list(list(109.875 199.8) list(110.5 199.8)) 0.26)
dbCreatePath(cv list("M3" "drawing") list(list(109.875 204.1) list(109.24 204.1)) 0.26)
dbCreateLabel(cv list("M4" "pin") list(109.875 208.275) "D3_CORE" "centerLeft" "R0" "roman" 2)
dbCreatePath(cv list("M3" "drawing") list(list(109.875 139.8) list(110.5 139.8)) 0.26)
dbCreatePath(cv list("M3" "drawing") list(list(109.875 144.1) list(109.24 144.1)) 0.26)
dbCreateLabel(cv list("M4" "pin") list(109.875 148.275) "D4_CORE" "centerLeft" "R0" "roman" 2)
dbCreatePath(cv list("M3" "drawing") list(list(140.2 109.875) list(140.2 110.5)) 0.26)
dbCreatePath(cv list("M3" "drawing") list(list(135.9 109.875) list(135.9 109.24)) 0.26)
dbCreateLabel(cv list("M4" "pin") list(131.725 109.875) "D5_CORE" "centerLeft" "R90" "roman" 2)
dbCreatePath(cv list("M3" "drawing") list(list(200.2 109.875) list(200.2 110.5)) 0.26)
dbCreatePath(cv list("M3" "drawing") list(list(195.9 109.875) list(195.9 109.24)) 0.26)
dbCreateLabel(cv list("M4" "pin") list(191.725 109.875) "D6_CORE" "centerLeft" "R90" "roman" 2)
dbCreatePath(cv list("M3" "drawing") list(list(260.2 109.875) list(260.2 110.5)) 0.26)
dbCreatePath(cv list("M3" "drawing") list(list(255.9 109.875) list(255.9 109.24)) 0.26)
dbCreateLabel(cv list("M4" "pin") list(251.725 109.875) "D7_CORE" "centerLeft" "R90" "roman" 2)
dbCreatePath(cv list("M3" "drawing") list(list(320.2 109.875) list(320.2 110.5)) 0.26)
dbCreatePath(cv list("M3" "drawing") list(list(315.9 109.875) list(315.9 109.24)) 0.26)
dbCreateLabel(cv list("M4" "pin") list(311.725 109.875) "D8_CORE" "centerLeft" "R90" "roman" 2)
dbCreatePath(cv list("M3" "drawing") list(list(380.2 109.875) list(380.2 110.5)) 0.26)
dbCreatePath(cv list("M3" "drawing") list(list(375.9 109.875) list(375.9 109.24)) 0.26)
dbCreateLabel(cv list("M4" "pin") list(371.725 109.875) "D9_CORE" "centerLeft" "R90" "roman" 2)
dbCreatePath(cv list("M3" "drawing") list(list(409.5 140.2) list(410.125 140.2)) 0.26)
dbCreatePath(cv list("M3" "drawing") list(list(410.76 135.9) list(410.125 135.9)) 0.26)
dbCreateLabel(cv list("M4" "pin") list(410.125 131.725) "D10_CORE" "centerRight" "R0" "roman" 2)
dbCreatePath(cv list("M3" "drawing") list(list(409.5 200.2) list(410.125 200.2)) 0.26)
dbCreatePath(cv list("M3" "drawing") list(list(410.76 195.9) list(410.125 195.9)) 0.26)
dbCreateLabel(cv list("M4" "pin") list(410.125 191.725) "D11_CORE" "centerRight" "R0" "roman" 2)
dbCreatePath(cv list("M3" "drawing") list(list(409.5 260.2) list(410.125 260.2)) 0.26)
dbCreatePath(cv list("M3" "drawing") list(list(410.76 255.9) list(410.125 255.9)) 0.26)
dbCreateLabel(cv list("M4" "pin") list(410.125 251.725) "D12_CORE" "centerRight" "R0" "roman" 2)
dbCreatePath(cv list("M3" "drawing") list(list(409.5 320.2) list(410.125 320.2)) 0.26)
dbCreatePath(cv list("M3" "drawing") list(list(410.76 315.9) list(410.125 315.9)) 0.26)
dbCreateLabel(cv list("M4" "pin") list(410.125 311.725) "D13_CORE" "centerRight" "R0" "roman" 2)
dbCreatePath(cv list("M3" "drawing") list(list(409.5 380.2) list(410.125 380.2)) 0.26)
dbCreatePath(cv list("M3" "drawing") list(list(410.76 375.9) list(410.125 375.9)) 0.26)
dbCreateLabel(cv list("M4" "pin") list(410.125 371.725) "D14_CORE" "centerRight" "R0" "roman" 2)
dbCreatePath(cv list("M3" "drawing") list(list(379.8 410.125) list(379.8 409.5)) 0.26)
dbCreatePath(cv list("M3" "drawing") list(list(384.1 410.125) list(384.1 410.76)) 0.26)
dbCreateLabel(cv list("M4" "pin") list(388.275 410.125) "D15_CORE" "centerRight" "R90" "roman" 2)

; ==================== Pin Labels (with Inner Pad Support) ====================
dbCreateLabel(cv list("AP" "pin") list(-11 380) "D0" "centerRight" "R0" "roman" 10)
dbCreateLabel(cv list("AP" "pin") list(-11 320) "D1" "centerRight" "R0" "roman" 10)
dbCreateLabel(cv list("AP" "pin") list(-11 260) "D2" "centerRight" "R0" "roman" 10)
dbCreateLabel(cv list("AP" "pin") list(-11 200) "D3" "centerRight" "R0" "roman" 10)
dbCreateLabel(cv list("AP" "pin") list(-11 140) "D4" "centerRight" "R0" "roman" 10)
dbCreateLabel(cv list("AP" "pin") list(140 -11) "D5" "centerRight" "R90" "roman" 10)
dbCreateLabel(cv list("AP" "pin") list(200 -11) "D6" "centerRight" "R90" "roman" 10)
dbCreateLabel(cv list("AP" "pin") list(260 -11) "D7" "centerRight" "R90" "roman" 10)
dbCreateLabel(cv list("AP" "pin") list(320 -11) "D8" "centerRight" "R90" "roman" 10)
dbCreateLabel(cv list("AP" "pin") list(380 -11) "D9" "centerRight" "R90" "roman" 10)
dbCreateLabel(cv list("AP" "pin") list(531 140) "D10" "centerLeft" "R0" "roman" 10)
dbCreateLabel(cv list("AP" "pin") list(531 200) "D11" "centerLeft" "R0" "roman" 10)
dbCreateLabel(cv list("AP" "pin") list(531 260) "D12" "centerLeft" "R0" "roman" 10)
dbCreateLabel(cv list("AP" "pin") list(531 320) "D13" "centerLeft" "R0" "roman" 10)
dbCreateLabel(cv list("AP" "pin") list(531 380) "D14" "centerLeft" "R0" "roman" 10)
dbCreateLabel(cv list("AP" "pin") list(380 531) "D15" "centerLeft" "R90" "roman" 10)
dbCreateLabel(cv list("AP" "pin") list(320 531) "VIOL" "centerLeft" "R90" "roman" 10)
dbCreateLabel(cv list("AP" "pin") list(260 531) "GIOL" "centerLeft" "R90" "roman" 10)
dbCreateLabel(cv list("AP" "pin") list(200 531) "VIOH" "centerLeft" "R90" "roman" 10)
dbCreateLabel(cv list("AP" "pin") list(140 531) "GIOH" "centerLeft" "R90" "roman" 10)

dbSave(cv)
t
