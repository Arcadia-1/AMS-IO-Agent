pddw16sdgz_h_gMaster = dbOpenCellView("tphn28hpcpgv18" "PDDW16SDGZ_H_G" "symbol")
dbCreateInst(cv pddw16sdgz_h_gMaster "RSTN_left0" '(0 9.6875) "R270")
schCreateWire(cv "route" "full" '((1.000 9.562) (1.750 9.562)) 0 0 0 nil nil)
schCreateWireLabel(cv nil '(1.250 9.562) "VSS" "lowerLeft" "R0" "stick" 0.0625 nil)
schCreateWire(cv "route" "full" '((1.000 9.438) (1.750 9.438)) 0 0 0 nil nil)
schCreateWireLabel(cv nil '(1.250 9.438) "RSTN_CORE" "lowerLeft" "R0" "stick" 0.0625 nil)
schCreatePin(cv nil "RSTN_CORE" "inputOutput" nil '(1.750 9.438) "R180")
schCreateWire(cv "route" "full" '((1.000 9.812) (1.750 9.812)) 0 0 0 nil nil)
schCreateWireLabel(cv nil '(1.250 9.812) "IOVDDL" "lowerLeft" "R0" "stick" 0.0625 nil)
schCreateWire(cv "route" "full" '((1.000 9.938) (1.750 9.938)) 0 0 0 nil nil)
schCreateWireLabel(cv nil '(1.250 9.938) "VSS" "lowerLeft" "R0" "stick" 0.0625 nil)
schCreateWire(cv "route" "full" '((0.000 8.999) (-0.750 8.999)) 0 0 0 nil nil)
schCreateWireLabel(cv nil '(-0.250 8.999) "RSTN" "lowerRight" "R0" "stick" 0.0625 nil)
schCreatePin(cv nil "RSTN" "inputOutput" nil '(-0.750 8.999) "R0")
schCreateWire(cv "route" "full" '((1.000 9.312) (1.750 9.312)) 0 0 0 nil nil)
schCreateWireLabel(cv nil '(1.250 9.312) "POC" "lowerLeft" "R0" "stick" 0.0625 nil)
schCreateWire(cv "route" "full" '((1.000 9.126) (1.750 9.126)) 0 0 0 nil nil)
schCreateWireLabel(cv nil '(1.250 9.126) "IOVDDL" "lowerLeft" "R0" "stick" 0.0625 nil)
schCreateWire(cv "route" "full" '((1.000 8.938) (1.750 8.938)) 0 0 0 nil nil)
schCreateWireLabel(cv nil '(1.250 8.938) "VSS" "lowerLeft" "R0" "stick" 0.0625 nil)
schCreateWire(cv "route" "full" '((1.000 8.749) (1.750 8.749)) 0 0 0 nil nil)
schCreateWireLabel(cv nil '(1.250 8.749) "IOVDDH" "lowerLeft" "R0" "stick" 0.0625 nil)
schCreateWire(cv "route" "full" '((1.000 8.376) (1.750 8.376)) 0 0 0 nil nil)
schCreateWireLabel(cv nil '(1.250 8.376) "IOVSS" "lowerLeft" "R0" "stick" 0.0625 nil)
dbCreateInst(cv pddw16sdgz_h_gMaster "SCK_left1" '(0 7.6875) "R270")
schCreateWire(cv "route" "full" '((1.000 7.562) (1.750 7.562)) 0 0 0 nil nil)
schCreateWireLabel(cv nil '(1.250 7.562) "VSS" "lowerLeft" "R0" "stick" 0.0625 nil)
schCreateWire(cv "route" "full" '((1.000 7.438) (1.750 7.438)) 0 0 0 nil nil)
schCreateWireLabel(cv nil '(1.250 7.438) "SCK_CORE" "lowerLeft" "R0" "stick" 0.0625 nil)
schCreatePin(cv nil "SCK_CORE" "inputOutput" nil '(1.750 7.438) "R180")
schCreateWire(cv "route" "full" '((1.000 7.812) (1.750 7.812)) 0 0 0 nil nil)
schCreateWireLabel(cv nil '(1.250 7.812) "IOVDDL" "lowerLeft" "R0" "stick" 0.0625 nil)
schCreateWire(cv "route" "full" '((1.000 7.938) (1.750 7.938)) 0 0 0 nil nil)
schCreateWireLabel(cv nil '(1.250 7.938) "VSS" "lowerLeft" "R0" "stick" 0.0625 nil)
schCreateWire(cv "route" "full" '((0.000 7.000) (-0.750 7.000)) 0 0 0 nil nil)
schCreateWireLabel(cv nil '(-0.250 7.000) "SCK" "lowerRight" "R0" "stick" 0.0625 nil)
schCreatePin(cv nil "SCK" "inputOutput" nil '(-0.750 7.000) "R0")
schCreateWire(cv "route" "full" '((1.000 7.312) (1.750 7.312)) 0 0 0 nil nil)
schCreateWireLabel(cv nil '(1.250 7.312) "POC" "lowerLeft" "R0" "stick" 0.0625 nil)
schCreateWire(cv "route" "full" '((1.000 7.125) (1.750 7.125)) 0 0 0 nil nil)
schCreateWireLabel(cv nil '(1.250 7.125) "IOVDDL" "lowerLeft" "R0" "stick" 0.0625 nil)
schCreateWire(cv "route" "full" '((1.000 6.938) (1.750 6.938)) 0 0 0 nil nil)
schCreateWireLabel(cv nil '(1.250 6.938) "VSS" "lowerLeft" "R0" "stick" 0.0625 nil)
schCreateWire(cv "route" "full" '((1.000 6.750) (1.750 6.750)) 0 0 0 nil nil)
schCreateWireLabel(cv nil '(1.250 6.750) "IOVDDH" "lowerLeft" "R0" "stick" 0.0625 nil)
schCreateWire(cv "route" "full" '((1.000 6.375) (1.750 6.375)) 0 0 0 nil nil)
schCreateWireLabel(cv nil '(1.250 6.375) "IOVSS" "lowerLeft" "R0" "stick" 0.0625 nil)
dbCreateInst(cv pddw16sdgz_h_gMaster "SDI_left2" '(0 5.6875) "R270")
schCreateWire(cv "route" "full" '((1.000 5.562) (1.750 5.562)) 0 0 0 nil nil)
schCreateWireLabel(cv nil '(1.250 5.562) "VSS" "lowerLeft" "R0" "stick" 0.0625 nil)
schCreateWire(cv "route" "full" '((1.000 5.438) (1.750 5.438)) 0 0 0 nil nil)
schCreateWireLabel(cv nil '(1.250 5.438) "SDI_CORE" "lowerLeft" "R0" "stick" 0.0625 nil)
schCreatePin(cv nil "SDI_CORE" "inputOutput" nil '(1.750 5.438) "R180")
schCreateWire(cv "route" "full" '((1.000 5.812) (1.750 5.812)) 0 0 0 nil nil)
schCreateWireLabel(cv nil '(1.250 5.812) "IOVDDL" "lowerLeft" "R0" "stick" 0.0625 nil)
schCreateWire(cv "route" "full" '((1.000 5.938) (1.750 5.938)) 0 0 0 nil nil)
schCreateWireLabel(cv nil '(1.250 5.938) "VSS" "lowerLeft" "R0" "stick" 0.0625 nil)
schCreateWire(cv "route" "full" '((0.000 5.000) (-0.750 5.000)) 0 0 0 nil nil)
schCreateWireLabel(cv nil '(-0.250 5.000) "SDI" "lowerRight" "R0" "stick" 0.0625 nil)
schCreatePin(cv nil "SDI" "inputOutput" nil '(-0.750 5.000) "R0")
schCreateWire(cv "route" "full" '((1.000 5.312) (1.750 5.312)) 0 0 0 nil nil)
schCreateWireLabel(cv nil '(1.250 5.312) "POC" "lowerLeft" "R0" "stick" 0.0625 nil)
schCreateWire(cv "route" "full" '((1.000 5.125) (1.750 5.125)) 0 0 0 nil nil)
schCreateWireLabel(cv nil '(1.250 5.125) "IOVDDL" "lowerLeft" "R0" "stick" 0.0625 nil)
schCreateWire(cv "route" "full" '((1.000 4.938) (1.750 4.938)) 0 0 0 nil nil)
schCreateWireLabel(cv nil '(1.250 4.938) "VSS" "lowerLeft" "R0" "stick" 0.0625 nil)
schCreateWire(cv "route" "full" '((1.000 4.750) (1.750 4.750)) 0 0 0 nil nil)
schCreateWireLabel(cv nil '(1.250 4.750) "IOVDDH" "lowerLeft" "R0" "stick" 0.0625 nil)
schCreateWire(cv "route" "full" '((1.000 4.375) (1.750 4.375)) 0 0 0 nil nil)
schCreateWireLabel(cv nil '(1.250 4.375) "IOVSS" "lowerLeft" "R0" "stick" 0.0625 nil)
dbCreateInst(cv pddw16sdgz_h_gMaster "SDO_left3" '(0 3.6875) "R270")
schCreateWire(cv "route" "full" '((1.000 3.562) (1.750 3.562)) 0 0 0 nil nil)
schCreateWireLabel(cv nil '(1.250 3.562) "IOVDDL" "lowerLeft" "R0" "stick" 0.0625 nil)
noConnMaster = dbOpenCellView("basic" "noConn" "symbol")
schCreateWire(cv "route" "full" '((1.000 3.438) (1.750 3.438)) 0 0 0 nil nil)
dbCreateInst(cv noConnMaster "noConn_SDO_left3_C" '(1.750 3.438) "R90")
schCreateWire(cv "route" "full" '((1.000 3.812) (1.750 3.812)) 0 0 0 nil nil)
schCreateWireLabel(cv nil '(1.250 3.812) "VSS" "lowerLeft" "R0" "stick" 0.0625 nil)
schCreateWire(cv "route" "full" '((1.000 3.938) (1.750 3.938)) 0 0 0 nil nil)
schCreateWireLabel(cv nil '(1.250 3.938) "SDO_CORE" "lowerLeft" "R0" "stick" 0.0625 nil)
schCreatePin(cv nil "SDO_CORE" "inputOutput" nil '(1.750 3.938) "R180")
schCreateWire(cv "route" "full" '((0.000 3.000) (-0.750 3.000)) 0 0 0 nil nil)
schCreateWireLabel(cv nil '(-0.250 3.000) "SDO" "lowerRight" "R0" "stick" 0.0625 nil)
schCreatePin(cv nil "SDO" "inputOutput" nil '(-0.750 3.000) "R0")
schCreateWire(cv "route" "full" '((1.000 3.312) (1.750 3.312)) 0 0 0 nil nil)
schCreateWireLabel(cv nil '(1.250 3.312) "POC" "lowerLeft" "R0" "stick" 0.0625 nil)
schCreateWire(cv "route" "full" '((1.000 3.125) (1.750 3.125)) 0 0 0 nil nil)
schCreateWireLabel(cv nil '(1.250 3.125) "IOVDDL" "lowerLeft" "R0" "stick" 0.0625 nil)
schCreateWire(cv "route" "full" '((1.000 2.938) (1.750 2.938)) 0 0 0 nil nil)
schCreateWireLabel(cv nil '(1.250 2.938) "VSS" "lowerLeft" "R0" "stick" 0.0625 nil)
schCreateWire(cv "route" "full" '((1.000 2.750) (1.750 2.750)) 0 0 0 nil nil)
schCreateWireLabel(cv nil '(1.250 2.750) "IOVDDH" "lowerLeft" "R0" "stick" 0.0625 nil)
schCreateWire(cv "route" "full" '((1.000 2.375) (1.750 2.375)) 0 0 0 nil nil)
schCreateWireLabel(cv nil '(1.250 2.375) "IOVSS" "lowerLeft" "R0" "stick" 0.0625 nil)
pddw16sdgz_v_gMaster = dbOpenCellView("tphn28hpcpgv18" "PDDW16SDGZ_V_G" "symbol")
dbCreateInst(cv pddw16sdgz_v_gMaster "D8_bottom0" '(2.3125 0) "R0")
schCreateWire(cv "route" "full" '((2.438 1.000) (2.438 1.750)) 0 0 0 nil nil)
schCreateWireLabel(cv nil '(2.438 1.250) "IOVDDL" "lowerLeft" "R90" "stick" 0.0625 nil)
schCreateWire(cv "route" "full" '((2.562 1.000) (2.562 1.750)) 0 0 0 nil nil)
dbCreateInst(cv noConnMaster "noConn_D8_bottom0_C" '(2.562 1.750) "R180")
schCreateWire(cv "route" "full" '((2.188 1.000) (2.188 1.750)) 0 0 0 nil nil)
schCreateWireLabel(cv nil '(2.188 1.250) "VSS" "lowerLeft" "R90" "stick" 0.0625 nil)
schCreateWire(cv "route" "full" '((2.062 1.000) (2.062 1.750)) 0 0 0 nil nil)
schCreateWireLabel(cv nil '(2.062 1.250) "D8_CORE" "lowerLeft" "R90" "stick" 0.0625 nil)
schCreatePin(cv nil "D8_CORE" "inputOutput" nil '(2.062 1.750) "R270")
schCreateWire(cv "route" "full" '((3.000 0.000) (3.000 -0.750)) 0 0 0 nil nil)
schCreateWireLabel(cv nil '(3.000 -0.250) "D8" "lowerRight" "R90" "stick" 0.0625 nil)
schCreatePin(cv nil "D8" "inputOutput" nil '(3.000 -0.750) "R90")
schCreateWire(cv "route" "full" '((2.688 1.000) (2.688 1.750)) 0 0 0 nil nil)
schCreateWireLabel(cv nil '(2.688 1.250) "POC" "lowerLeft" "R90" "stick" 0.0625 nil)
schCreateWire(cv "route" "full" '((2.875 1.000) (2.875 1.750)) 0 0 0 nil nil)
schCreateWireLabel(cv nil '(2.875 1.250) "IOVDDL" "lowerLeft" "R90" "stick" 0.0625 nil)
schCreateWire(cv "route" "full" '((3.062 1.000) (3.062 1.750)) 0 0 0 nil nil)
schCreateWireLabel(cv nil '(3.062 1.250) "VSS" "lowerLeft" "R90" "stick" 0.0625 nil)
schCreateWire(cv "route" "full" '((3.250 1.000) (3.250 1.750)) 0 0 0 nil nil)
schCreateWireLabel(cv nil '(3.250 1.250) "IOVDDH" "lowerLeft" "R90" "stick" 0.0625 nil)
schCreateWire(cv "route" "full" '((3.625 1.000) (3.625 1.750)) 0 0 0 nil nil)
schCreateWireLabel(cv nil '(3.625 1.250) "IOVSS" "lowerLeft" "R90" "stick" 0.0625 nil)
dbCreateInst(cv pddw16sdgz_v_gMaster "D7_bottom1" '(4.3125 0) "R0")
schCreateWire(cv "route" "full" '((4.438 1.000) (4.438 1.750)) 0 0 0 nil nil)
schCreateWireLabel(cv nil '(4.438 1.250) "IOVDDL" "lowerLeft" "R90" "stick" 0.0625 nil)
schCreateWire(cv "route" "full" '((4.562 1.000) (4.562 1.750)) 0 0 0 nil nil)
dbCreateInst(cv noConnMaster "noConn_D7_bottom1_C" '(4.562 1.750) "R180")
schCreateWire(cv "route" "full" '((4.188 1.000) (4.188 1.750)) 0 0 0 nil nil)
schCreateWireLabel(cv nil '(4.188 1.250) "VSS" "lowerLeft" "R90" "stick" 0.0625 nil)
schCreateWire(cv "route" "full" '((4.062 1.000) (4.062 1.750)) 0 0 0 nil nil)
schCreateWireLabel(cv nil '(4.062 1.250) "D7_CORE" "lowerLeft" "R90" "stick" 0.0625 nil)
schCreatePin(cv nil "D7_CORE" "inputOutput" nil '(4.062 1.750) "R270")
schCreateWire(cv "route" "full" '((5.000 0.000) (5.000 -0.750)) 0 0 0 nil nil)
schCreateWireLabel(cv nil '(5.000 -0.250) "D7" "lowerRight" "R90" "stick" 0.0625 nil)
schCreatePin(cv nil "D7" "inputOutput" nil '(5.000 -0.750) "R90")
schCreateWire(cv "route" "full" '((4.688 1.000) (4.688 1.750)) 0 0 0 nil nil)
schCreateWireLabel(cv nil '(4.688 1.250) "POC" "lowerLeft" "R90" "stick" 0.0625 nil)
schCreateWire(cv "route" "full" '((4.875 1.000) (4.875 1.750)) 0 0 0 nil nil)
schCreateWireLabel(cv nil '(4.875 1.250) "IOVDDL" "lowerLeft" "R90" "stick" 0.0625 nil)
schCreateWire(cv "route" "full" '((5.062 1.000) (5.062 1.750)) 0 0 0 nil nil)
schCreateWireLabel(cv nil '(5.062 1.250) "VSS" "lowerLeft" "R90" "stick" 0.0625 nil)
schCreateWire(cv "route" "full" '((5.250 1.000) (5.250 1.750)) 0 0 0 nil nil)
schCreateWireLabel(cv nil '(5.250 1.250) "IOVDDH" "lowerLeft" "R90" "stick" 0.0625 nil)
schCreateWire(cv "route" "full" '((5.625 1.000) (5.625 1.750)) 0 0 0 nil nil)
schCreateWireLabel(cv nil '(5.625 1.250) "IOVSS" "lowerLeft" "R90" "stick" 0.0625 nil)
dbCreateInst(cv pddw16sdgz_v_gMaster "D6_bottom2" '(6.3125 0) "R0")
schCreateWire(cv "route" "full" '((6.438 1.000) (6.438 1.750)) 0 0 0 nil nil)
schCreateWireLabel(cv nil '(6.438 1.250) "IOVDDL" "lowerLeft" "R90" "stick" 0.0625 nil)
schCreateWire(cv "route" "full" '((6.562 1.000) (6.562 1.750)) 0 0 0 nil nil)
dbCreateInst(cv noConnMaster "noConn_D6_bottom2_C" '(6.562 1.750) "R180")
schCreateWire(cv "route" "full" '((6.188 1.000) (6.188 1.750)) 0 0 0 nil nil)
schCreateWireLabel(cv nil '(6.188 1.250) "VSS" "lowerLeft" "R90" "stick" 0.0625 nil)
schCreateWire(cv "route" "full" '((6.062 1.000) (6.062 1.750)) 0 0 0 nil nil)
schCreateWireLabel(cv nil '(6.062 1.250) "D6_CORE" "lowerLeft" "R90" "stick" 0.0625 nil)
schCreatePin(cv nil "D6_CORE" "inputOutput" nil '(6.062 1.750) "R270")
schCreateWire(cv "route" "full" '((7.000 0.000) (7.000 -0.750)) 0 0 0 nil nil)
schCreateWireLabel(cv nil '(7.000 -0.250) "D6" "lowerRight" "R90" "stick" 0.0625 nil)
schCreatePin(cv nil "D6" "inputOutput" nil '(7.000 -0.750) "R90")
schCreateWire(cv "route" "full" '((6.688 1.000) (6.688 1.750)) 0 0 0 nil nil)
schCreateWireLabel(cv nil '(6.688 1.250) "POC" "lowerLeft" "R90" "stick" 0.0625 nil)
schCreateWire(cv "route" "full" '((6.875 1.000) (6.875 1.750)) 0 0 0 nil nil)
schCreateWireLabel(cv nil '(6.875 1.250) "IOVDDL" "lowerLeft" "R90" "stick" 0.0625 nil)
schCreateWire(cv "route" "full" '((7.062 1.000) (7.062 1.750)) 0 0 0 nil nil)
schCreateWireLabel(cv nil '(7.062 1.250) "VSS" "lowerLeft" "R90" "stick" 0.0625 nil)
schCreateWire(cv "route" "full" '((7.250 1.000) (7.250 1.750)) 0 0 0 nil nil)
schCreateWireLabel(cv nil '(7.250 1.250) "IOVDDH" "lowerLeft" "R90" "stick" 0.0625 nil)
schCreateWire(cv "route" "full" '((7.625 1.000) (7.625 1.750)) 0 0 0 nil nil)
schCreateWireLabel(cv nil '(7.625 1.250) "IOVSS" "lowerLeft" "R90" "stick" 0.0625 nil)
dbCreateInst(cv pddw16sdgz_v_gMaster "D5_bottom3" '(8.3125 0) "R0")
schCreateWire(cv "route" "full" '((8.438 1.000) (8.438 1.750)) 0 0 0 nil nil)
schCreateWireLabel(cv nil '(8.438 1.250) "IOVDDL" "lowerLeft" "R90" "stick" 0.0625 nil)
schCreateWire(cv "route" "full" '((8.562 1.000) (8.562 1.750)) 0 0 0 nil nil)
dbCreateInst(cv noConnMaster "noConn_D5_bottom3_C" '(8.562 1.750) "R180")
schCreateWire(cv "route" "full" '((8.188 1.000) (8.188 1.750)) 0 0 0 nil nil)
schCreateWireLabel(cv nil '(8.188 1.250) "VSS" "lowerLeft" "R90" "stick" 0.0625 nil)
schCreateWire(cv "route" "full" '((8.062 1.000) (8.062 1.750)) 0 0 0 nil nil)
schCreateWireLabel(cv nil '(8.062 1.250) "D5_CORE" "lowerLeft" "R90" "stick" 0.0625 nil)
schCreatePin(cv nil "D5_CORE" "inputOutput" nil '(8.062 1.750) "R270")
schCreateWire(cv "route" "full" '((9.001 0.000) (9.001 -0.750)) 0 0 0 nil nil)
schCreateWireLabel(cv nil '(9.001 -0.250) "D5" "lowerRight" "R90" "stick" 0.0625 nil)
schCreatePin(cv nil "D5" "inputOutput" nil '(9.001 -0.750) "R90")
schCreateWire(cv "route" "full" '((8.688 1.000) (8.688 1.750)) 0 0 0 nil nil)
schCreateWireLabel(cv nil '(8.688 1.250) "POC" "lowerLeft" "R90" "stick" 0.0625 nil)
schCreateWire(cv "route" "full" '((8.874 1.000) (8.874 1.750)) 0 0 0 nil nil)
schCreateWireLabel(cv nil '(8.874 1.250) "IOVDDL" "lowerLeft" "R90" "stick" 0.0625 nil)
schCreateWire(cv "route" "full" '((9.062 1.000) (9.062 1.750)) 0 0 0 nil nil)
schCreateWireLabel(cv nil '(9.062 1.250) "VSS" "lowerLeft" "R90" "stick" 0.0625 nil)
schCreateWire(cv "route" "full" '((9.251 1.000) (9.251 1.750)) 0 0 0 nil nil)
schCreateWireLabel(cv nil '(9.251 1.250) "IOVDDH" "lowerLeft" "R90" "stick" 0.0625 nil)
schCreateWire(cv "route" "full" '((9.624 1.000) (9.624 1.750)) 0 0 0 nil nil)
schCreateWireLabel(cv nil '(9.624 1.250) "IOVSS" "lowerLeft" "R90" "stick" 0.0625 nil)
dbCreateInst(cv pddw16sdgz_h_gMaster "D4_right0" '(12.0 2.3125) "R90")
schCreateWire(cv "route" "full" '((11.000 2.438) (10.250 2.438)) 0 0 0 nil nil)
schCreateWireLabel(cv nil '(10.750 2.438) "IOVDDL" "lowerRight" "R0" "stick" 0.0625 nil)
schCreateWire(cv "route" "full" '((11.000 2.562) (10.250 2.562)) 0 0 0 nil nil)
dbCreateInst(cv noConnMaster "noConn_D4_right0_C" '(10.250 2.562) "R270")
schCreateWire(cv "route" "full" '((11.000 2.188) (10.250 2.188)) 0 0 0 nil nil)
schCreateWireLabel(cv nil '(10.750 2.188) "VSS" "lowerRight" "R0" "stick" 0.0625 nil)
schCreateWire(cv "route" "full" '((11.000 2.062) (10.250 2.062)) 0 0 0 nil nil)
schCreateWireLabel(cv nil '(10.750 2.062) "D4_CORE" "lowerRight" "R0" "stick" 0.0625 nil)
schCreatePin(cv nil "D4_CORE" "inputOutput" nil '(10.250 2.062) "R0")
schCreateWire(cv "route" "full" '((12.000 3.000) (12.750 3.000)) 0 0 0 nil nil)
schCreateWireLabel(cv nil '(12.250 3.000) "D4" "lowerLeft" "R0" "stick" 0.0625 nil)
schCreatePin(cv nil "D4" "inputOutput" nil '(12.750 3.000) "R180")
schCreateWire(cv "route" "full" '((11.000 2.688) (10.250 2.688)) 0 0 0 nil nil)
schCreateWireLabel(cv nil '(10.750 2.688) "POC" "lowerRight" "R0" "stick" 0.0625 nil)
schCreateWire(cv "route" "full" '((11.000 2.875) (10.250 2.875)) 0 0 0 nil nil)
schCreateWireLabel(cv nil '(10.750 2.875) "IOVDDL" "lowerRight" "R0" "stick" 0.0625 nil)
schCreateWire(cv "route" "full" '((11.000 3.062) (10.250 3.062)) 0 0 0 nil nil)
schCreateWireLabel(cv nil '(10.750 3.062) "VSS" "lowerRight" "R0" "stick" 0.0625 nil)
schCreateWire(cv "route" "full" '((11.000 3.250) (10.250 3.250)) 0 0 0 nil nil)
schCreateWireLabel(cv nil '(10.750 3.250) "IOVDDH" "lowerRight" "R0" "stick" 0.0625 nil)
schCreateWire(cv "route" "full" '((11.000 3.625) (10.250 3.625)) 0 0 0 nil nil)
schCreateWireLabel(cv nil '(10.750 3.625) "IOVSS" "lowerRight" "R0" "stick" 0.0625 nil)
dbCreateInst(cv pddw16sdgz_h_gMaster "D3_right1" '(12.0 4.3125) "R90")
schCreateWire(cv "route" "full" '((11.000 4.438) (10.250 4.438)) 0 0 0 nil nil)
schCreateWireLabel(cv nil '(10.750 4.438) "IOVDDL" "lowerRight" "R0" "stick" 0.0625 nil)
schCreateWire(cv "route" "full" '((11.000 4.562) (10.250 4.562)) 0 0 0 nil nil)
dbCreateInst(cv noConnMaster "noConn_D3_right1_C" '(10.250 4.562) "R270")
schCreateWire(cv "route" "full" '((11.000 4.188) (10.250 4.188)) 0 0 0 nil nil)
schCreateWireLabel(cv nil '(10.750 4.188) "VSS" "lowerRight" "R0" "stick" 0.0625 nil)
schCreateWire(cv "route" "full" '((11.000 4.062) (10.250 4.062)) 0 0 0 nil nil)
schCreateWireLabel(cv nil '(10.750 4.062) "D3_CORE" "lowerRight" "R0" "stick" 0.0625 nil)
schCreatePin(cv nil "D3_CORE" "inputOutput" nil '(10.250 4.062) "R0")
schCreateWire(cv "route" "full" '((12.000 5.000) (12.750 5.000)) 0 0 0 nil nil)
schCreateWireLabel(cv nil '(12.250 5.000) "D3" "lowerLeft" "R0" "stick" 0.0625 nil)
schCreatePin(cv nil "D3" "inputOutput" nil '(12.750 5.000) "R180")
schCreateWire(cv "route" "full" '((11.000 4.688) (10.250 4.688)) 0 0 0 nil nil)
schCreateWireLabel(cv nil '(10.750 4.688) "POC" "lowerRight" "R0" "stick" 0.0625 nil)
schCreateWire(cv "route" "full" '((11.000 4.875) (10.250 4.875)) 0 0 0 nil nil)
schCreateWireLabel(cv nil '(10.750 4.875) "IOVDDL" "lowerRight" "R0" "stick" 0.0625 nil)
schCreateWire(cv "route" "full" '((11.000 5.062) (10.250 5.062)) 0 0 0 nil nil)
schCreateWireLabel(cv nil '(10.750 5.062) "VSS" "lowerRight" "R0" "stick" 0.0625 nil)
schCreateWire(cv "route" "full" '((11.000 5.250) (10.250 5.250)) 0 0 0 nil nil)
schCreateWireLabel(cv nil '(10.750 5.250) "IOVDDH" "lowerRight" "R0" "stick" 0.0625 nil)
schCreateWire(cv "route" "full" '((11.000 5.625) (10.250 5.625)) 0 0 0 nil nil)
schCreateWireLabel(cv nil '(10.750 5.625) "IOVSS" "lowerRight" "R0" "stick" 0.0625 nil)
dbCreateInst(cv pddw16sdgz_h_gMaster "D2_right2" '(12.0 6.3125) "R90")
schCreateWire(cv "route" "full" '((11.000 6.438) (10.250 6.438)) 0 0 0 nil nil)
schCreateWireLabel(cv nil '(10.750 6.438) "IOVDDL" "lowerRight" "R0" "stick" 0.0625 nil)
schCreateWire(cv "route" "full" '((11.000 6.562) (10.250 6.562)) 0 0 0 nil nil)
dbCreateInst(cv noConnMaster "noConn_D2_right2_C" '(10.250 6.562) "R270")
schCreateWire(cv "route" "full" '((11.000 6.188) (10.250 6.188)) 0 0 0 nil nil)
schCreateWireLabel(cv nil '(10.750 6.188) "VSS" "lowerRight" "R0" "stick" 0.0625 nil)
schCreateWire(cv "route" "full" '((11.000 6.062) (10.250 6.062)) 0 0 0 nil nil)
schCreateWireLabel(cv nil '(10.750 6.062) "D2_CORE" "lowerRight" "R0" "stick" 0.0625 nil)
schCreatePin(cv nil "D2_CORE" "inputOutput" nil '(10.250 6.062) "R0")
schCreateWire(cv "route" "full" '((12.000 7.000) (12.750 7.000)) 0 0 0 nil nil)
schCreateWireLabel(cv nil '(12.250 7.000) "D2" "lowerLeft" "R0" "stick" 0.0625 nil)
schCreatePin(cv nil "D2" "inputOutput" nil '(12.750 7.000) "R180")
schCreateWire(cv "route" "full" '((11.000 6.688) (10.250 6.688)) 0 0 0 nil nil)
schCreateWireLabel(cv nil '(10.750 6.688) "POC" "lowerRight" "R0" "stick" 0.0625 nil)
schCreateWire(cv "route" "full" '((11.000 6.875) (10.250 6.875)) 0 0 0 nil nil)
schCreateWireLabel(cv nil '(10.750 6.875) "IOVDDL" "lowerRight" "R0" "stick" 0.0625 nil)
schCreateWire(cv "route" "full" '((11.000 7.062) (10.250 7.062)) 0 0 0 nil nil)
schCreateWireLabel(cv nil '(10.750 7.062) "VSS" "lowerRight" "R0" "stick" 0.0625 nil)
schCreateWire(cv "route" "full" '((11.000 7.250) (10.250 7.250)) 0 0 0 nil nil)
schCreateWireLabel(cv nil '(10.750 7.250) "IOVDDH" "lowerRight" "R0" "stick" 0.0625 nil)
schCreateWire(cv "route" "full" '((11.000 7.625) (10.250 7.625)) 0 0 0 nil nil)
schCreateWireLabel(cv nil '(10.750 7.625) "IOVSS" "lowerRight" "R0" "stick" 0.0625 nil)
dbCreateInst(cv pddw16sdgz_h_gMaster "D1_right3" '(12.0 8.3125) "R90")
schCreateWire(cv "route" "full" '((11.000 8.438) (10.250 8.438)) 0 0 0 nil nil)
schCreateWireLabel(cv nil '(10.750 8.438) "IOVDDL" "lowerRight" "R0" "stick" 0.0625 nil)
schCreateWire(cv "route" "full" '((11.000 8.562) (10.250 8.562)) 0 0 0 nil nil)
dbCreateInst(cv noConnMaster "noConn_D1_right3_C" '(10.250 8.562) "R270")
schCreateWire(cv "route" "full" '((11.000 8.188) (10.250 8.188)) 0 0 0 nil nil)
schCreateWireLabel(cv nil '(10.750 8.188) "VSS" "lowerRight" "R0" "stick" 0.0625 nil)
schCreateWire(cv "route" "full" '((11.000 8.062) (10.250 8.062)) 0 0 0 nil nil)
schCreateWireLabel(cv nil '(10.750 8.062) "D1_CORE" "lowerRight" "R0" "stick" 0.0625 nil)
schCreatePin(cv nil "D1_CORE" "inputOutput" nil '(10.250 8.062) "R0")
schCreateWire(cv "route" "full" '((12.000 9.001) (12.750 9.001)) 0 0 0 nil nil)
schCreateWireLabel(cv nil '(12.250 9.001) "D1" "lowerLeft" "R0" "stick" 0.0625 nil)
schCreatePin(cv nil "D1" "inputOutput" nil '(12.750 9.001) "R180")
schCreateWire(cv "route" "full" '((11.000 8.688) (10.250 8.688)) 0 0 0 nil nil)
schCreateWireLabel(cv nil '(10.750 8.688) "POC" "lowerRight" "R0" "stick" 0.0625 nil)
schCreateWire(cv "route" "full" '((11.000 8.874) (10.250 8.874)) 0 0 0 nil nil)
schCreateWireLabel(cv nil '(10.750 8.874) "IOVDDL" "lowerRight" "R0" "stick" 0.0625 nil)
schCreateWire(cv "route" "full" '((11.000 9.062) (10.250 9.062)) 0 0 0 nil nil)
schCreateWireLabel(cv nil '(10.750 9.062) "VSS" "lowerRight" "R0" "stick" 0.0625 nil)
schCreateWire(cv "route" "full" '((11.000 9.251) (10.250 9.251)) 0 0 0 nil nil)
schCreateWireLabel(cv nil '(10.750 9.251) "IOVDDH" "lowerRight" "R0" "stick" 0.0625 nil)
schCreateWire(cv "route" "full" '((11.000 9.624) (10.250 9.624)) 0 0 0 nil nil)
schCreateWireLabel(cv nil '(10.750 9.624) "IOVSS" "lowerRight" "R0" "stick" 0.0625 nil)
pvdd2poc_v_gMaster = dbOpenCellView("tphn28hpcpgv18" "PVDD2POC_V_G" "symbol")
dbCreateInst(cv pvdd2poc_v_gMaster "IOVDDH_top0" '(10.0 12.0) "R180")
schCreateWire(cv "route" "full" '((9.625 11.000) (9.625 10.250)) 0 0 0 nil nil)
schCreateWireLabel(cv nil '(9.625 10.750) "POC" "lowerRight" "R90" "stick" 0.0625 nil)
schCreateWire(cv "route" "full" '((9.438 11.000) (9.438 10.250)) 0 0 0 nil nil)
schCreateWireLabel(cv nil '(9.438 10.750) "IOVDDL" "lowerRight" "R90" "stick" 0.0625 nil)
schCreateWire(cv "route" "full" '((9.250 11.000) (9.250 10.250)) 0 0 0 nil nil)
schCreateWireLabel(cv nil '(9.250 10.750) "VSS" "lowerRight" "R90" "stick" 0.0625 nil)
schCreateWire(cv "route" "full" '((9.000 12.000) (9.000 12.750)) 0 0 0 nil nil)
schCreateWireLabel(cv nil '(9.000 12.250) "IOVDDH" "lowerLeft" "R90" "stick" 0.0625 nil)
schCreatePin(cv nil "IOVDDH" "inputOutput" nil '(9.000 12.750) "R270")
schCreateWire(cv "route" "full" '((8.688 11.000) (8.688 10.250)) 0 0 0 nil nil)
schCreateWireLabel(cv nil '(8.688 10.750) "IOVSS" "lowerRight" "R90" "stick" 0.0625 nil)
pvss2dgz_v_gMaster = dbOpenCellView("tphn28hpcpgv18" "PVSS2DGZ_V_G" "symbol")
dbCreateInst(cv pvss2dgz_v_gMaster "IOVSS_top1" '(8.0 12.0) "R180")
schCreateWire(cv "route" "full" '((7.625 11.000) (7.625 10.250)) 0 0 0 nil nil)
schCreateWireLabel(cv nil '(7.625 10.750) "POC" "lowerRight" "R90" "stick" 0.0625 nil)
schCreateWire(cv "route" "full" '((7.438 11.000) (7.438 10.250)) 0 0 0 nil nil)
schCreateWireLabel(cv nil '(7.438 10.750) "IOVDDL" "lowerRight" "R90" "stick" 0.0625 nil)
schCreateWire(cv "route" "full" '((7.250 11.000) (7.250 10.250)) 0 0 0 nil nil)
schCreateWireLabel(cv nil '(7.250 10.750) "VSS" "lowerRight" "R90" "stick" 0.0625 nil)
schCreateWire(cv "route" "full" '((7.062 11.000) (7.062 10.250)) 0 0 0 nil nil)
schCreateWireLabel(cv nil '(7.062 10.750) "IOVDDH" "lowerRight" "R90" "stick" 0.0625 nil)
schCreateWire(cv "route" "full" '((7.000 12.000) (7.000 12.750)) 0 0 0 nil nil)
schCreateWireLabel(cv nil '(7.000 12.250) "IOVSS" "lowerLeft" "R90" "stick" 0.0625 nil)
schCreatePin(cv nil "IOVSS" "inputOutput" nil '(7.000 12.750) "R270")
pvdd1dgz_v_gMaster = dbOpenCellView("tphn28hpcpgv18" "PVDD1DGZ_V_G" "symbol")
dbCreateInst(cv pvdd1dgz_v_gMaster "IOVDDL_top2" '(6.0 12.0) "R180")
schCreateWire(cv "route" "full" '((5.625 11.000) (5.625 10.250)) 0 0 0 nil nil)
schCreateWireLabel(cv nil '(5.625 10.750) "POC" "lowerRight" "R90" "stick" 0.0625 nil)
schCreateWire(cv "route" "full" '((5.000 12.000) (5.000 12.750)) 0 0 0 nil nil)
schCreateWireLabel(cv nil '(5.000 12.250) "IOVDDL" "lowerLeft" "R90" "stick" 0.0625 nil)
schCreatePin(cv nil "IOVDDL" "inputOutput" nil '(5.000 12.750) "R270")
schCreateWire(cv "route" "full" '((5.250 11.000) (5.250 10.250)) 0 0 0 nil nil)
schCreateWireLabel(cv nil '(5.250 10.750) "VSS" "lowerRight" "R90" "stick" 0.0625 nil)
schCreateWire(cv "route" "full" '((5.062 11.000) (5.062 10.250)) 0 0 0 nil nil)
schCreateWireLabel(cv nil '(5.062 10.750) "IOVDDH" "lowerRight" "R90" "stick" 0.0625 nil)
schCreateWire(cv "route" "full" '((4.688 11.000) (4.688 10.250)) 0 0 0 nil nil)
schCreateWireLabel(cv nil '(4.688 10.750) "IOVSS" "lowerRight" "R90" "stick" 0.0625 nil)
pvss1dgz_v_gMaster = dbOpenCellView("tphn28hpcpgv18" "PVSS1DGZ_V_G" "symbol")
dbCreateInst(cv pvss1dgz_v_gMaster "VSS_top3" '(4.0 12.0) "R180")
schCreateWire(cv "route" "full" '((3.625 11.000) (3.625 10.250)) 0 0 0 nil nil)
schCreateWireLabel(cv nil '(3.625 10.750) "POC" "lowerRight" "R90" "stick" 0.0625 nil)
schCreateWire(cv "route" "full" '((3.438 11.000) (3.438 10.250)) 0 0 0 nil nil)
schCreateWireLabel(cv nil '(3.438 10.750) "IOVDDL" "lowerRight" "R90" "stick" 0.0625 nil)
schCreateWire(cv "route" "full" '((3.000 12.000) (3.000 12.750)) 0 0 0 nil nil)
schCreateWireLabel(cv nil '(3.000 12.250) "VSS" "lowerLeft" "R90" "stick" 0.0625 nil)
schCreatePin(cv nil "VSS" "inputOutput" nil '(3.000 12.750) "R270")
schCreateWire(cv "route" "full" '((3.062 11.000) (3.062 10.250)) 0 0 0 nil nil)
schCreateWireLabel(cv nil '(3.062 10.750) "IOVDDH" "lowerRight" "R90" "stick" 0.0625 nil)
schCreateWire(cv "route" "full" '((2.688 11.000) (2.688 10.250)) 0 0 0 nil nil)
schCreateWireLabel(cv nil '(2.688 10.750) "IOVSS" "lowerRight" "R90" "stick" 0.0625 nil)
schCheck(cv)
dbSave(cv)
t
