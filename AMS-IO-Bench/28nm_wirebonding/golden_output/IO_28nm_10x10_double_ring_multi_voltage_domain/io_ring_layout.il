; Generated Layout Script with Dual Ring Support

; ==================== All Components (Sorted by Placement Order) ====================
dbCreateParamInstByMasterName(cv "tphn28hpcpgv18" "PDB3AC_H_G" "layout" "CLKN_left_9" list(0 150) "R270")
dbCreateParamInstByMasterName(cv "PAD" "PAD60GU" "layout" "pad60gu_CLKN_left_9" list(0 150) "R270")
dbCreateParamInstByMasterName(cv "tphn28hpcpgv18" "PDB3AC_H_G" "layout" "CLKP_left_8" list(0 210) "R270")
dbCreateParamInstByMasterName(cv "PAD" "PAD60GU" "layout" "pad60gu_CLKP_left_8" list(0 210) "R270")
dbCreateParamInstByMasterName(cv "tphn28hpcpgv18" "PVSS3AC_H_G" "layout" "AVSS_left_7" list(0 270) "R270")
dbCreateParamInstByMasterName(cv "PAD" "PAD60GU" "layout" "pad60gu_AVSS_left_7" list(0 270) "R270")
dbCreateParamInstByMasterName(cv "tphn28hpcpgv18" "PVDD3AC_H_G" "layout" "AVDD_left_6" list(0 330) "R270")
dbCreateParamInstByMasterName(cv "PAD" "PAD60GU" "layout" "pad60gu_AVDD_left_6" list(0 330) "R270")
dbCreateParamInstByMasterName(cv "tphn28hpcpgv18" "PDB3AC_H_G" "layout" "VREF_left_5" list(0 390) "R270")
dbCreateParamInstByMasterName(cv "PAD" "PAD60GU" "layout" "pad60gu_VREF_left_5" list(0 390) "R270")
dbCreateParamInstByMasterName(cv "tphn28hpcpgv18" "PDB3AC_H_G" "layout" "VCM_left_4" list(0 450) "R270")
dbCreateParamInstByMasterName(cv "PAD" "PAD60GU" "layout" "pad60gu_VCM_left_4" list(0 450) "R270")
dbCreateParamInstByMasterName(cv "tphn28hpcpgv18" "PDB3AC_H_G" "layout" "VIM_left_3" list(0 510) "R270")
dbCreateParamInstByMasterName(cv "PAD" "PAD60GU" "layout" "pad60gu_VIM_left_3" list(0 510) "R270")
dbCreateParamInstByMasterName(cv "tphn28hpcpgv18" "PDB3AC_H_G" "layout" "VIP_left_2" list(0 570) "R270")
dbCreateParamInstByMasterName(cv "PAD" "PAD60GU" "layout" "pad60gu_VIP_left_2" list(0 570) "R270")
dbCreateParamInstByMasterName(cv "tphn28hpcpgv18" "PDB3AC_H_G" "layout" "VINN_left_1" list(0 630) "R270")
dbCreateParamInstByMasterName(cv "PAD" "PAD60GU" "layout" "pad60gu_VINN_left_1" list(0 630) "R270")
dbCreateParamInstByMasterName(cv "tphn28hpcpgv18" "PDB3AC_H_G" "layout" "VINP_left_0" list(0 690) "R270")
dbCreateParamInstByMasterName(cv "PAD" "PAD60GU" "layout" "pad60gu_VINP_left_0" list(0 690) "R270")
dbCreateParamInstByMasterName(cv "tphn28hpcpgv18" "PCORNERA_G" "layout" "CORNER_TL_top_left" list(0 820) "R270")
dbCreateParamInstByMasterName(cv "tphn28hpcpgv18" "PVSS3AC_V_G" "layout" "VSS_DAC_bottom_9" list(670 0) "R0")
dbCreateParamInstByMasterName(cv "PAD" "PAD60GU" "layout" "pad60gu_VSS_DAC_bottom_9" list(670 0) "R0")
dbCreateParamInstByMasterName(cv "tphn28hpcpgv18" "PVDD3AC_V_G" "layout" "VDD_DAC_bottom_8" list(610 0) "R0")
dbCreateParamInstByMasterName(cv "PAD" "PAD60GU" "layout" "pad60gu_VDD_DAC_bottom_8" list(610 0) "R0")
dbCreateParamInstByMasterName(cv "tphn28hpcpgv18" "PVSS3AC_V_G" "layout" "VSS_ADC_bottom_7" list(550 0) "R0")
dbCreateParamInstByMasterName(cv "PAD" "PAD60GU" "layout" "pad60gu_VSS_ADC_bottom_7" list(550 0) "R0")
dbCreateParamInstByMasterName(cv "tphn28hpcpgv18" "PVDD3AC_V_G" "layout" "VDD_ADC_bottom_6" list(490 0) "R0")
dbCreateParamInstByMasterName(cv "PAD" "PAD60GU" "layout" "pad60gu_VDD_ADC_bottom_6" list(490 0) "R0")
dbCreateParamInstByMasterName(cv "tphn28hpcpgv18" "PVSS3AC_V_G" "layout" "VREFN_bottom_5" list(430 0) "R0")
dbCreateParamInstByMasterName(cv "PAD" "PAD60GU" "layout" "pad60gu_VREFN_bottom_5" list(430 0) "R0")
dbCreateParamInstByMasterName(cv "tphn28hpcpgv18" "PVDD3AC_V_G" "layout" "VREFH_bottom_4" list(370 0) "R0")
dbCreateParamInstByMasterName(cv "PAD" "PAD60GU" "layout" "pad60gu_VREFH_bottom_4" list(370 0) "R0")
dbCreateParamInstByMasterName(cv "tphn28hpcpgv18" "PVSS3AC_V_G" "layout" "VSS_DAT_bottom_3" list(310 0) "R0")
dbCreateParamInstByMasterName(cv "PAD" "PAD60GU" "layout" "pad60gu_VSS_DAT_bottom_3" list(310 0) "R0")
dbCreateParamInstByMasterName(cv "tphn28hpcpgv18" "PVDD3AC_V_G" "layout" "VDD_DAT_bottom_2" list(250 0) "R0")
dbCreateParamInstByMasterName(cv "PAD" "PAD60GU" "layout" "pad60gu_VDD_DAT_bottom_2" list(250 0) "R0")
dbCreateParamInstByMasterName(cv "tphn28hpcpgv18" "PVSS3AC_V_G" "layout" "VSS_CKB_bottom_1" list(190 0) "R0")
dbCreateParamInstByMasterName(cv "PAD" "PAD60GU" "layout" "pad60gu_VSS_CKB_bottom_1" list(190 0) "R0")
dbCreateParamInstByMasterName(cv "tphn28hpcpgv18" "PVDD3AC_V_G" "layout" "VDD_CKB_bottom_0" list(130 0) "R0")
dbCreateParamInstByMasterName(cv "PAD" "PAD60GU" "layout" "pad60gu_VDD_CKB_bottom_0" list(130 0) "R0")
dbCreateParamInstByMasterName(cv "tphn28hpcpgv18" "PCORNERA_G" "layout" "CORNER_BL_bottom_left" list(0 0) "R0")
dbCreateParamInstByMasterName(cv "tphn28hpcpgv18" "PDDW16SDGZ_H_G" "layout" "D9_right_9" list(820 670) "R90")
dbCreateParamInstByMasterName(cv "PAD" "PAD60GU" "layout" "pad60gu_D9_right_9" list(820 670) "R90")
dbCreateParamInstByMasterName(cv "tphn28hpcpgv18" "PDDW16SDGZ_H_G" "layout" "D8_right_8" list(820 610) "R90")
dbCreateParamInstByMasterName(cv "PAD" "PAD60GU" "layout" "pad60gu_D8_right_8" list(820 610) "R90")
dbCreateParamInstByMasterName(cv "tphn28hpcpgv18" "PDDW16SDGZ_H_G" "layout" "D7_right_7" list(820 550) "R90")
dbCreateParamInstByMasterName(cv "PAD" "PAD60GU" "layout" "pad60gu_D7_right_7" list(820 550) "R90")
dbCreateParamInstByMasterName(cv "tphn28hpcpgv18" "PDDW16SDGZ_H_G" "layout" "D6_right_6" list(820 490) "R90")
dbCreateParamInstByMasterName(cv "PAD" "PAD60GU" "layout" "pad60gu_D6_right_6" list(820 490) "R90")
dbCreateParamInstByMasterName(cv "tphn28hpcpgv18" "PDDW16SDGZ_H_G" "layout" "D5_right_5" list(820 430) "R90")
dbCreateParamInstByMasterName(cv "PAD" "PAD60GU" "layout" "pad60gu_D5_right_5" list(820 430) "R90")
dbCreateParamInstByMasterName(cv "tphn28hpcpgv18" "PDDW16SDGZ_H_G" "layout" "D4_right_4" list(820 370) "R90")
dbCreateParamInstByMasterName(cv "PAD" "PAD60GU" "layout" "pad60gu_D4_right_4" list(820 370) "R90")
dbCreateParamInstByMasterName(cv "tphn28hpcpgv18" "PDDW16SDGZ_H_G" "layout" "D3_right_3" list(820 310) "R90")
dbCreateParamInstByMasterName(cv "PAD" "PAD60GU" "layout" "pad60gu_D3_right_3" list(820 310) "R90")
dbCreateParamInstByMasterName(cv "tphn28hpcpgv18" "PDDW16SDGZ_H_G" "layout" "D2_right_2" list(820 250) "R90")
dbCreateParamInstByMasterName(cv "PAD" "PAD60GU" "layout" "pad60gu_D2_right_2" list(820 250) "R90")
dbCreateParamInstByMasterName(cv "tphn28hpcpgv18" "PDDW16SDGZ_H_G" "layout" "D1_right_1" list(820 190) "R90")
dbCreateParamInstByMasterName(cv "PAD" "PAD60GU" "layout" "pad60gu_D1_right_1" list(820 190) "R90")
dbCreateParamInstByMasterName(cv "tphn28hpcpgv18" "PDDW16SDGZ_H_G" "layout" "D0_right_0" list(820 130) "R90")
dbCreateParamInstByMasterName(cv "PAD" "PAD60GU" "layout" "pad60gu_D0_right_0" list(820 130) "R90")
dbCreateParamInstByMasterName(cv "tphn28hpcpgv18" "PCORNERA_G" "layout" "CORNER_BR_bottom_right" list(820 0) "R90")
dbCreateParamInstByMasterName(cv "tphn28hpcpgv18" "PVSS2DGZ_V_G" "layout" "GIOH_top_9" list(150 820) "R180")
dbCreateParamInstByMasterName(cv "PAD" "PAD60GU" "layout" "pad60gu_GIOH_top_9" list(150 820) "R180")
dbCreateParamInstByMasterName(cv "tphn28hpcpgv18" "PVDD2POC_V_G" "layout" "VIOH_top_8" list(210 820) "R180")
dbCreateParamInstByMasterName(cv "PAD" "PAD60GU" "layout" "pad60gu_VIOH_top_8" list(210 820) "R180")
dbCreateParamInstByMasterName(cv "tphn28hpcpgv18" "PVSS1DGZ_V_G" "layout" "GIOL_top_7" list(270 820) "R180")
dbCreateParamInstByMasterName(cv "PAD" "PAD60GU" "layout" "pad60gu_GIOL_top_7" list(270 820) "R180")
dbCreateParamInstByMasterName(cv "tphn28hpcpgv18" "PVDD1DGZ_V_G" "layout" "VIOL_top_6" list(330 820) "R180")
dbCreateParamInstByMasterName(cv "PAD" "PAD60GU" "layout" "pad60gu_VIOL_top_6" list(330 820) "R180")
dbCreateParamInstByMasterName(cv "tphn28hpcpgv18" "PDDW16SDGZ_V_G" "layout" "D15_top_5" list(390 820) "R180")
dbCreateParamInstByMasterName(cv "PAD" "PAD60GU" "layout" "pad60gu_D15_top_5" list(390 820) "R180")
dbCreateParamInstByMasterName(cv "tphn28hpcpgv18" "PDDW16SDGZ_V_G" "layout" "D14_top_4" list(450 820) "R180")
dbCreateParamInstByMasterName(cv "PAD" "PAD60GU" "layout" "pad60gu_D14_top_4" list(450 820) "R180")
dbCreateParamInstByMasterName(cv "tphn28hpcpgv18" "PDDW16SDGZ_V_G" "layout" "D13_top_3" list(510 820) "R180")
dbCreateParamInstByMasterName(cv "PAD" "PAD60GU" "layout" "pad60gu_D13_top_3" list(510 820) "R180")
dbCreateParamInstByMasterName(cv "tphn28hpcpgv18" "PDDW16SDGZ_V_G" "layout" "D12_top_2" list(570 820) "R180")
dbCreateParamInstByMasterName(cv "PAD" "PAD60GU" "layout" "pad60gu_D12_top_2" list(570 820) "R180")
dbCreateParamInstByMasterName(cv "tphn28hpcpgv18" "PDDW16SDGZ_V_G" "layout" "D11_top_1" list(630 820) "R180")
dbCreateParamInstByMasterName(cv "PAD" "PAD60GU" "layout" "pad60gu_D11_top_1" list(630 820) "R180")
dbCreateParamInstByMasterName(cv "tphn28hpcpgv18" "PDDW16SDGZ_V_G" "layout" "D10_top_0" list(690 820) "R180")
dbCreateParamInstByMasterName(cv "PAD" "PAD60GU" "layout" "pad60gu_D10_top_0" list(690 820) "R180")
dbCreateParamInstByMasterName(cv "tphn28hpcpgv18" "PCORNER_G" "layout" "CORNER_TR_top_right" list(820 820) "R180")

; ==================== Inner Ring Pads ====================
dbCreateParamInstByMasterName(cv "tphn28hpcpgv18" "PVDD3AC_H_G" "layout" "inner_pad_VREF_CORE_left_5_6" list(0 360) "R270")
dbCreateParamInstByMasterName(cv "PAD" "PAD60NU" "layout" "inner_pad60nu_VREF_CORE_left_5_6" list(0 360) "R270")
dbCreateParamInstByMasterName(cv "tphn28hpcpgv18" "PVDD3AC_H_G" "layout" "inner_pad_VAMP_CORE_left_0_1" list(0 660) "R270")
dbCreateParamInstByMasterName(cv "PAD" "PAD60NU" "layout" "inner_pad60nu_VAMP_CORE_left_0_1" list(0 660) "R270")
dbCreateParamInstByMasterName(cv "tphn28hpcpgv18" "PVDD3AC_H_G" "layout" "inner_pad_IBIAS_CORE_left_2_3" list(0 540) "R270")
dbCreateParamInstByMasterName(cv "PAD" "PAD60NU" "layout" "inner_pad60nu_IBIAS_CORE_left_2_3" list(0 540) "R270")
dbCreateParamInstByMasterName(cv "tphn28hpcpgv18" "PVDD3AC_V_G" "layout" "inner_pad_ADC_CORE_bottom_6_7" list(520 0) "R0")
dbCreateParamInstByMasterName(cv "PAD" "PAD60NU" "layout" "inner_pad60nu_ADC_CORE_bottom_6_7" list(520 0) "R0")

; ==================== Filler Components ====================
dbCreateParamInstByMasterName(cv "tphn28hpcpgv18" "PRCUTA_G" "layout" "sep_bottom_right_corner" list(690 0) "R0")
dbCreateParamInstByMasterName(cv "tphn28hpcpgv18" "PFILLER20A_G" "layout" "filler_bottom_left_corner" list(110 0) "R0")
dbCreateParamInstByMasterName(cv "tphn28hpcpgv18" "PFILLER20A_G" "layout" "filler_R0_1_1" list(650 0) "R0")
dbCreateParamInstByMasterName(cv "tphn28hpcpgv18" "PFILLER20A_G" "layout" "filler_R0_1_2" list(630 0) "R0")
dbCreateParamInstByMasterName(cv "tphn28hpcpgv18" "PRCUTA_G" "layout" "filler_R0_2_1" list(590 0) "R0")
dbCreateParamInstByMasterName(cv "tphn28hpcpgv18" "PRCUTA_G" "layout" "filler_R0_2_2" list(570 0) "R0")
dbCreateParamInstByMasterName(cv "tphn28hpcpgv18" "PFILLER10A_G" "layout" "filler_R0_3_1" list(540 0) "R0")
dbCreateParamInstByMasterName(cv "tphn28hpcpgv18" "PFILLER10A_G" "layout" "filler_R0_3_2" list(510 0) "R0")
dbCreateParamInstByMasterName(cv "tphn28hpcpgv18" "PRCUTA_G" "layout" "filler_R0_4_1" list(470 0) "R0")
dbCreateParamInstByMasterName(cv "tphn28hpcpgv18" "PRCUTA_G" "layout" "filler_R0_4_2" list(450 0) "R0")
dbCreateParamInstByMasterName(cv "tphn28hpcpgv18" "PFILLER20A_G" "layout" "filler_R0_5_1" list(410 0) "R0")
dbCreateParamInstByMasterName(cv "tphn28hpcpgv18" "PFILLER20A_G" "layout" "filler_R0_5_2" list(390 0) "R0")
dbCreateParamInstByMasterName(cv "tphn28hpcpgv18" "PRCUTA_G" "layout" "filler_R0_6_1" list(350 0) "R0")
dbCreateParamInstByMasterName(cv "tphn28hpcpgv18" "PRCUTA_G" "layout" "filler_R0_6_2" list(330 0) "R0")
dbCreateParamInstByMasterName(cv "tphn28hpcpgv18" "PFILLER20A_G" "layout" "filler_R0_7_1" list(290 0) "R0")
dbCreateParamInstByMasterName(cv "tphn28hpcpgv18" "PFILLER20A_G" "layout" "filler_R0_7_2" list(270 0) "R0")
dbCreateParamInstByMasterName(cv "tphn28hpcpgv18" "PRCUTA_G" "layout" "filler_R0_8_1" list(230 0) "R0")
dbCreateParamInstByMasterName(cv "tphn28hpcpgv18" "PRCUTA_G" "layout" "filler_R0_8_2" list(210 0) "R0")
dbCreateParamInstByMasterName(cv "tphn28hpcpgv18" "PFILLER20A_G" "layout" "filler_R0_9_1" list(170 0) "R0")
dbCreateParamInstByMasterName(cv "tphn28hpcpgv18" "PFILLER20A_G" "layout" "filler_R0_9_2" list(150 0) "R0")
dbCreateParamInstByMasterName(cv "tphn28hpcpgv18" "PFILLER20_G" "layout" "filler_right_top_corner" list(820 690) "R90")
dbCreateParamInstByMasterName(cv "tphn28hpcpgv18" "PRCUTA_G" "layout" "filler_right_bottom_corner" list(820 110) "R90")
dbCreateParamInstByMasterName(cv "tphn28hpcpgv18" "PFILLER20_G" "layout" "filler_R90_1_1" list(820 650) "R90")
dbCreateParamInstByMasterName(cv "tphn28hpcpgv18" "PFILLER20_G" "layout" "filler_R90_1_2" list(820 630) "R90")
dbCreateParamInstByMasterName(cv "tphn28hpcpgv18" "PFILLER20_G" "layout" "filler_R90_2_1" list(820 590) "R90")
dbCreateParamInstByMasterName(cv "tphn28hpcpgv18" "PFILLER20_G" "layout" "filler_R90_2_2" list(820 570) "R90")
dbCreateParamInstByMasterName(cv "tphn28hpcpgv18" "PFILLER20_G" "layout" "filler_R90_3_1" list(820 530) "R90")
dbCreateParamInstByMasterName(cv "tphn28hpcpgv18" "PFILLER20_G" "layout" "filler_R90_3_2" list(820 510) "R90")
dbCreateParamInstByMasterName(cv "tphn28hpcpgv18" "PFILLER20_G" "layout" "filler_R90_4_1" list(820 470) "R90")
dbCreateParamInstByMasterName(cv "tphn28hpcpgv18" "PFILLER20_G" "layout" "filler_R90_4_2" list(820 450) "R90")
dbCreateParamInstByMasterName(cv "tphn28hpcpgv18" "PFILLER20_G" "layout" "filler_R90_5_1" list(820 410) "R90")
dbCreateParamInstByMasterName(cv "tphn28hpcpgv18" "PFILLER20_G" "layout" "filler_R90_5_2" list(820 390) "R90")
dbCreateParamInstByMasterName(cv "tphn28hpcpgv18" "PFILLER20_G" "layout" "filler_R90_6_1" list(820 350) "R90")
dbCreateParamInstByMasterName(cv "tphn28hpcpgv18" "PFILLER20_G" "layout" "filler_R90_6_2" list(820 330) "R90")
dbCreateParamInstByMasterName(cv "tphn28hpcpgv18" "PFILLER20_G" "layout" "filler_R90_7_1" list(820 290) "R90")
dbCreateParamInstByMasterName(cv "tphn28hpcpgv18" "PFILLER20_G" "layout" "filler_R90_7_2" list(820 270) "R90")
dbCreateParamInstByMasterName(cv "tphn28hpcpgv18" "PFILLER20_G" "layout" "filler_R90_8_1" list(820 230) "R90")
dbCreateParamInstByMasterName(cv "tphn28hpcpgv18" "PFILLER20_G" "layout" "filler_R90_8_2" list(820 210) "R90")
dbCreateParamInstByMasterName(cv "tphn28hpcpgv18" "PFILLER20_G" "layout" "filler_R90_9_1" list(820 170) "R90")
dbCreateParamInstByMasterName(cv "tphn28hpcpgv18" "PFILLER20_G" "layout" "filler_R90_9_2" list(820 150) "R90")
dbCreateParamInstByMasterName(cv "tphn28hpcpgv18" "PRCUTA_G" "layout" "sep_top_left_corner" list(130 820) "R180")
dbCreateParamInstByMasterName(cv "tphn28hpcpgv18" "PFILLER20_G" "layout" "filler_top_right_corner" list(710 820) "R180")
dbCreateParamInstByMasterName(cv "tphn28hpcpgv18" "PFILLER20_G" "layout" "filler_R180_1_1" list(170 820) "R180")
dbCreateParamInstByMasterName(cv "tphn28hpcpgv18" "PFILLER20_G" "layout" "filler_R180_1_2" list(190 820) "R180")
dbCreateParamInstByMasterName(cv "tphn28hpcpgv18" "PFILLER20_G" "layout" "filler_R180_2_1" list(230 820) "R180")
dbCreateParamInstByMasterName(cv "tphn28hpcpgv18" "PFILLER20_G" "layout" "filler_R180_2_2" list(250 820) "R180")
dbCreateParamInstByMasterName(cv "tphn28hpcpgv18" "PFILLER20_G" "layout" "filler_R180_3_1" list(290 820) "R180")
dbCreateParamInstByMasterName(cv "tphn28hpcpgv18" "PFILLER20_G" "layout" "filler_R180_3_2" list(310 820) "R180")
dbCreateParamInstByMasterName(cv "tphn28hpcpgv18" "PFILLER20_G" "layout" "filler_R180_4_1" list(350 820) "R180")
dbCreateParamInstByMasterName(cv "tphn28hpcpgv18" "PFILLER20_G" "layout" "filler_R180_4_2" list(370 820) "R180")
dbCreateParamInstByMasterName(cv "tphn28hpcpgv18" "PFILLER20_G" "layout" "filler_R180_5_1" list(410 820) "R180")
dbCreateParamInstByMasterName(cv "tphn28hpcpgv18" "PFILLER20_G" "layout" "filler_R180_5_2" list(430 820) "R180")
dbCreateParamInstByMasterName(cv "tphn28hpcpgv18" "PFILLER20_G" "layout" "filler_R180_6_1" list(470 820) "R180")
dbCreateParamInstByMasterName(cv "tphn28hpcpgv18" "PFILLER20_G" "layout" "filler_R180_6_2" list(490 820) "R180")
dbCreateParamInstByMasterName(cv "tphn28hpcpgv18" "PFILLER20_G" "layout" "filler_R180_7_1" list(530 820) "R180")
dbCreateParamInstByMasterName(cv "tphn28hpcpgv18" "PFILLER20_G" "layout" "filler_R180_7_2" list(550 820) "R180")
dbCreateParamInstByMasterName(cv "tphn28hpcpgv18" "PFILLER20_G" "layout" "filler_R180_8_1" list(590 820) "R180")
dbCreateParamInstByMasterName(cv "tphn28hpcpgv18" "PFILLER20_G" "layout" "filler_R180_8_2" list(610 820) "R180")
dbCreateParamInstByMasterName(cv "tphn28hpcpgv18" "PFILLER20_G" "layout" "filler_R180_9_1" list(650 820) "R180")
dbCreateParamInstByMasterName(cv "tphn28hpcpgv18" "PFILLER20_G" "layout" "filler_R180_9_2" list(670 820) "R180")
dbCreateParamInstByMasterName(cv "tphn28hpcpgv18" "PFILLER20A_G" "layout" "filler_left_bottom_corner" list(0 130) "R270")
dbCreateParamInstByMasterName(cv "tphn28hpcpgv18" "PRCUTA_G" "layout" "sep_left_top_corner" list(0 710) "R270")
dbCreateParamInstByMasterName(cv "tphn28hpcpgv18" "PFILLER20A_G" "layout" "filler_R270_1_1" list(0 170) "R270")
dbCreateParamInstByMasterName(cv "tphn28hpcpgv18" "PFILLER20A_G" "layout" "filler_R270_1_2" list(0 190) "R270")
dbCreateParamInstByMasterName(cv "tphn28hpcpgv18" "PRCUTA_G" "layout" "filler_R270_2_1" list(0 230) "R270")
dbCreateParamInstByMasterName(cv "tphn28hpcpgv18" "PRCUTA_G" "layout" "filler_R270_2_2" list(0 250) "R270")
dbCreateParamInstByMasterName(cv "tphn28hpcpgv18" "PFILLER20A_G" "layout" "filler_R270_3_1" list(0 290) "R270")
dbCreateParamInstByMasterName(cv "tphn28hpcpgv18" "PFILLER20A_G" "layout" "filler_R270_3_2" list(0 310) "R270")
dbCreateParamInstByMasterName(cv "tphn28hpcpgv18" "PFILLER10A_G" "layout" "filler_R270_4_1" list(0 340) "R270")
dbCreateParamInstByMasterName(cv "tphn28hpcpgv18" "PFILLER10A_G" "layout" "filler_R270_4_2" list(0 370) "R270")
dbCreateParamInstByMasterName(cv "tphn28hpcpgv18" "PFILLER20A_G" "layout" "filler_R270_5_1" list(0 410) "R270")
dbCreateParamInstByMasterName(cv "tphn28hpcpgv18" "PFILLER20A_G" "layout" "filler_R270_5_2" list(0 430) "R270")
dbCreateParamInstByMasterName(cv "tphn28hpcpgv18" "PFILLER20A_G" "layout" "filler_R270_6_1" list(0 470) "R270")
dbCreateParamInstByMasterName(cv "tphn28hpcpgv18" "PFILLER20A_G" "layout" "filler_R270_6_2" list(0 490) "R270")
dbCreateParamInstByMasterName(cv "tphn28hpcpgv18" "PFILLER10A_G" "layout" "filler_R270_7_1" list(0 520) "R270")
dbCreateParamInstByMasterName(cv "tphn28hpcpgv18" "PFILLER10A_G" "layout" "filler_R270_7_2" list(0 550) "R270")
dbCreateParamInstByMasterName(cv "tphn28hpcpgv18" "PFILLER20A_G" "layout" "filler_R270_8_1" list(0 590) "R270")
dbCreateParamInstByMasterName(cv "tphn28hpcpgv18" "PFILLER20A_G" "layout" "filler_R270_8_2" list(0 610) "R270")
dbCreateParamInstByMasterName(cv "tphn28hpcpgv18" "PFILLER10A_G" "layout" "filler_R270_9_1" list(0 640) "R270")
dbCreateParamInstByMasterName(cv "tphn28hpcpgv18" "PFILLER10A_G" "layout" "filler_R270_9_2" list(0 670) "R270")

; ==================== Digital IO Features (with Inner Pad Support) ====================
dbCreatePath(cv list("M3" "drawing") list(list(709.5 130) list(709.5 690)) 0.2)
dbCreatePath(cv list("M3" "drawing") list(list(710.76 130) list(710.76 690)) 0.2)
dbCreatePath(cv list("M3" "drawing") list(list(130 709.5) list(690 709.5)) 0.2)
dbCreatePath(cv list("M3" "drawing") list(list(130 710.76) list(690 710.76)) 0.2)
dbCreatePath(cv list("M3" "drawing") list(list(690 709.5) list(709.5 709.5)) 0.2 "extendExtend")
dbCreatePath(cv list("M3" "drawing") list(list(709.5 709.5) list(709.5 690)) 0.2 "extendExtend")
dbCreatePath(cv list("M3" "drawing") list(list(690 710.76) list(710.76 710.76)) 0.2 "extendExtend")
dbCreatePath(cv list("M3" "drawing") list(list(710.76 710.76) list(710.76 690)) 0.2 "extendExtend")
dbCreatePath(cv list("M3" "drawing") list(list(327.655 709.88) list(327.655 709.5)) 0.2)
tech = techGetTechFile(cv)
viaParams = list(list("cutRows" 2) list("cutColumns" 4))
viaDefId = techFindViaDefByName(tech "M3_M2")
newVia = dbCreateVia(cv viaDefId list(327.655 709.88) "R180" viaParams)
dbCreatePath(cv list("M3" "drawing") list(list(267.61 709.88) list(267.61 710.76)) 0.2)
tech = techGetTechFile(cv)
viaParams = list(list("cutRows" 2) list("cutColumns" 4))
viaDefId = techFindViaDefByName(tech "M3_M2")
newVia = dbCreateVia(cv viaDefId list(267.61 709.88) "R180" viaParams)
dbCreatePath(cv list("M3" "drawing") list(list(710.76 140.2) list(710.125 140.2)) 0.26)
dbCreatePath(cv list("M3" "drawing") list(list(710.76 131.725) list(710.125 131.725)) 0.26)
dbCreatePath(cv list("M3" "drawing") list(list(709.5 135.9) list(710.125 135.9)) 0.26)
dbCreateLabel(cv list("M4" "pin") list(710.125 144.33) "D0_CORE" "centerRight" "R0" "roman" 2)
dbCreatePath(cv list("M3" "drawing") list(list(710.76 200.2) list(710.125 200.2)) 0.26)
dbCreatePath(cv list("M3" "drawing") list(list(710.76 191.725) list(710.125 191.725)) 0.26)
dbCreatePath(cv list("M3" "drawing") list(list(709.5 195.9) list(710.125 195.9)) 0.26)
dbCreateLabel(cv list("M4" "pin") list(710.125 204.33) "D1_CORE" "centerRight" "R0" "roman" 2)
dbCreatePath(cv list("M3" "drawing") list(list(710.76 260.2) list(710.125 260.2)) 0.26)
dbCreatePath(cv list("M3" "drawing") list(list(710.76 251.725) list(710.125 251.725)) 0.26)
dbCreatePath(cv list("M3" "drawing") list(list(709.5 255.9) list(710.125 255.9)) 0.26)
dbCreateLabel(cv list("M4" "pin") list(710.125 264.33) "D2_CORE" "centerRight" "R0" "roman" 2)
dbCreatePath(cv list("M3" "drawing") list(list(710.76 320.2) list(710.125 320.2)) 0.26)
dbCreatePath(cv list("M3" "drawing") list(list(710.76 311.725) list(710.125 311.725)) 0.26)
dbCreatePath(cv list("M3" "drawing") list(list(709.5 315.9) list(710.125 315.9)) 0.26)
dbCreateLabel(cv list("M4" "pin") list(710.125 324.33) "D3_CORE" "centerRight" "R0" "roman" 2)
dbCreatePath(cv list("M3" "drawing") list(list(710.76 380.2) list(710.125 380.2)) 0.26)
dbCreatePath(cv list("M3" "drawing") list(list(710.76 371.725) list(710.125 371.725)) 0.26)
dbCreatePath(cv list("M3" "drawing") list(list(709.5 375.9) list(710.125 375.9)) 0.26)
dbCreateLabel(cv list("M4" "pin") list(710.125 384.33) "D4_CORE" "centerRight" "R0" "roman" 2)
dbCreatePath(cv list("M3" "drawing") list(list(710.76 440.2) list(710.125 440.2)) 0.26)
dbCreatePath(cv list("M3" "drawing") list(list(710.76 431.725) list(710.125 431.725)) 0.26)
dbCreatePath(cv list("M3" "drawing") list(list(709.5 435.9) list(710.125 435.9)) 0.26)
dbCreateLabel(cv list("M4" "pin") list(710.125 444.33) "D5_CORE" "centerRight" "R0" "roman" 2)
dbCreatePath(cv list("M3" "drawing") list(list(710.76 500.2) list(710.125 500.2)) 0.26)
dbCreatePath(cv list("M3" "drawing") list(list(710.76 491.725) list(710.125 491.725)) 0.26)
dbCreatePath(cv list("M3" "drawing") list(list(709.5 495.9) list(710.125 495.9)) 0.26)
dbCreateLabel(cv list("M4" "pin") list(710.125 504.33) "D6_CORE" "centerRight" "R0" "roman" 2)
dbCreatePath(cv list("M3" "drawing") list(list(710.76 560.2) list(710.125 560.2)) 0.26)
dbCreatePath(cv list("M3" "drawing") list(list(710.76 551.725) list(710.125 551.725)) 0.26)
dbCreatePath(cv list("M3" "drawing") list(list(709.5 555.9) list(710.125 555.9)) 0.26)
dbCreateLabel(cv list("M4" "pin") list(710.125 564.33) "D7_CORE" "centerRight" "R0" "roman" 2)
dbCreatePath(cv list("M3" "drawing") list(list(709.5 620.2) list(710.125 620.2)) 0.26)
dbCreatePath(cv list("M3" "drawing") list(list(710.76 615.9) list(710.125 615.9)) 0.26)
dbCreateLabel(cv list("M4" "pin") list(710.125 611.725) "D8_CORE" "centerRight" "R0" "roman" 2)
dbCreatePath(cv list("M3" "drawing") list(list(709.5 680.2) list(710.125 680.2)) 0.26)
dbCreatePath(cv list("M3" "drawing") list(list(710.76 675.9) list(710.125 675.9)) 0.26)
dbCreateLabel(cv list("M4" "pin") list(710.125 671.725) "D9_CORE" "centerRight" "R0" "roman" 2)
dbCreatePath(cv list("M3" "drawing") list(list(679.8 710.125) list(679.8 709.5)) 0.26)
dbCreatePath(cv list("M3" "drawing") list(list(684.1 710.125) list(684.1 710.76)) 0.26)
dbCreateLabel(cv list("M4" "pin") list(688.275 710.125) "D10_CORE" "centerRight" "R90" "roman" 2)
dbCreatePath(cv list("M3" "drawing") list(list(619.8 710.125) list(619.8 709.5)) 0.26)
dbCreatePath(cv list("M3" "drawing") list(list(624.1 710.125) list(624.1 710.76)) 0.26)
dbCreateLabel(cv list("M4" "pin") list(628.275 710.125) "D11_CORE" "centerRight" "R90" "roman" 2)
dbCreatePath(cv list("M3" "drawing") list(list(559.8 710.125) list(559.8 709.5)) 0.26)
dbCreatePath(cv list("M3" "drawing") list(list(564.1 710.125) list(564.1 710.76)) 0.26)
dbCreateLabel(cv list("M4" "pin") list(568.275 710.125) "D12_CORE" "centerRight" "R90" "roman" 2)
dbCreatePath(cv list("M3" "drawing") list(list(499.8 710.125) list(499.8 709.5)) 0.26)
dbCreatePath(cv list("M3" "drawing") list(list(504.1 710.125) list(504.1 710.76)) 0.26)
dbCreateLabel(cv list("M4" "pin") list(508.275 710.125) "D13_CORE" "centerRight" "R90" "roman" 2)
dbCreatePath(cv list("M3" "drawing") list(list(439.8 710.125) list(439.8 709.5)) 0.26)
dbCreatePath(cv list("M3" "drawing") list(list(444.1 710.125) list(444.1 710.76)) 0.26)
dbCreateLabel(cv list("M4" "pin") list(448.275 710.125) "D14_CORE" "centerRight" "R90" "roman" 2)
dbCreatePath(cv list("M3" "drawing") list(list(379.8 710.125) list(379.8 709.5)) 0.26)
dbCreatePath(cv list("M3" "drawing") list(list(384.1 710.125) list(384.1 710.76)) 0.26)
dbCreateLabel(cv list("M4" "pin") list(388.275 710.125) "D15_CORE" "centerRight" "R90" "roman" 2)

; ==================== Pin Labels (with Inner Pad Support) ====================
dbCreateLabel(cv list("AP" "pin") list(-11 680) "VINP" "centerRight" "R0" "roman" 10)
dbCreateLabel(cv list("AP" "pin") list(-11 620) "VINN" "centerRight" "R0" "roman" 10)
dbCreateLabel(cv list("AP" "pin") list(-11 560) "VIP" "centerRight" "R0" "roman" 10)
dbCreateLabel(cv list("AP" "pin") list(-11 500) "VIM" "centerRight" "R0" "roman" 10)
dbCreateLabel(cv list("AP" "pin") list(-11 440) "VCM" "centerRight" "R0" "roman" 10)
dbCreateLabel(cv list("AP" "pin") list(-11 380) "VREF" "centerRight" "R0" "roman" 10)
dbCreateLabel(cv list("AP" "pin") list(-11 320) "AVDD" "centerRight" "R0" "roman" 10)
dbCreateLabel(cv list("M2" "pin") list(109.9 320) "AVDD_CORE" "centerLeft" "R0" "roman" 2)
dbCreateLabel(cv list("AP" "pin") list(-11 260) "AVSS" "centerRight" "R0" "roman" 10)
dbCreateLabel(cv list("M2" "pin") list(109.9 260) "AVSS_CORE" "centerLeft" "R0" "roman" 2)
dbCreateLabel(cv list("AP" "pin") list(-11 200) "CLKP" "centerRight" "R0" "roman" 10)
dbCreateLabel(cv list("AP" "pin") list(-11 140) "CLKN" "centerRight" "R0" "roman" 10)
dbCreateLabel(cv list("AP" "pin") list(140 -11) "VDD_CKB" "centerRight" "R90" "roman" 10)
dbCreateLabel(cv list("M2" "pin") list(140 109.9) "VDD_CKB_CORE" "centerLeft" "R90" "roman" 2)
dbCreateLabel(cv list("AP" "pin") list(200 -11) "VSS_CKB" "centerRight" "R90" "roman" 10)
dbCreateLabel(cv list("M2" "pin") list(200 109.9) "VSS_CKB_CORE" "centerLeft" "R90" "roman" 2)
dbCreateLabel(cv list("AP" "pin") list(260 -11) "VDD_DAT" "centerRight" "R90" "roman" 10)
dbCreateLabel(cv list("M2" "pin") list(260 109.9) "VDD_DAT_CORE" "centerLeft" "R90" "roman" 2)
dbCreateLabel(cv list("AP" "pin") list(320 -11) "VSS_DAT" "centerRight" "R90" "roman" 10)
dbCreateLabel(cv list("M2" "pin") list(320 109.9) "VSS_DAT_CORE" "centerLeft" "R90" "roman" 2)
dbCreateLabel(cv list("AP" "pin") list(380 -11) "VREFH" "centerRight" "R90" "roman" 10)
dbCreateLabel(cv list("M2" "pin") list(380 109.9) "VREFH_CORE" "centerLeft" "R90" "roman" 2)
dbCreateLabel(cv list("AP" "pin") list(440 -11) "VREFN" "centerRight" "R90" "roman" 10)
dbCreateLabel(cv list("M2" "pin") list(440 109.9) "VREFN_CORE" "centerLeft" "R90" "roman" 2)
dbCreateLabel(cv list("AP" "pin") list(500 -11) "VDD_ADC" "centerRight" "R90" "roman" 10)
dbCreateLabel(cv list("M2" "pin") list(500 109.9) "VDD_ADC_CORE" "centerLeft" "R90" "roman" 2)
dbCreateLabel(cv list("AP" "pin") list(560 -11) "VSS_ADC" "centerRight" "R90" "roman" 10)
dbCreateLabel(cv list("M2" "pin") list(560 109.9) "VSS_ADC_CORE" "centerLeft" "R90" "roman" 2)
dbCreateLabel(cv list("AP" "pin") list(620 -11) "VDD_DAC" "centerRight" "R90" "roman" 10)
dbCreateLabel(cv list("M2" "pin") list(620 109.9) "VDD_DAC_CORE" "centerLeft" "R90" "roman" 2)
dbCreateLabel(cv list("AP" "pin") list(680 -11) "VSS_DAC" "centerRight" "R90" "roman" 10)
dbCreateLabel(cv list("M2" "pin") list(680 109.9) "VSS_DAC_CORE" "centerLeft" "R90" "roman" 2)
dbCreateLabel(cv list("AP" "pin") list(831 140) "D0" "centerLeft" "R0" "roman" 10)
dbCreateLabel(cv list("AP" "pin") list(831 200) "D1" "centerLeft" "R0" "roman" 10)
dbCreateLabel(cv list("AP" "pin") list(831 260) "D2" "centerLeft" "R0" "roman" 10)
dbCreateLabel(cv list("AP" "pin") list(831 320) "D3" "centerLeft" "R0" "roman" 10)
dbCreateLabel(cv list("AP" "pin") list(831 380) "D4" "centerLeft" "R0" "roman" 10)
dbCreateLabel(cv list("AP" "pin") list(831 440) "D5" "centerLeft" "R0" "roman" 10)
dbCreateLabel(cv list("AP" "pin") list(831 500) "D6" "centerLeft" "R0" "roman" 10)
dbCreateLabel(cv list("AP" "pin") list(831 560) "D7" "centerLeft" "R0" "roman" 10)
dbCreateLabel(cv list("AP" "pin") list(831 620) "D8" "centerLeft" "R0" "roman" 10)
dbCreateLabel(cv list("AP" "pin") list(831 680) "D9" "centerLeft" "R0" "roman" 10)
dbCreateLabel(cv list("AP" "pin") list(680 831) "D10" "centerLeft" "R90" "roman" 10)
dbCreateLabel(cv list("AP" "pin") list(620 831) "D11" "centerLeft" "R90" "roman" 10)
dbCreateLabel(cv list("AP" "pin") list(560 831) "D12" "centerLeft" "R90" "roman" 10)
dbCreateLabel(cv list("AP" "pin") list(500 831) "D13" "centerLeft" "R90" "roman" 10)
dbCreateLabel(cv list("AP" "pin") list(440 831) "D14" "centerLeft" "R90" "roman" 10)
dbCreateLabel(cv list("AP" "pin") list(380 831) "D15" "centerLeft" "R90" "roman" 10)
dbCreateLabel(cv list("AP" "pin") list(320 831) "VIOL" "centerLeft" "R90" "roman" 10)
dbCreateLabel(cv list("AP" "pin") list(260 831) "GIOL" "centerLeft" "R90" "roman" 10)
dbCreateLabel(cv list("AP" "pin") list(200 831) "VIOH" "centerLeft" "R90" "roman" 10)
dbCreateLabel(cv list("AP" "pin") list(140 831) "GIOH" "centerLeft" "R90" "roman" 10)
dbCreateLabel(cv list("AP" "pin") list(152 350) "VREF_CORE" "centerLeft" "R0" "roman" 10)
dbCreateLabel(cv list("M2" "pin") list(109.9 350) "VREF_CORE_CORE" "centerLeft" "R0" "roman" 2)
dbCreateLabel(cv list("AP" "pin") list(152 650) "VAMP_CORE" "centerLeft" "R0" "roman" 10)
dbCreateLabel(cv list("M2" "pin") list(109.9 650) "VAMP_CORE_CORE" "centerLeft" "R0" "roman" 2)
dbCreateLabel(cv list("AP" "pin") list(152 530) "IBIAS_CORE" "centerLeft" "R0" "roman" 10)
dbCreateLabel(cv list("M2" "pin") list(109.9 530) "IBIAS_CORE_CORE" "centerLeft" "R0" "roman" 2)
dbCreateLabel(cv list("AP" "pin") list(530 152) "ADC_CORE" "centerLeft" "R90" "roman" 10)
dbCreateLabel(cv list("M2" "pin") list(530 109.9) "ADC_CORE_CORE" "centerLeft" "R90" "roman" 2)

dbSave(cv)
t
