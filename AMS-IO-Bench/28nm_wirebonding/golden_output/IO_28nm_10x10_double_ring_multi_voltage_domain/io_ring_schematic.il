pdb3ac_h_gMaster = dbOpenCellView("tphn28hpcpgv18" "PDB3AC_H_G" "symbol")
dbCreateInst(cv pdb3ac_h_gMaster "VINP_left0" '(0 20.8125) "R270")
schCreateWire(cv "route" "full" '((0.000 21.000) (-0.750 21.000)) 0 0 0 nil nil)
schCreateWireLabel(cv nil '(-0.250 21.000) "VINP" "lowerRight" "R0" "stick" 0.0625 nil)
schCreatePin(cv nil "VINP" "inputOutput" nil '(-0.750 21.000) "R0")
schCreateWire(cv "route" "full" '((0.875 21.062) (1.625 21.062)) 0 0 0 nil nil)
schCreateWireLabel(cv nil '(1.125 21.062) "AVSS" "lowerLeft" "R0" "stick" 0.0625 nil)
schCreateWire(cv "route" "full" '((0.875 20.688) (1.625 20.688)) 0 0 0 nil nil)
schCreateWireLabel(cv nil '(1.125 20.688) "GIOL" "lowerLeft" "R0" "stick" 0.0625 nil)
schCreateWire(cv "route" "full" '((0.875 21.438) (1.625 21.438)) 0 0 0 nil nil)
schCreateWireLabel(cv nil '(1.125 21.438) "AVDD" "lowerLeft" "R0" "stick" 0.0625 nil)
dbCreateInst(cv pdb3ac_h_gMaster "VINN_left1" '(0 18.8125) "R270")
schCreateWire(cv "route" "full" '((0.000 19.000) (-0.750 19.000)) 0 0 0 nil nil)
schCreateWireLabel(cv nil '(-0.250 19.000) "VINN" "lowerRight" "R0" "stick" 0.0625 nil)
schCreatePin(cv nil "VINN" "inputOutput" nil '(-0.750 19.000) "R0")
schCreateWire(cv "route" "full" '((0.875 19.062) (1.625 19.062)) 0 0 0 nil nil)
schCreateWireLabel(cv nil '(1.125 19.062) "AVSS" "lowerLeft" "R0" "stick" 0.0625 nil)
schCreateWire(cv "route" "full" '((0.875 18.688) (1.625 18.688)) 0 0 0 nil nil)
schCreateWireLabel(cv nil '(1.125 18.688) "GIOL" "lowerLeft" "R0" "stick" 0.0625 nil)
schCreateWire(cv "route" "full" '((0.875 19.438) (1.625 19.438)) 0 0 0 nil nil)
schCreateWireLabel(cv nil '(1.125 19.438) "AVDD" "lowerLeft" "R0" "stick" 0.0625 nil)
dbCreateInst(cv pdb3ac_h_gMaster "VIP_left2" '(0 16.8125) "R270")
schCreateWire(cv "route" "full" '((0.000 17.000) (-0.750 17.000)) 0 0 0 nil nil)
schCreateWireLabel(cv nil '(-0.250 17.000) "VIP" "lowerRight" "R0" "stick" 0.0625 nil)
schCreatePin(cv nil "VIP" "inputOutput" nil '(-0.750 17.000) "R0")
schCreateWire(cv "route" "full" '((0.875 17.062) (1.625 17.062)) 0 0 0 nil nil)
schCreateWireLabel(cv nil '(1.125 17.062) "AVSS" "lowerLeft" "R0" "stick" 0.0625 nil)
schCreateWire(cv "route" "full" '((0.875 16.688) (1.625 16.688)) 0 0 0 nil nil)
schCreateWireLabel(cv nil '(1.125 16.688) "GIOL" "lowerLeft" "R0" "stick" 0.0625 nil)
schCreateWire(cv "route" "full" '((0.875 17.438) (1.625 17.438)) 0 0 0 nil nil)
schCreateWireLabel(cv nil '(1.125 17.438) "AVDD" "lowerLeft" "R0" "stick" 0.0625 nil)
dbCreateInst(cv pdb3ac_h_gMaster "VIM_left3" '(0 14.8125) "R270")
schCreateWire(cv "route" "full" '((0.000 15.001) (-0.750 15.001)) 0 0 0 nil nil)
schCreateWireLabel(cv nil '(-0.250 15.001) "VIM" "lowerRight" "R0" "stick" 0.0625 nil)
schCreatePin(cv nil "VIM" "inputOutput" nil '(-0.750 15.001) "R0")
schCreateWire(cv "route" "full" '((0.875 15.062) (1.625 15.062)) 0 0 0 nil nil)
schCreateWireLabel(cv nil '(1.125 15.062) "AVSS" "lowerLeft" "R0" "stick" 0.0625 nil)
schCreateWire(cv "route" "full" '((0.875 14.688) (1.625 14.688)) 0 0 0 nil nil)
schCreateWireLabel(cv nil '(1.125 14.688) "GIOL" "lowerLeft" "R0" "stick" 0.0625 nil)
schCreateWire(cv "route" "full" '((0.875 15.438) (1.625 15.438)) 0 0 0 nil nil)
schCreateWireLabel(cv nil '(1.125 15.438) "AVDD" "lowerLeft" "R0" "stick" 0.0625 nil)
dbCreateInst(cv pdb3ac_h_gMaster "VCM_left4" '(0 12.8125) "R270")
schCreateWire(cv "route" "full" '((0.000 13.001) (-0.750 13.001)) 0 0 0 nil nil)
schCreateWireLabel(cv nil '(-0.250 13.001) "VCM" "lowerRight" "R0" "stick" 0.0625 nil)
schCreatePin(cv nil "VCM" "inputOutput" nil '(-0.750 13.001) "R0")
schCreateWire(cv "route" "full" '((0.875 13.062) (1.625 13.062)) 0 0 0 nil nil)
schCreateWireLabel(cv nil '(1.125 13.062) "AVSS" "lowerLeft" "R0" "stick" 0.0625 nil)
schCreateWire(cv "route" "full" '((0.875 12.688) (1.625 12.688)) 0 0 0 nil nil)
schCreateWireLabel(cv nil '(1.125 12.688) "GIOL" "lowerLeft" "R0" "stick" 0.0625 nil)
schCreateWire(cv "route" "full" '((0.875 13.438) (1.625 13.438)) 0 0 0 nil nil)
schCreateWireLabel(cv nil '(1.125 13.438) "AVDD" "lowerLeft" "R0" "stick" 0.0625 nil)
dbCreateInst(cv pdb3ac_h_gMaster "VREF_left5" '(0 10.8125) "R270")
schCreateWire(cv "route" "full" '((0.000 11.001) (-0.750 11.001)) 0 0 0 nil nil)
schCreateWireLabel(cv nil '(-0.250 11.001) "VREF" "lowerRight" "R0" "stick" 0.0625 nil)
schCreatePin(cv nil "VREF" "inputOutput" nil '(-0.750 11.001) "R0")
schCreateWire(cv "route" "full" '((0.875 11.062) (1.625 11.062)) 0 0 0 nil nil)
schCreateWireLabel(cv nil '(1.125 11.062) "AVSS" "lowerLeft" "R0" "stick" 0.0625 nil)
schCreateWire(cv "route" "full" '((0.875 10.688) (1.625 10.688)) 0 0 0 nil nil)
schCreateWireLabel(cv nil '(1.125 10.688) "GIOL" "lowerLeft" "R0" "stick" 0.0625 nil)
schCreateWire(cv "route" "full" '((0.875 11.438) (1.625 11.438)) 0 0 0 nil nil)
schCreateWireLabel(cv nil '(1.125 11.438) "AVDD" "lowerLeft" "R0" "stick" 0.0625 nil)
pvdd3ac_h_gMaster = dbOpenCellView("tphn28hpcpgv18" "PVDD3AC_H_G" "symbol")
dbCreateInst(cv pvdd3ac_h_gMaster "AVDD_left6" '(0 8.8125) "R270")
schCreateWire(cv "route" "full" '((0.875 9.438) (1.625 9.438)) 0 0 0 nil nil)
schCreateWireLabel(cv nil '(1.125 9.438) "AVDD_CORE" "lowerLeft" "R0" "stick" 0.0625 nil)
schCreatePin(cv nil "AVDD_CORE" "inputOutput" nil '(1.625 9.438) "R180")
schCreateWire(cv "route" "full" '((0.875 9.062) (1.625 9.062)) 0 0 0 nil nil)
schCreateWireLabel(cv nil '(1.125 9.062) "AVSS" "lowerLeft" "R0" "stick" 0.0625 nil)
schCreateWire(cv "route" "full" '((0.875 8.688) (1.625 8.688)) 0 0 0 nil nil)
schCreateWireLabel(cv nil '(1.125 8.688) "GIOL" "lowerLeft" "R0" "stick" 0.0625 nil)
schCreateWire(cv "route" "full" '((0.000 9.001) (-0.750 9.001)) 0 0 0 nil nil)
schCreateWireLabel(cv nil '(-0.250 9.001) "AVDD" "lowerRight" "R0" "stick" 0.0625 nil)
schCreatePin(cv nil "AVDD" "inputOutput" nil '(-0.750 9.001) "R0")
pvss3ac_h_gMaster = dbOpenCellView("tphn28hpcpgv18" "PVSS3AC_H_G" "symbol")
dbCreateInst(cv pvss3ac_h_gMaster "AVSS_left7" '(0 6.8125) "R270")
schCreateWire(cv "route" "full" '((0.000 7.000) (-0.750 7.000)) 0 0 0 nil nil)
schCreateWireLabel(cv nil '(-0.250 7.000) "AVSS" "lowerRight" "R0" "stick" 0.0625 nil)
schCreatePin(cv nil "AVSS" "inputOutput" nil '(-0.750 7.000) "R0")
schCreateWire(cv "route" "full" '((0.875 6.688) (1.625 6.688)) 0 0 0 nil nil)
schCreateWireLabel(cv nil '(1.125 6.688) "GIOL" "lowerLeft" "R0" "stick" 0.0625 nil)
schCreateWire(cv "route" "full" '((0.875 7.438) (1.625 7.438)) 0 0 0 nil nil)
schCreateWireLabel(cv nil '(1.125 7.438) "AVSS_CORE" "lowerLeft" "R0" "stick" 0.0625 nil)
schCreatePin(cv nil "AVSS_CORE" "inputOutput" nil '(1.625 7.438) "R180")
schCreateWire(cv "route" "full" '((0.875 7.062) (1.625 7.062)) 0 0 0 nil nil)
schCreateWireLabel(cv nil '(1.125 7.062) "AVDD" "lowerLeft" "R0" "stick" 0.0625 nil)
dbCreateInst(cv pdb3ac_h_gMaster "CLKP_left8" '(0 4.8125) "R270")
schCreateWire(cv "route" "full" '((0.000 5.000) (-0.750 5.000)) 0 0 0 nil nil)
schCreateWireLabel(cv nil '(-0.250 5.000) "CLKP" "lowerRight" "R0" "stick" 0.0625 nil)
schCreatePin(cv nil "CLKP" "inputOutput" nil '(-0.750 5.000) "R0")
schCreateWire(cv "route" "full" '((0.875 5.062) (1.625 5.062)) 0 0 0 nil nil)
schCreateWireLabel(cv nil '(1.125 5.062) "VSS_CKB" "lowerLeft" "R0" "stick" 0.0625 nil)
schCreateWire(cv "route" "full" '((0.875 4.688) (1.625 4.688)) 0 0 0 nil nil)
schCreateWireLabel(cv nil '(1.125 4.688) "GIOL" "lowerLeft" "R0" "stick" 0.0625 nil)
schCreateWire(cv "route" "full" '((0.875 5.438) (1.625 5.438)) 0 0 0 nil nil)
schCreateWireLabel(cv nil '(1.125 5.438) "VDD_CKB" "lowerLeft" "R0" "stick" 0.0625 nil)
dbCreateInst(cv pdb3ac_h_gMaster "CLKN_left9" '(0 2.8125) "R270")
schCreateWire(cv "route" "full" '((0.000 3.001) (-0.750 3.001)) 0 0 0 nil nil)
schCreateWireLabel(cv nil '(-0.250 3.001) "CLKN" "lowerRight" "R0" "stick" 0.0625 nil)
schCreatePin(cv nil "CLKN" "inputOutput" nil '(-0.750 3.001) "R0")
schCreateWire(cv "route" "full" '((0.875 3.062) (1.625 3.062)) 0 0 0 nil nil)
schCreateWireLabel(cv nil '(1.125 3.062) "VSS_CKB" "lowerLeft" "R0" "stick" 0.0625 nil)
schCreateWire(cv "route" "full" '((0.875 2.688) (1.625 2.688)) 0 0 0 nil nil)
schCreateWireLabel(cv nil '(1.125 2.688) "GIOL" "lowerLeft" "R0" "stick" 0.0625 nil)
schCreateWire(cv "route" "full" '((0.875 3.438) (1.625 3.438)) 0 0 0 nil nil)
schCreateWireLabel(cv nil '(1.125 3.438) "VDD_CKB" "lowerLeft" "R0" "stick" 0.0625 nil)
pvdd3ac_v_gMaster = dbOpenCellView("tphn28hpcpgv18" "PVDD3AC_V_G" "symbol")
dbCreateInst(cv pvdd3ac_v_gMaster "VDD_CKB_bottom0" '(3.1875 0) "R0")
schCreateWire(cv "route" "full" '((2.562 0.875) (2.562 1.625)) 0 0 0 nil nil)
schCreateWireLabel(cv nil '(2.562 1.125) "VDD_CKB_CORE" "lowerLeft" "R90" "stick" 0.0625 nil)
schCreatePin(cv nil "VDD_CKB_CORE" "inputOutput" nil '(2.562 1.625) "R270")
schCreateWire(cv "route" "full" '((2.938 0.875) (2.938 1.625)) 0 0 0 nil nil)
schCreateWireLabel(cv nil '(2.938 1.125) "VSS_CKB" "lowerLeft" "R90" "stick" 0.0625 nil)
schCreateWire(cv "route" "full" '((3.312 0.875) (3.312 1.625)) 0 0 0 nil nil)
schCreateWireLabel(cv nil '(3.312 1.125) "GIOL" "lowerLeft" "R90" "stick" 0.0625 nil)
schCreateWire(cv "route" "full" '((2.999 0.000) (2.999 -0.750)) 0 0 0 nil nil)
schCreateWireLabel(cv nil '(2.999 -0.250) "VDD_CKB" "lowerRight" "R90" "stick" 0.0625 nil)
schCreatePin(cv nil "VDD_CKB" "inputOutput" nil '(2.999 -0.750) "R90")
pvss3ac_v_gMaster = dbOpenCellView("tphn28hpcpgv18" "PVSS3AC_V_G" "symbol")
dbCreateInst(cv pvss3ac_v_gMaster "VSS_CKB_bottom1" '(5.1875 0) "R0")
schCreateWire(cv "route" "full" '((5.000 0.000) (5.000 -0.750)) 0 0 0 nil nil)
schCreateWireLabel(cv nil '(5.000 -0.250) "VSS_CKB" "lowerRight" "R90" "stick" 0.0625 nil)
schCreatePin(cv nil "VSS_CKB" "inputOutput" nil '(5.000 -0.750) "R90")
schCreateWire(cv "route" "full" '((5.312 0.875) (5.312 1.625)) 0 0 0 nil nil)
schCreateWireLabel(cv nil '(5.312 1.125) "GIOL" "lowerLeft" "R90" "stick" 0.0625 nil)
schCreateWire(cv "route" "full" '((4.562 0.875) (4.562 1.625)) 0 0 0 nil nil)
schCreateWireLabel(cv nil '(4.562 1.125) "VSS_CKB_CORE" "lowerLeft" "R90" "stick" 0.0625 nil)
schCreatePin(cv nil "VSS_CKB_CORE" "inputOutput" nil '(4.562 1.625) "R270")
schCreateWire(cv "route" "full" '((4.938 0.875) (4.938 1.625)) 0 0 0 nil nil)
schCreateWireLabel(cv nil '(4.938 1.125) "VDD_CKB" "lowerLeft" "R90" "stick" 0.0625 nil)
dbCreateInst(cv pvdd3ac_v_gMaster "VDD_DAT_bottom2" '(7.1875 0) "R0")
schCreateWire(cv "route" "full" '((6.562 0.875) (6.562 1.625)) 0 0 0 nil nil)
schCreateWireLabel(cv nil '(6.562 1.125) "VDD_DAT_CORE" "lowerLeft" "R90" "stick" 0.0625 nil)
schCreatePin(cv nil "VDD_DAT_CORE" "inputOutput" nil '(6.562 1.625) "R270")
schCreateWire(cv "route" "full" '((6.938 0.875) (6.938 1.625)) 0 0 0 nil nil)
schCreateWireLabel(cv nil '(6.938 1.125) "VSS_DAT" "lowerLeft" "R90" "stick" 0.0625 nil)
schCreateWire(cv "route" "full" '((7.312 0.875) (7.312 1.625)) 0 0 0 nil nil)
schCreateWireLabel(cv nil '(7.312 1.125) "GIOL" "lowerLeft" "R90" "stick" 0.0625 nil)
schCreateWire(cv "route" "full" '((7.000 0.000) (7.000 -0.750)) 0 0 0 nil nil)
schCreateWireLabel(cv nil '(7.000 -0.250) "VDD_DAT" "lowerRight" "R90" "stick" 0.0625 nil)
schCreatePin(cv nil "VDD_DAT" "inputOutput" nil '(7.000 -0.750) "R90")
dbCreateInst(cv pvss3ac_v_gMaster "VSS_DAT_bottom3" '(9.1875 0) "R0")
schCreateWire(cv "route" "full" '((8.999 0.000) (8.999 -0.750)) 0 0 0 nil nil)
schCreateWireLabel(cv nil '(8.999 -0.250) "VSS_DAT" "lowerRight" "R90" "stick" 0.0625 nil)
schCreatePin(cv nil "VSS_DAT" "inputOutput" nil '(8.999 -0.750) "R90")
schCreateWire(cv "route" "full" '((9.312 0.875) (9.312 1.625)) 0 0 0 nil nil)
schCreateWireLabel(cv nil '(9.312 1.125) "GIOL" "lowerLeft" "R90" "stick" 0.0625 nil)
schCreateWire(cv "route" "full" '((8.562 0.875) (8.562 1.625)) 0 0 0 nil nil)
schCreateWireLabel(cv nil '(8.562 1.125) "VSS_DAT_CORE" "lowerLeft" "R90" "stick" 0.0625 nil)
schCreatePin(cv nil "VSS_DAT_CORE" "inputOutput" nil '(8.562 1.625) "R270")
schCreateWire(cv "route" "full" '((8.938 0.875) (8.938 1.625)) 0 0 0 nil nil)
schCreateWireLabel(cv nil '(8.938 1.125) "VDD_DAT" "lowerLeft" "R90" "stick" 0.0625 nil)
dbCreateInst(cv pvdd3ac_v_gMaster "VREFH_bottom4" '(11.1875 0) "R0")
schCreateWire(cv "route" "full" '((10.562 0.875) (10.562 1.625)) 0 0 0 nil nil)
schCreateWireLabel(cv nil '(10.562 1.125) "VREFH_CORE" "lowerLeft" "R90" "stick" 0.0625 nil)
schCreatePin(cv nil "VREFH_CORE" "inputOutput" nil '(10.562 1.625) "R270")
schCreateWire(cv "route" "full" '((10.938 0.875) (10.938 1.625)) 0 0 0 nil nil)
schCreateWireLabel(cv nil '(10.938 1.125) "VREFN" "lowerLeft" "R90" "stick" 0.0625 nil)
schCreateWire(cv "route" "full" '((11.312 0.875) (11.312 1.625)) 0 0 0 nil nil)
schCreateWireLabel(cv nil '(11.312 1.125) "GIOL" "lowerLeft" "R90" "stick" 0.0625 nil)
schCreateWire(cv "route" "full" '((10.999 0.000) (10.999 -0.750)) 0 0 0 nil nil)
schCreateWireLabel(cv nil '(10.999 -0.250) "VREFH" "lowerRight" "R90" "stick" 0.0625 nil)
schCreatePin(cv nil "VREFH" "inputOutput" nil '(10.999 -0.750) "R90")
dbCreateInst(cv pvss3ac_v_gMaster "VREFN_bottom5" '(13.1875 0) "R0")
schCreateWire(cv "route" "full" '((12.999 0.000) (12.999 -0.750)) 0 0 0 nil nil)
schCreateWireLabel(cv nil '(12.999 -0.250) "VREFN" "lowerRight" "R90" "stick" 0.0625 nil)
schCreatePin(cv nil "VREFN" "inputOutput" nil '(12.999 -0.750) "R90")
schCreateWire(cv "route" "full" '((13.312 0.875) (13.312 1.625)) 0 0 0 nil nil)
schCreateWireLabel(cv nil '(13.312 1.125) "GIOL" "lowerLeft" "R90" "stick" 0.0625 nil)
schCreateWire(cv "route" "full" '((12.562 0.875) (12.562 1.625)) 0 0 0 nil nil)
schCreateWireLabel(cv nil '(12.562 1.125) "VREFN_CORE" "lowerLeft" "R90" "stick" 0.0625 nil)
schCreatePin(cv nil "VREFN_CORE" "inputOutput" nil '(12.562 1.625) "R270")
schCreateWire(cv "route" "full" '((12.938 0.875) (12.938 1.625)) 0 0 0 nil nil)
schCreateWireLabel(cv nil '(12.938 1.125) "VREFH" "lowerLeft" "R90" "stick" 0.0625 nil)
dbCreateInst(cv pvdd3ac_v_gMaster "VDD_ADC_bottom6" '(15.1875 0) "R0")
schCreateWire(cv "route" "full" '((14.562 0.875) (14.562 1.625)) 0 0 0 nil nil)
schCreateWireLabel(cv nil '(14.562 1.125) "VDD_ADC_CORE" "lowerLeft" "R90" "stick" 0.0625 nil)
schCreatePin(cv nil "VDD_ADC_CORE" "inputOutput" nil '(14.562 1.625) "R270")
schCreateWire(cv "route" "full" '((14.938 0.875) (14.938 1.625)) 0 0 0 nil nil)
schCreateWireLabel(cv nil '(14.938 1.125) "VSS_ADC" "lowerLeft" "R90" "stick" 0.0625 nil)
schCreateWire(cv "route" "full" '((15.312 0.875) (15.312 1.625)) 0 0 0 nil nil)
schCreateWireLabel(cv nil '(15.312 1.125) "GIOL" "lowerLeft" "R90" "stick" 0.0625 nil)
schCreateWire(cv "route" "full" '((14.999 0.000) (14.999 -0.750)) 0 0 0 nil nil)
schCreateWireLabel(cv nil '(14.999 -0.250) "VDD_ADC" "lowerRight" "R90" "stick" 0.0625 nil)
schCreatePin(cv nil "VDD_ADC" "inputOutput" nil '(14.999 -0.750) "R90")
dbCreateInst(cv pvss3ac_v_gMaster "VSS_ADC_bottom7" '(17.1875 0) "R0")
schCreateWire(cv "route" "full" '((17.000 0.000) (17.000 -0.750)) 0 0 0 nil nil)
schCreateWireLabel(cv nil '(17.000 -0.250) "VSS_ADC" "lowerRight" "R90" "stick" 0.0625 nil)
schCreatePin(cv nil "VSS_ADC" "inputOutput" nil '(17.000 -0.750) "R90")
schCreateWire(cv "route" "full" '((17.312 0.875) (17.312 1.625)) 0 0 0 nil nil)
schCreateWireLabel(cv nil '(17.312 1.125) "GIOL" "lowerLeft" "R90" "stick" 0.0625 nil)
schCreateWire(cv "route" "full" '((16.562 0.875) (16.562 1.625)) 0 0 0 nil nil)
schCreateWireLabel(cv nil '(16.562 1.125) "VSS_ADC_CORE" "lowerLeft" "R90" "stick" 0.0625 nil)
schCreatePin(cv nil "VSS_ADC_CORE" "inputOutput" nil '(16.562 1.625) "R270")
schCreateWire(cv "route" "full" '((16.938 0.875) (16.938 1.625)) 0 0 0 nil nil)
schCreateWireLabel(cv nil '(16.938 1.125) "VDD_ADC" "lowerLeft" "R90" "stick" 0.0625 nil)
dbCreateInst(cv pvdd3ac_v_gMaster "VDD_DAC_bottom8" '(19.1875 0) "R0")
schCreateWire(cv "route" "full" '((18.562 0.875) (18.562 1.625)) 0 0 0 nil nil)
schCreateWireLabel(cv nil '(18.562 1.125) "VDD_DAC_CORE" "lowerLeft" "R90" "stick" 0.0625 nil)
schCreatePin(cv nil "VDD_DAC_CORE" "inputOutput" nil '(18.562 1.625) "R270")
schCreateWire(cv "route" "full" '((18.938 0.875) (18.938 1.625)) 0 0 0 nil nil)
schCreateWireLabel(cv nil '(18.938 1.125) "VSS_DAC" "lowerLeft" "R90" "stick" 0.0625 nil)
schCreateWire(cv "route" "full" '((19.312 0.875) (19.312 1.625)) 0 0 0 nil nil)
schCreateWireLabel(cv nil '(19.312 1.125) "GIOL" "lowerLeft" "R90" "stick" 0.0625 nil)
schCreateWire(cv "route" "full" '((19.000 0.000) (19.000 -0.750)) 0 0 0 nil nil)
schCreateWireLabel(cv nil '(19.000 -0.250) "VDD_DAC" "lowerRight" "R90" "stick" 0.0625 nil)
schCreatePin(cv nil "VDD_DAC" "inputOutput" nil '(19.000 -0.750) "R90")
dbCreateInst(cv pvss3ac_v_gMaster "VSS_DAC_bottom9" '(21.1875 0) "R0")
schCreateWire(cv "route" "full" '((21.000 0.000) (21.000 -0.750)) 0 0 0 nil nil)
schCreateWireLabel(cv nil '(21.000 -0.250) "VSS_DAC" "lowerRight" "R90" "stick" 0.0625 nil)
schCreatePin(cv nil "VSS_DAC" "inputOutput" nil '(21.000 -0.750) "R90")
schCreateWire(cv "route" "full" '((21.312 0.875) (21.312 1.625)) 0 0 0 nil nil)
schCreateWireLabel(cv nil '(21.312 1.125) "GIOL" "lowerLeft" "R90" "stick" 0.0625 nil)
schCreateWire(cv "route" "full" '((20.562 0.875) (20.562 1.625)) 0 0 0 nil nil)
schCreateWireLabel(cv nil '(20.562 1.125) "VSS_DAC_CORE" "lowerLeft" "R90" "stick" 0.0625 nil)
schCreatePin(cv nil "VSS_DAC_CORE" "inputOutput" nil '(20.562 1.625) "R270")
schCreateWire(cv "route" "full" '((20.938 0.875) (20.938 1.625)) 0 0 0 nil nil)
schCreateWireLabel(cv nil '(20.938 1.125) "VDD_DAC" "lowerLeft" "R90" "stick" 0.0625 nil)
pddw16sdgz_h_gMaster = dbOpenCellView("tphn28hpcpgv18" "PDDW16SDGZ_H_G" "symbol")
dbCreateInst(cv pddw16sdgz_h_gMaster "D0_right0" '(24.0 2.3125) "R90")
schCreateWire(cv "route" "full" '((23.000 2.438) (22.250 2.438)) 0 0 0 nil nil)
schCreateWireLabel(cv nil '(22.750 2.438) "GIOL" "lowerRight" "R0" "stick" 0.0625 nil)
schCreateWire(cv "route" "full" '((23.000 2.562) (22.250 2.562)) 0 0 0 nil nil)
schCreateWireLabel(cv nil '(22.750 2.562) "D0_CORE" "lowerRight" "R0" "stick" 0.0625 nil)
schCreatePin(cv nil "D0_CORE" "inputOutput" nil '(22.250 2.562) "R0")
schCreateWire(cv "route" "full" '((23.000 2.188) (22.250 2.188)) 0 0 0 nil nil)
schCreateWireLabel(cv nil '(22.750 2.188) "VIOL" "lowerRight" "R0" "stick" 0.0625 nil)
schCreateWire(cv "route" "full" '((23.000 2.062) (22.250 2.062)) 0 0 0 nil nil)
schCreateWireLabel(cv nil '(22.750 2.062) "GIOL" "lowerRight" "R0" "stick" 0.0625 nil)
schCreateWire(cv "route" "full" '((24.000 3.000) (24.750 3.000)) 0 0 0 nil nil)
schCreateWireLabel(cv nil '(24.250 3.000) "D0" "lowerLeft" "R0" "stick" 0.0625 nil)
schCreatePin(cv nil "D0" "inputOutput" nil '(24.750 3.000) "R180")
schCreateWire(cv "route" "full" '((23.000 2.688) (22.250 2.688)) 0 0 0 nil nil)
schCreateWireLabel(cv nil '(22.750 2.688) "POC" "lowerRight" "R0" "stick" 0.0625 nil)
schCreateWire(cv "route" "full" '((23.000 2.875) (22.250 2.875)) 0 0 0 nil nil)
schCreateWireLabel(cv nil '(22.750 2.875) "VIOL" "lowerRight" "R0" "stick" 0.0625 nil)
schCreateWire(cv "route" "full" '((23.000 3.062) (22.250 3.062)) 0 0 0 nil nil)
schCreateWireLabel(cv nil '(22.750 3.062) "GIOL" "lowerRight" "R0" "stick" 0.0625 nil)
schCreateWire(cv "route" "full" '((23.000 3.250) (22.250 3.250)) 0 0 0 nil nil)
schCreateWireLabel(cv nil '(22.750 3.250) "VIOH" "lowerRight" "R0" "stick" 0.0625 nil)
schCreateWire(cv "route" "full" '((23.000 3.625) (22.250 3.625)) 0 0 0 nil nil)
schCreateWireLabel(cv nil '(22.750 3.625) "GIOH" "lowerRight" "R0" "stick" 0.0625 nil)
dbCreateInst(cv pddw16sdgz_h_gMaster "D1_right1" '(24.0 4.3125) "R90")
schCreateWire(cv "route" "full" '((23.000 4.438) (22.250 4.438)) 0 0 0 nil nil)
schCreateWireLabel(cv nil '(22.750 4.438) "GIOL" "lowerRight" "R0" "stick" 0.0625 nil)
schCreateWire(cv "route" "full" '((23.000 4.562) (22.250 4.562)) 0 0 0 nil nil)
schCreateWireLabel(cv nil '(22.750 4.562) "D1_CORE" "lowerRight" "R0" "stick" 0.0625 nil)
schCreatePin(cv nil "D1_CORE" "inputOutput" nil '(22.250 4.562) "R0")
schCreateWire(cv "route" "full" '((23.000 4.188) (22.250 4.188)) 0 0 0 nil nil)
schCreateWireLabel(cv nil '(22.750 4.188) "VIOL" "lowerRight" "R0" "stick" 0.0625 nil)
schCreateWire(cv "route" "full" '((23.000 4.062) (22.250 4.062)) 0 0 0 nil nil)
schCreateWireLabel(cv nil '(22.750 4.062) "GIOL" "lowerRight" "R0" "stick" 0.0625 nil)
schCreateWire(cv "route" "full" '((24.000 5.000) (24.750 5.000)) 0 0 0 nil nil)
schCreateWireLabel(cv nil '(24.250 5.000) "D1" "lowerLeft" "R0" "stick" 0.0625 nil)
schCreatePin(cv nil "D1" "inputOutput" nil '(24.750 5.000) "R180")
schCreateWire(cv "route" "full" '((23.000 4.688) (22.250 4.688)) 0 0 0 nil nil)
schCreateWireLabel(cv nil '(22.750 4.688) "POC" "lowerRight" "R0" "stick" 0.0625 nil)
schCreateWire(cv "route" "full" '((23.000 4.875) (22.250 4.875)) 0 0 0 nil nil)
schCreateWireLabel(cv nil '(22.750 4.875) "VIOL" "lowerRight" "R0" "stick" 0.0625 nil)
schCreateWire(cv "route" "full" '((23.000 5.062) (22.250 5.062)) 0 0 0 nil nil)
schCreateWireLabel(cv nil '(22.750 5.062) "GIOL" "lowerRight" "R0" "stick" 0.0625 nil)
schCreateWire(cv "route" "full" '((23.000 5.250) (22.250 5.250)) 0 0 0 nil nil)
schCreateWireLabel(cv nil '(22.750 5.250) "VIOH" "lowerRight" "R0" "stick" 0.0625 nil)
schCreateWire(cv "route" "full" '((23.000 5.625) (22.250 5.625)) 0 0 0 nil nil)
schCreateWireLabel(cv nil '(22.750 5.625) "GIOH" "lowerRight" "R0" "stick" 0.0625 nil)
dbCreateInst(cv pddw16sdgz_h_gMaster "D2_right2" '(24.0 6.3125) "R90")
schCreateWire(cv "route" "full" '((23.000 6.438) (22.250 6.438)) 0 0 0 nil nil)
schCreateWireLabel(cv nil '(22.750 6.438) "GIOL" "lowerRight" "R0" "stick" 0.0625 nil)
schCreateWire(cv "route" "full" '((23.000 6.562) (22.250 6.562)) 0 0 0 nil nil)
schCreateWireLabel(cv nil '(22.750 6.562) "D2_CORE" "lowerRight" "R0" "stick" 0.0625 nil)
schCreatePin(cv nil "D2_CORE" "inputOutput" nil '(22.250 6.562) "R0")
schCreateWire(cv "route" "full" '((23.000 6.188) (22.250 6.188)) 0 0 0 nil nil)
schCreateWireLabel(cv nil '(22.750 6.188) "VIOL" "lowerRight" "R0" "stick" 0.0625 nil)
schCreateWire(cv "route" "full" '((23.000 6.062) (22.250 6.062)) 0 0 0 nil nil)
schCreateWireLabel(cv nil '(22.750 6.062) "GIOL" "lowerRight" "R0" "stick" 0.0625 nil)
schCreateWire(cv "route" "full" '((24.000 7.000) (24.750 7.000)) 0 0 0 nil nil)
schCreateWireLabel(cv nil '(24.250 7.000) "D2" "lowerLeft" "R0" "stick" 0.0625 nil)
schCreatePin(cv nil "D2" "inputOutput" nil '(24.750 7.000) "R180")
schCreateWire(cv "route" "full" '((23.000 6.688) (22.250 6.688)) 0 0 0 nil nil)
schCreateWireLabel(cv nil '(22.750 6.688) "POC" "lowerRight" "R0" "stick" 0.0625 nil)
schCreateWire(cv "route" "full" '((23.000 6.875) (22.250 6.875)) 0 0 0 nil nil)
schCreateWireLabel(cv nil '(22.750 6.875) "VIOL" "lowerRight" "R0" "stick" 0.0625 nil)
schCreateWire(cv "route" "full" '((23.000 7.062) (22.250 7.062)) 0 0 0 nil nil)
schCreateWireLabel(cv nil '(22.750 7.062) "GIOL" "lowerRight" "R0" "stick" 0.0625 nil)
schCreateWire(cv "route" "full" '((23.000 7.250) (22.250 7.250)) 0 0 0 nil nil)
schCreateWireLabel(cv nil '(22.750 7.250) "VIOH" "lowerRight" "R0" "stick" 0.0625 nil)
schCreateWire(cv "route" "full" '((23.000 7.625) (22.250 7.625)) 0 0 0 nil nil)
schCreateWireLabel(cv nil '(22.750 7.625) "GIOH" "lowerRight" "R0" "stick" 0.0625 nil)
dbCreateInst(cv pddw16sdgz_h_gMaster "D3_right3" '(24.0 8.3125) "R90")
schCreateWire(cv "route" "full" '((23.000 8.438) (22.250 8.438)) 0 0 0 nil nil)
schCreateWireLabel(cv nil '(22.750 8.438) "GIOL" "lowerRight" "R0" "stick" 0.0625 nil)
schCreateWire(cv "route" "full" '((23.000 8.562) (22.250 8.562)) 0 0 0 nil nil)
schCreateWireLabel(cv nil '(22.750 8.562) "D3_CORE" "lowerRight" "R0" "stick" 0.0625 nil)
schCreatePin(cv nil "D3_CORE" "inputOutput" nil '(22.250 8.562) "R0")
schCreateWire(cv "route" "full" '((23.000 8.188) (22.250 8.188)) 0 0 0 nil nil)
schCreateWireLabel(cv nil '(22.750 8.188) "VIOL" "lowerRight" "R0" "stick" 0.0625 nil)
schCreateWire(cv "route" "full" '((23.000 8.062) (22.250 8.062)) 0 0 0 nil nil)
schCreateWireLabel(cv nil '(22.750 8.062) "GIOL" "lowerRight" "R0" "stick" 0.0625 nil)
schCreateWire(cv "route" "full" '((24.000 9.001) (24.750 9.001)) 0 0 0 nil nil)
schCreateWireLabel(cv nil '(24.250 9.001) "D3" "lowerLeft" "R0" "stick" 0.0625 nil)
schCreatePin(cv nil "D3" "inputOutput" nil '(24.750 9.001) "R180")
schCreateWire(cv "route" "full" '((23.000 8.688) (22.250 8.688)) 0 0 0 nil nil)
schCreateWireLabel(cv nil '(22.750 8.688) "POC" "lowerRight" "R0" "stick" 0.0625 nil)
schCreateWire(cv "route" "full" '((23.000 8.874) (22.250 8.874)) 0 0 0 nil nil)
schCreateWireLabel(cv nil '(22.750 8.874) "VIOL" "lowerRight" "R0" "stick" 0.0625 nil)
schCreateWire(cv "route" "full" '((23.000 9.062) (22.250 9.062)) 0 0 0 nil nil)
schCreateWireLabel(cv nil '(22.750 9.062) "GIOL" "lowerRight" "R0" "stick" 0.0625 nil)
schCreateWire(cv "route" "full" '((23.000 9.251) (22.250 9.251)) 0 0 0 nil nil)
schCreateWireLabel(cv nil '(22.750 9.251) "VIOH" "lowerRight" "R0" "stick" 0.0625 nil)
schCreateWire(cv "route" "full" '((23.000 9.624) (22.250 9.624)) 0 0 0 nil nil)
schCreateWireLabel(cv nil '(22.750 9.624) "GIOH" "lowerRight" "R0" "stick" 0.0625 nil)
dbCreateInst(cv pddw16sdgz_h_gMaster "D4_right4" '(24.0 10.3125) "R90")
schCreateWire(cv "route" "full" '((23.000 10.438) (22.250 10.438)) 0 0 0 nil nil)
schCreateWireLabel(cv nil '(22.750 10.438) "GIOL" "lowerRight" "R0" "stick" 0.0625 nil)
schCreateWire(cv "route" "full" '((23.000 10.562) (22.250 10.562)) 0 0 0 nil nil)
schCreateWireLabel(cv nil '(22.750 10.562) "D4_CORE" "lowerRight" "R0" "stick" 0.0625 nil)
schCreatePin(cv nil "D4_CORE" "inputOutput" nil '(22.250 10.562) "R0")
schCreateWire(cv "route" "full" '((23.000 10.188) (22.250 10.188)) 0 0 0 nil nil)
schCreateWireLabel(cv nil '(22.750 10.188) "VIOL" "lowerRight" "R0" "stick" 0.0625 nil)
schCreateWire(cv "route" "full" '((23.000 10.062) (22.250 10.062)) 0 0 0 nil nil)
schCreateWireLabel(cv nil '(22.750 10.062) "GIOL" "lowerRight" "R0" "stick" 0.0625 nil)
schCreateWire(cv "route" "full" '((24.000 11.001) (24.750 11.001)) 0 0 0 nil nil)
schCreateWireLabel(cv nil '(24.250 11.001) "D4" "lowerLeft" "R0" "stick" 0.0625 nil)
schCreatePin(cv nil "D4" "inputOutput" nil '(24.750 11.001) "R180")
schCreateWire(cv "route" "full" '((23.000 10.688) (22.250 10.688)) 0 0 0 nil nil)
schCreateWireLabel(cv nil '(22.750 10.688) "POC" "lowerRight" "R0" "stick" 0.0625 nil)
schCreateWire(cv "route" "full" '((23.000 10.874) (22.250 10.874)) 0 0 0 nil nil)
schCreateWireLabel(cv nil '(22.750 10.874) "VIOL" "lowerRight" "R0" "stick" 0.0625 nil)
schCreateWire(cv "route" "full" '((23.000 11.062) (22.250 11.062)) 0 0 0 nil nil)
schCreateWireLabel(cv nil '(22.750 11.062) "GIOL" "lowerRight" "R0" "stick" 0.0625 nil)
schCreateWire(cv "route" "full" '((23.000 11.251) (22.250 11.251)) 0 0 0 nil nil)
schCreateWireLabel(cv nil '(22.750 11.251) "VIOH" "lowerRight" "R0" "stick" 0.0625 nil)
schCreateWire(cv "route" "full" '((23.000 11.624) (22.250 11.624)) 0 0 0 nil nil)
schCreateWireLabel(cv nil '(22.750 11.624) "GIOH" "lowerRight" "R0" "stick" 0.0625 nil)
dbCreateInst(cv pddw16sdgz_h_gMaster "D5_right5" '(24.0 12.3125) "R90")
schCreateWire(cv "route" "full" '((23.000 12.438) (22.250 12.438)) 0 0 0 nil nil)
schCreateWireLabel(cv nil '(22.750 12.438) "GIOL" "lowerRight" "R0" "stick" 0.0625 nil)
schCreateWire(cv "route" "full" '((23.000 12.562) (22.250 12.562)) 0 0 0 nil nil)
schCreateWireLabel(cv nil '(22.750 12.562) "D5_CORE" "lowerRight" "R0" "stick" 0.0625 nil)
schCreatePin(cv nil "D5_CORE" "inputOutput" nil '(22.250 12.562) "R0")
schCreateWire(cv "route" "full" '((23.000 12.188) (22.250 12.188)) 0 0 0 nil nil)
schCreateWireLabel(cv nil '(22.750 12.188) "VIOL" "lowerRight" "R0" "stick" 0.0625 nil)
schCreateWire(cv "route" "full" '((23.000 12.062) (22.250 12.062)) 0 0 0 nil nil)
schCreateWireLabel(cv nil '(22.750 12.062) "GIOL" "lowerRight" "R0" "stick" 0.0625 nil)
schCreateWire(cv "route" "full" '((24.000 13.001) (24.750 13.001)) 0 0 0 nil nil)
schCreateWireLabel(cv nil '(24.250 13.001) "D5" "lowerLeft" "R0" "stick" 0.0625 nil)
schCreatePin(cv nil "D5" "inputOutput" nil '(24.750 13.001) "R180")
schCreateWire(cv "route" "full" '((23.000 12.688) (22.250 12.688)) 0 0 0 nil nil)
schCreateWireLabel(cv nil '(22.750 12.688) "POC" "lowerRight" "R0" "stick" 0.0625 nil)
schCreateWire(cv "route" "full" '((23.000 12.874) (22.250 12.874)) 0 0 0 nil nil)
schCreateWireLabel(cv nil '(22.750 12.874) "VIOL" "lowerRight" "R0" "stick" 0.0625 nil)
schCreateWire(cv "route" "full" '((23.000 13.062) (22.250 13.062)) 0 0 0 nil nil)
schCreateWireLabel(cv nil '(22.750 13.062) "GIOL" "lowerRight" "R0" "stick" 0.0625 nil)
schCreateWire(cv "route" "full" '((23.000 13.251) (22.250 13.251)) 0 0 0 nil nil)
schCreateWireLabel(cv nil '(22.750 13.251) "VIOH" "lowerRight" "R0" "stick" 0.0625 nil)
schCreateWire(cv "route" "full" '((23.000 13.624) (22.250 13.624)) 0 0 0 nil nil)
schCreateWireLabel(cv nil '(22.750 13.624) "GIOH" "lowerRight" "R0" "stick" 0.0625 nil)
dbCreateInst(cv pddw16sdgz_h_gMaster "D6_right6" '(24.0 14.3125) "R90")
schCreateWire(cv "route" "full" '((23.000 14.438) (22.250 14.438)) 0 0 0 nil nil)
schCreateWireLabel(cv nil '(22.750 14.438) "GIOL" "lowerRight" "R0" "stick" 0.0625 nil)
schCreateWire(cv "route" "full" '((23.000 14.562) (22.250 14.562)) 0 0 0 nil nil)
schCreateWireLabel(cv nil '(22.750 14.562) "D6_CORE" "lowerRight" "R0" "stick" 0.0625 nil)
schCreatePin(cv nil "D6_CORE" "inputOutput" nil '(22.250 14.562) "R0")
schCreateWire(cv "route" "full" '((23.000 14.188) (22.250 14.188)) 0 0 0 nil nil)
schCreateWireLabel(cv nil '(22.750 14.188) "VIOL" "lowerRight" "R0" "stick" 0.0625 nil)
schCreateWire(cv "route" "full" '((23.000 14.062) (22.250 14.062)) 0 0 0 nil nil)
schCreateWireLabel(cv nil '(22.750 14.062) "GIOL" "lowerRight" "R0" "stick" 0.0625 nil)
schCreateWire(cv "route" "full" '((24.000 15.001) (24.750 15.001)) 0 0 0 nil nil)
schCreateWireLabel(cv nil '(24.250 15.001) "D6" "lowerLeft" "R0" "stick" 0.0625 nil)
schCreatePin(cv nil "D6" "inputOutput" nil '(24.750 15.001) "R180")
schCreateWire(cv "route" "full" '((23.000 14.688) (22.250 14.688)) 0 0 0 nil nil)
schCreateWireLabel(cv nil '(22.750 14.688) "POC" "lowerRight" "R0" "stick" 0.0625 nil)
schCreateWire(cv "route" "full" '((23.000 14.874) (22.250 14.874)) 0 0 0 nil nil)
schCreateWireLabel(cv nil '(22.750 14.874) "VIOL" "lowerRight" "R0" "stick" 0.0625 nil)
schCreateWire(cv "route" "full" '((23.000 15.062) (22.250 15.062)) 0 0 0 nil nil)
schCreateWireLabel(cv nil '(22.750 15.062) "GIOL" "lowerRight" "R0" "stick" 0.0625 nil)
schCreateWire(cv "route" "full" '((23.000 15.251) (22.250 15.251)) 0 0 0 nil nil)
schCreateWireLabel(cv nil '(22.750 15.251) "VIOH" "lowerRight" "R0" "stick" 0.0625 nil)
schCreateWire(cv "route" "full" '((23.000 15.624) (22.250 15.624)) 0 0 0 nil nil)
schCreateWireLabel(cv nil '(22.750 15.624) "GIOH" "lowerRight" "R0" "stick" 0.0625 nil)
dbCreateInst(cv pddw16sdgz_h_gMaster "D7_right7" '(24.0 16.3125) "R90")
schCreateWire(cv "route" "full" '((23.000 16.438) (22.250 16.438)) 0 0 0 nil nil)
schCreateWireLabel(cv nil '(22.750 16.438) "GIOL" "lowerRight" "R0" "stick" 0.0625 nil)
schCreateWire(cv "route" "full" '((23.000 16.562) (22.250 16.562)) 0 0 0 nil nil)
schCreateWireLabel(cv nil '(22.750 16.562) "D7_CORE" "lowerRight" "R0" "stick" 0.0625 nil)
schCreatePin(cv nil "D7_CORE" "inputOutput" nil '(22.250 16.562) "R0")
schCreateWire(cv "route" "full" '((23.000 16.188) (22.250 16.188)) 0 0 0 nil nil)
schCreateWireLabel(cv nil '(22.750 16.188) "VIOL" "lowerRight" "R0" "stick" 0.0625 nil)
schCreateWire(cv "route" "full" '((23.000 16.062) (22.250 16.062)) 0 0 0 nil nil)
schCreateWireLabel(cv nil '(22.750 16.062) "GIOL" "lowerRight" "R0" "stick" 0.0625 nil)
schCreateWire(cv "route" "full" '((24.000 17.000) (24.750 17.000)) 0 0 0 nil nil)
schCreateWireLabel(cv nil '(24.250 17.000) "D7" "lowerLeft" "R0" "stick" 0.0625 nil)
schCreatePin(cv nil "D7" "inputOutput" nil '(24.750 17.000) "R180")
schCreateWire(cv "route" "full" '((23.000 16.688) (22.250 16.688)) 0 0 0 nil nil)
schCreateWireLabel(cv nil '(22.750 16.688) "POC" "lowerRight" "R0" "stick" 0.0625 nil)
schCreateWire(cv "route" "full" '((23.000 16.875) (22.250 16.875)) 0 0 0 nil nil)
schCreateWireLabel(cv nil '(22.750 16.875) "VIOL" "lowerRight" "R0" "stick" 0.0625 nil)
schCreateWire(cv "route" "full" '((23.000 17.062) (22.250 17.062)) 0 0 0 nil nil)
schCreateWireLabel(cv nil '(22.750 17.062) "GIOL" "lowerRight" "R0" "stick" 0.0625 nil)
schCreateWire(cv "route" "full" '((23.000 17.250) (22.250 17.250)) 0 0 0 nil nil)
schCreateWireLabel(cv nil '(22.750 17.250) "VIOH" "lowerRight" "R0" "stick" 0.0625 nil)
schCreateWire(cv "route" "full" '((23.000 17.625) (22.250 17.625)) 0 0 0 nil nil)
schCreateWireLabel(cv nil '(22.750 17.625) "GIOH" "lowerRight" "R0" "stick" 0.0625 nil)
dbCreateInst(cv pddw16sdgz_h_gMaster "D8_right8" '(24.0 18.3125) "R90")
schCreateWire(cv "route" "full" '((23.000 18.438) (22.250 18.438)) 0 0 0 nil nil)
schCreateWireLabel(cv nil '(22.750 18.438) "VIOL" "lowerRight" "R0" "stick" 0.0625 nil)
noConnMaster = dbOpenCellView("basic" "noConn" "symbol")
schCreateWire(cv "route" "full" '((23.000 18.562) (22.250 18.562)) 0 0 0 nil nil)
dbCreateInst(cv noConnMaster "noConn_D8_right8_C" '(22.250 18.562) "R270")
schCreateWire(cv "route" "full" '((23.000 18.188) (22.250 18.188)) 0 0 0 nil nil)
schCreateWireLabel(cv nil '(22.750 18.188) "GIOL" "lowerRight" "R0" "stick" 0.0625 nil)
schCreateWire(cv "route" "full" '((23.000 18.062) (22.250 18.062)) 0 0 0 nil nil)
schCreateWireLabel(cv nil '(22.750 18.062) "D8_CORE" "lowerRight" "R0" "stick" 0.0625 nil)
schCreatePin(cv nil "D8_CORE" "inputOutput" nil '(22.250 18.062) "R0")
schCreateWire(cv "route" "full" '((24.000 19.000) (24.750 19.000)) 0 0 0 nil nil)
schCreateWireLabel(cv nil '(24.250 19.000) "D8" "lowerLeft" "R0" "stick" 0.0625 nil)
schCreatePin(cv nil "D8" "inputOutput" nil '(24.750 19.000) "R180")
schCreateWire(cv "route" "full" '((23.000 18.688) (22.250 18.688)) 0 0 0 nil nil)
schCreateWireLabel(cv nil '(22.750 18.688) "POC" "lowerRight" "R0" "stick" 0.0625 nil)
schCreateWire(cv "route" "full" '((23.000 18.875) (22.250 18.875)) 0 0 0 nil nil)
schCreateWireLabel(cv nil '(22.750 18.875) "VIOL" "lowerRight" "R0" "stick" 0.0625 nil)
schCreateWire(cv "route" "full" '((23.000 19.062) (22.250 19.062)) 0 0 0 nil nil)
schCreateWireLabel(cv nil '(22.750 19.062) "GIOL" "lowerRight" "R0" "stick" 0.0625 nil)
schCreateWire(cv "route" "full" '((23.000 19.250) (22.250 19.250)) 0 0 0 nil nil)
schCreateWireLabel(cv nil '(22.750 19.250) "VIOH" "lowerRight" "R0" "stick" 0.0625 nil)
schCreateWire(cv "route" "full" '((23.000 19.625) (22.250 19.625)) 0 0 0 nil nil)
schCreateWireLabel(cv nil '(22.750 19.625) "GIOH" "lowerRight" "R0" "stick" 0.0625 nil)
dbCreateInst(cv pddw16sdgz_h_gMaster "D9_right9" '(24.0 20.3125) "R90")
schCreateWire(cv "route" "full" '((23.000 20.438) (22.250 20.438)) 0 0 0 nil nil)
schCreateWireLabel(cv nil '(22.750 20.438) "VIOL" "lowerRight" "R0" "stick" 0.0625 nil)
schCreateWire(cv "route" "full" '((23.000 20.562) (22.250 20.562)) 0 0 0 nil nil)
dbCreateInst(cv noConnMaster "noConn_D9_right9_C" '(22.250 20.562) "R270")
schCreateWire(cv "route" "full" '((23.000 20.188) (22.250 20.188)) 0 0 0 nil nil)
schCreateWireLabel(cv nil '(22.750 20.188) "GIOL" "lowerRight" "R0" "stick" 0.0625 nil)
schCreateWire(cv "route" "full" '((23.000 20.062) (22.250 20.062)) 0 0 0 nil nil)
schCreateWireLabel(cv nil '(22.750 20.062) "D9_CORE" "lowerRight" "R0" "stick" 0.0625 nil)
schCreatePin(cv nil "D9_CORE" "inputOutput" nil '(22.250 20.062) "R0")
schCreateWire(cv "route" "full" '((24.000 21.000) (24.750 21.000)) 0 0 0 nil nil)
schCreateWireLabel(cv nil '(24.250 21.000) "D9" "lowerLeft" "R0" "stick" 0.0625 nil)
schCreatePin(cv nil "D9" "inputOutput" nil '(24.750 21.000) "R180")
schCreateWire(cv "route" "full" '((23.000 20.688) (22.250 20.688)) 0 0 0 nil nil)
schCreateWireLabel(cv nil '(22.750 20.688) "POC" "lowerRight" "R0" "stick" 0.0625 nil)
schCreateWire(cv "route" "full" '((23.000 20.875) (22.250 20.875)) 0 0 0 nil nil)
schCreateWireLabel(cv nil '(22.750 20.875) "VIOL" "lowerRight" "R0" "stick" 0.0625 nil)
schCreateWire(cv "route" "full" '((23.000 21.062) (22.250 21.062)) 0 0 0 nil nil)
schCreateWireLabel(cv nil '(22.750 21.062) "GIOL" "lowerRight" "R0" "stick" 0.0625 nil)
schCreateWire(cv "route" "full" '((23.000 21.250) (22.250 21.250)) 0 0 0 nil nil)
schCreateWireLabel(cv nil '(22.750 21.250) "VIOH" "lowerRight" "R0" "stick" 0.0625 nil)
schCreateWire(cv "route" "full" '((23.000 21.625) (22.250 21.625)) 0 0 0 nil nil)
schCreateWireLabel(cv nil '(22.750 21.625) "GIOH" "lowerRight" "R0" "stick" 0.0625 nil)
pddw16sdgz_v_gMaster = dbOpenCellView("tphn28hpcpgv18" "PDDW16SDGZ_V_G" "symbol")
dbCreateInst(cv pddw16sdgz_v_gMaster "D10_top0" '(21.6875 24.0) "R180")
schCreateWire(cv "route" "full" '((21.562 23.000) (21.562 22.250)) 0 0 0 nil nil)
schCreateWireLabel(cv nil '(21.562 22.750) "VIOL" "lowerRight" "R90" "stick" 0.0625 nil)
schCreateWire(cv "route" "full" '((21.438 23.000) (21.438 22.250)) 0 0 0 nil nil)
dbCreateInst(cv noConnMaster "noConn_D10_top0_C" '(21.438 22.250) "R0")
schCreateWire(cv "route" "full" '((21.812 23.000) (21.812 22.250)) 0 0 0 nil nil)
schCreateWireLabel(cv nil '(21.812 22.750) "GIOL" "lowerRight" "R90" "stick" 0.0625 nil)
schCreateWire(cv "route" "full" '((21.938 23.000) (21.938 22.250)) 0 0 0 nil nil)
schCreateWireLabel(cv nil '(21.938 22.750) "D10_CORE" "lowerRight" "R90" "stick" 0.0625 nil)
schCreatePin(cv nil "D10_CORE" "inputOutput" nil '(21.938 22.250) "R90")
schCreateWire(cv "route" "full" '((21.000 24.000) (21.000 24.750)) 0 0 0 nil nil)
schCreateWireLabel(cv nil '(21.000 24.250) "D10" "lowerLeft" "R90" "stick" 0.0625 nil)
schCreatePin(cv nil "D10" "inputOutput" nil '(21.000 24.750) "R270")
schCreateWire(cv "route" "full" '((21.312 23.000) (21.312 22.250)) 0 0 0 nil nil)
schCreateWireLabel(cv nil '(21.312 22.750) "POC" "lowerRight" "R90" "stick" 0.0625 nil)
schCreateWire(cv "route" "full" '((21.125 23.000) (21.125 22.250)) 0 0 0 nil nil)
schCreateWireLabel(cv nil '(21.125 22.750) "VIOL" "lowerRight" "R90" "stick" 0.0625 nil)
schCreateWire(cv "route" "full" '((20.938 23.000) (20.938 22.250)) 0 0 0 nil nil)
schCreateWireLabel(cv nil '(20.938 22.750) "GIOL" "lowerRight" "R90" "stick" 0.0625 nil)
schCreateWire(cv "route" "full" '((20.750 23.000) (20.750 22.250)) 0 0 0 nil nil)
schCreateWireLabel(cv nil '(20.750 22.750) "VIOH" "lowerRight" "R90" "stick" 0.0625 nil)
schCreateWire(cv "route" "full" '((20.375 23.000) (20.375 22.250)) 0 0 0 nil nil)
schCreateWireLabel(cv nil '(20.375 22.750) "GIOH" "lowerRight" "R90" "stick" 0.0625 nil)
dbCreateInst(cv pddw16sdgz_v_gMaster "D11_top1" '(19.6875 24.0) "R180")
schCreateWire(cv "route" "full" '((19.562 23.000) (19.562 22.250)) 0 0 0 nil nil)
schCreateWireLabel(cv nil '(19.562 22.750) "VIOL" "lowerRight" "R90" "stick" 0.0625 nil)
schCreateWire(cv "route" "full" '((19.438 23.000) (19.438 22.250)) 0 0 0 nil nil)
dbCreateInst(cv noConnMaster "noConn_D11_top1_C" '(19.438 22.250) "R0")
schCreateWire(cv "route" "full" '((19.812 23.000) (19.812 22.250)) 0 0 0 nil nil)
schCreateWireLabel(cv nil '(19.812 22.750) "GIOL" "lowerRight" "R90" "stick" 0.0625 nil)
schCreateWire(cv "route" "full" '((19.938 23.000) (19.938 22.250)) 0 0 0 nil nil)
schCreateWireLabel(cv nil '(19.938 22.750) "D11_CORE" "lowerRight" "R90" "stick" 0.0625 nil)
schCreatePin(cv nil "D11_CORE" "inputOutput" nil '(19.938 22.250) "R90")
schCreateWire(cv "route" "full" '((19.000 24.000) (19.000 24.750)) 0 0 0 nil nil)
schCreateWireLabel(cv nil '(19.000 24.250) "D11" "lowerLeft" "R90" "stick" 0.0625 nil)
schCreatePin(cv nil "D11" "inputOutput" nil '(19.000 24.750) "R270")
schCreateWire(cv "route" "full" '((19.312 23.000) (19.312 22.250)) 0 0 0 nil nil)
schCreateWireLabel(cv nil '(19.312 22.750) "POC" "lowerRight" "R90" "stick" 0.0625 nil)
schCreateWire(cv "route" "full" '((19.125 23.000) (19.125 22.250)) 0 0 0 nil nil)
schCreateWireLabel(cv nil '(19.125 22.750) "VIOL" "lowerRight" "R90" "stick" 0.0625 nil)
schCreateWire(cv "route" "full" '((18.938 23.000) (18.938 22.250)) 0 0 0 nil nil)
schCreateWireLabel(cv nil '(18.938 22.750) "GIOL" "lowerRight" "R90" "stick" 0.0625 nil)
schCreateWire(cv "route" "full" '((18.750 23.000) (18.750 22.250)) 0 0 0 nil nil)
schCreateWireLabel(cv nil '(18.750 22.750) "VIOH" "lowerRight" "R90" "stick" 0.0625 nil)
schCreateWire(cv "route" "full" '((18.375 23.000) (18.375 22.250)) 0 0 0 nil nil)
schCreateWireLabel(cv nil '(18.375 22.750) "GIOH" "lowerRight" "R90" "stick" 0.0625 nil)
dbCreateInst(cv pddw16sdgz_v_gMaster "D12_top2" '(17.6875 24.0) "R180")
schCreateWire(cv "route" "full" '((17.562 23.000) (17.562 22.250)) 0 0 0 nil nil)
schCreateWireLabel(cv nil '(17.562 22.750) "VIOL" "lowerRight" "R90" "stick" 0.0625 nil)
schCreateWire(cv "route" "full" '((17.438 23.000) (17.438 22.250)) 0 0 0 nil nil)
dbCreateInst(cv noConnMaster "noConn_D12_top2_C" '(17.438 22.250) "R0")
schCreateWire(cv "route" "full" '((17.812 23.000) (17.812 22.250)) 0 0 0 nil nil)
schCreateWireLabel(cv nil '(17.812 22.750) "GIOL" "lowerRight" "R90" "stick" 0.0625 nil)
schCreateWire(cv "route" "full" '((17.938 23.000) (17.938 22.250)) 0 0 0 nil nil)
schCreateWireLabel(cv nil '(17.938 22.750) "D12_CORE" "lowerRight" "R90" "stick" 0.0625 nil)
schCreatePin(cv nil "D12_CORE" "inputOutput" nil '(17.938 22.250) "R90")
schCreateWire(cv "route" "full" '((17.000 24.000) (17.000 24.750)) 0 0 0 nil nil)
schCreateWireLabel(cv nil '(17.000 24.250) "D12" "lowerLeft" "R90" "stick" 0.0625 nil)
schCreatePin(cv nil "D12" "inputOutput" nil '(17.000 24.750) "R270")
schCreateWire(cv "route" "full" '((17.312 23.000) (17.312 22.250)) 0 0 0 nil nil)
schCreateWireLabel(cv nil '(17.312 22.750) "POC" "lowerRight" "R90" "stick" 0.0625 nil)
schCreateWire(cv "route" "full" '((17.125 23.000) (17.125 22.250)) 0 0 0 nil nil)
schCreateWireLabel(cv nil '(17.125 22.750) "VIOL" "lowerRight" "R90" "stick" 0.0625 nil)
schCreateWire(cv "route" "full" '((16.938 23.000) (16.938 22.250)) 0 0 0 nil nil)
schCreateWireLabel(cv nil '(16.938 22.750) "GIOL" "lowerRight" "R90" "stick" 0.0625 nil)
schCreateWire(cv "route" "full" '((16.750 23.000) (16.750 22.250)) 0 0 0 nil nil)
schCreateWireLabel(cv nil '(16.750 22.750) "VIOH" "lowerRight" "R90" "stick" 0.0625 nil)
schCreateWire(cv "route" "full" '((16.375 23.000) (16.375 22.250)) 0 0 0 nil nil)
schCreateWireLabel(cv nil '(16.375 22.750) "GIOH" "lowerRight" "R90" "stick" 0.0625 nil)
dbCreateInst(cv pddw16sdgz_v_gMaster "D13_top3" '(15.6875 24.0) "R180")
schCreateWire(cv "route" "full" '((15.562 23.000) (15.562 22.250)) 0 0 0 nil nil)
schCreateWireLabel(cv nil '(15.562 22.750) "VIOL" "lowerRight" "R90" "stick" 0.0625 nil)
schCreateWire(cv "route" "full" '((15.438 23.000) (15.438 22.250)) 0 0 0 nil nil)
dbCreateInst(cv noConnMaster "noConn_D13_top3_C" '(15.438 22.250) "R0")
schCreateWire(cv "route" "full" '((15.812 23.000) (15.812 22.250)) 0 0 0 nil nil)
schCreateWireLabel(cv nil '(15.812 22.750) "GIOL" "lowerRight" "R90" "stick" 0.0625 nil)
schCreateWire(cv "route" "full" '((15.938 23.000) (15.938 22.250)) 0 0 0 nil nil)
schCreateWireLabel(cv nil '(15.938 22.750) "D13_CORE" "lowerRight" "R90" "stick" 0.0625 nil)
schCreatePin(cv nil "D13_CORE" "inputOutput" nil '(15.938 22.250) "R90")
schCreateWire(cv "route" "full" '((14.999 24.000) (14.999 24.750)) 0 0 0 nil nil)
schCreateWireLabel(cv nil '(14.999 24.250) "D13" "lowerLeft" "R90" "stick" 0.0625 nil)
schCreatePin(cv nil "D13" "inputOutput" nil '(14.999 24.750) "R270")
schCreateWire(cv "route" "full" '((15.312 23.000) (15.312 22.250)) 0 0 0 nil nil)
schCreateWireLabel(cv nil '(15.312 22.750) "POC" "lowerRight" "R90" "stick" 0.0625 nil)
schCreateWire(cv "route" "full" '((15.126 23.000) (15.126 22.250)) 0 0 0 nil nil)
schCreateWireLabel(cv nil '(15.126 22.750) "VIOL" "lowerRight" "R90" "stick" 0.0625 nil)
schCreateWire(cv "route" "full" '((14.938 23.000) (14.938 22.250)) 0 0 0 nil nil)
schCreateWireLabel(cv nil '(14.938 22.750) "GIOL" "lowerRight" "R90" "stick" 0.0625 nil)
schCreateWire(cv "route" "full" '((14.749 23.000) (14.749 22.250)) 0 0 0 nil nil)
schCreateWireLabel(cv nil '(14.749 22.750) "VIOH" "lowerRight" "R90" "stick" 0.0625 nil)
schCreateWire(cv "route" "full" '((14.376 23.000) (14.376 22.250)) 0 0 0 nil nil)
schCreateWireLabel(cv nil '(14.376 22.750) "GIOH" "lowerRight" "R90" "stick" 0.0625 nil)
dbCreateInst(cv pddw16sdgz_v_gMaster "D14_top4" '(13.6875 24.0) "R180")
schCreateWire(cv "route" "full" '((13.562 23.000) (13.562 22.250)) 0 0 0 nil nil)
schCreateWireLabel(cv nil '(13.562 22.750) "VIOL" "lowerRight" "R90" "stick" 0.0625 nil)
schCreateWire(cv "route" "full" '((13.438 23.000) (13.438 22.250)) 0 0 0 nil nil)
dbCreateInst(cv noConnMaster "noConn_D14_top4_C" '(13.438 22.250) "R0")
schCreateWire(cv "route" "full" '((13.812 23.000) (13.812 22.250)) 0 0 0 nil nil)
schCreateWireLabel(cv nil '(13.812 22.750) "GIOL" "lowerRight" "R90" "stick" 0.0625 nil)
schCreateWire(cv "route" "full" '((13.938 23.000) (13.938 22.250)) 0 0 0 nil nil)
schCreateWireLabel(cv nil '(13.938 22.750) "D14_CORE" "lowerRight" "R90" "stick" 0.0625 nil)
schCreatePin(cv nil "D14_CORE" "inputOutput" nil '(13.938 22.250) "R90")
schCreateWire(cv "route" "full" '((12.999 24.000) (12.999 24.750)) 0 0 0 nil nil)
schCreateWireLabel(cv nil '(12.999 24.250) "D14" "lowerLeft" "R90" "stick" 0.0625 nil)
schCreatePin(cv nil "D14" "inputOutput" nil '(12.999 24.750) "R270")
schCreateWire(cv "route" "full" '((13.312 23.000) (13.312 22.250)) 0 0 0 nil nil)
schCreateWireLabel(cv nil '(13.312 22.750) "POC" "lowerRight" "R90" "stick" 0.0625 nil)
schCreateWire(cv "route" "full" '((13.126 23.000) (13.126 22.250)) 0 0 0 nil nil)
schCreateWireLabel(cv nil '(13.126 22.750) "VIOL" "lowerRight" "R90" "stick" 0.0625 nil)
schCreateWire(cv "route" "full" '((12.938 23.000) (12.938 22.250)) 0 0 0 nil nil)
schCreateWireLabel(cv nil '(12.938 22.750) "GIOL" "lowerRight" "R90" "stick" 0.0625 nil)
schCreateWire(cv "route" "full" '((12.749 23.000) (12.749 22.250)) 0 0 0 nil nil)
schCreateWireLabel(cv nil '(12.749 22.750) "VIOH" "lowerRight" "R90" "stick" 0.0625 nil)
schCreateWire(cv "route" "full" '((12.376 23.000) (12.376 22.250)) 0 0 0 nil nil)
schCreateWireLabel(cv nil '(12.376 22.750) "GIOH" "lowerRight" "R90" "stick" 0.0625 nil)
dbCreateInst(cv pddw16sdgz_v_gMaster "D15_top5" '(11.6875 24.0) "R180")
schCreateWire(cv "route" "full" '((11.562 23.000) (11.562 22.250)) 0 0 0 nil nil)
schCreateWireLabel(cv nil '(11.562 22.750) "VIOL" "lowerRight" "R90" "stick" 0.0625 nil)
schCreateWire(cv "route" "full" '((11.438 23.000) (11.438 22.250)) 0 0 0 nil nil)
dbCreateInst(cv noConnMaster "noConn_D15_top5_C" '(11.438 22.250) "R0")
schCreateWire(cv "route" "full" '((11.812 23.000) (11.812 22.250)) 0 0 0 nil nil)
schCreateWireLabel(cv nil '(11.812 22.750) "GIOL" "lowerRight" "R90" "stick" 0.0625 nil)
schCreateWire(cv "route" "full" '((11.938 23.000) (11.938 22.250)) 0 0 0 nil nil)
schCreateWireLabel(cv nil '(11.938 22.750) "D15_CORE" "lowerRight" "R90" "stick" 0.0625 nil)
schCreatePin(cv nil "D15_CORE" "inputOutput" nil '(11.938 22.250) "R90")
schCreateWire(cv "route" "full" '((10.999 24.000) (10.999 24.750)) 0 0 0 nil nil)
schCreateWireLabel(cv nil '(10.999 24.250) "D15" "lowerLeft" "R90" "stick" 0.0625 nil)
schCreatePin(cv nil "D15" "inputOutput" nil '(10.999 24.750) "R270")
schCreateWire(cv "route" "full" '((11.312 23.000) (11.312 22.250)) 0 0 0 nil nil)
schCreateWireLabel(cv nil '(11.312 22.750) "POC" "lowerRight" "R90" "stick" 0.0625 nil)
schCreateWire(cv "route" "full" '((11.126 23.000) (11.126 22.250)) 0 0 0 nil nil)
schCreateWireLabel(cv nil '(11.126 22.750) "VIOL" "lowerRight" "R90" "stick" 0.0625 nil)
schCreateWire(cv "route" "full" '((10.938 23.000) (10.938 22.250)) 0 0 0 nil nil)
schCreateWireLabel(cv nil '(10.938 22.750) "GIOL" "lowerRight" "R90" "stick" 0.0625 nil)
schCreateWire(cv "route" "full" '((10.749 23.000) (10.749 22.250)) 0 0 0 nil nil)
schCreateWireLabel(cv nil '(10.749 22.750) "VIOH" "lowerRight" "R90" "stick" 0.0625 nil)
schCreateWire(cv "route" "full" '((10.376 23.000) (10.376 22.250)) 0 0 0 nil nil)
schCreateWireLabel(cv nil '(10.376 22.750) "GIOH" "lowerRight" "R90" "stick" 0.0625 nil)
pvdd1dgz_v_gMaster = dbOpenCellView("tphn28hpcpgv18" "PVDD1DGZ_V_G" "symbol")
dbCreateInst(cv pvdd1dgz_v_gMaster "VIOL_top6" '(10.0 24.0) "R180")
schCreateWire(cv "route" "full" '((9.625 23.000) (9.625 22.250)) 0 0 0 nil nil)
schCreateWireLabel(cv nil '(9.625 22.750) "POC" "lowerRight" "R90" "stick" 0.0625 nil)
schCreateWire(cv "route" "full" '((9.000 24.000) (9.000 24.750)) 0 0 0 nil nil)
schCreateWireLabel(cv nil '(9.000 24.250) "VIOL" "lowerLeft" "R90" "stick" 0.0625 nil)
schCreatePin(cv nil "VIOL" "inputOutput" nil '(9.000 24.750) "R270")
schCreateWire(cv "route" "full" '((9.250 23.000) (9.250 22.250)) 0 0 0 nil nil)
schCreateWireLabel(cv nil '(9.250 22.750) "GIOL" "lowerRight" "R90" "stick" 0.0625 nil)
schCreateWire(cv "route" "full" '((9.062 23.000) (9.062 22.250)) 0 0 0 nil nil)
schCreateWireLabel(cv nil '(9.062 22.750) "VIOH" "lowerRight" "R90" "stick" 0.0625 nil)
schCreateWire(cv "route" "full" '((8.688 23.000) (8.688 22.250)) 0 0 0 nil nil)
schCreateWireLabel(cv nil '(8.688 22.750) "GIOH" "lowerRight" "R90" "stick" 0.0625 nil)
pvss1dgz_v_gMaster = dbOpenCellView("tphn28hpcpgv18" "PVSS1DGZ_V_G" "symbol")
dbCreateInst(cv pvss1dgz_v_gMaster "GIOL_top7" '(8.0 24.0) "R180")
schCreateWire(cv "route" "full" '((7.625 23.000) (7.625 22.250)) 0 0 0 nil nil)
schCreateWireLabel(cv nil '(7.625 22.750) "POC" "lowerRight" "R90" "stick" 0.0625 nil)
schCreateWire(cv "route" "full" '((7.438 23.000) (7.438 22.250)) 0 0 0 nil nil)
schCreateWireLabel(cv nil '(7.438 22.750) "VIOL" "lowerRight" "R90" "stick" 0.0625 nil)
schCreateWire(cv "route" "full" '((7.000 24.000) (7.000 24.750)) 0 0 0 nil nil)
schCreateWireLabel(cv nil '(7.000 24.250) "GIOL" "lowerLeft" "R90" "stick" 0.0625 nil)
schCreatePin(cv nil "GIOL" "inputOutput" nil '(7.000 24.750) "R270")
schCreateWire(cv "route" "full" '((7.062 23.000) (7.062 22.250)) 0 0 0 nil nil)
schCreateWireLabel(cv nil '(7.062 22.750) "VIOH" "lowerRight" "R90" "stick" 0.0625 nil)
schCreateWire(cv "route" "full" '((6.688 23.000) (6.688 22.250)) 0 0 0 nil nil)
schCreateWireLabel(cv nil '(6.688 22.750) "GIOH" "lowerRight" "R90" "stick" 0.0625 nil)
pvdd2poc_v_gMaster = dbOpenCellView("tphn28hpcpgv18" "PVDD2POC_V_G" "symbol")
dbCreateInst(cv pvdd2poc_v_gMaster "VIOH_top8" '(6.0 24.0) "R180")
schCreateWire(cv "route" "full" '((5.625 23.000) (5.625 22.250)) 0 0 0 nil nil)
schCreateWireLabel(cv nil '(5.625 22.750) "POC" "lowerRight" "R90" "stick" 0.0625 nil)
schCreateWire(cv "route" "full" '((5.438 23.000) (5.438 22.250)) 0 0 0 nil nil)
schCreateWireLabel(cv nil '(5.438 22.750) "VIOL" "lowerRight" "R90" "stick" 0.0625 nil)
schCreateWire(cv "route" "full" '((5.250 23.000) (5.250 22.250)) 0 0 0 nil nil)
schCreateWireLabel(cv nil '(5.250 22.750) "GIOL" "lowerRight" "R90" "stick" 0.0625 nil)
schCreateWire(cv "route" "full" '((5.000 24.000) (5.000 24.750)) 0 0 0 nil nil)
schCreateWireLabel(cv nil '(5.000 24.250) "VIOH" "lowerLeft" "R90" "stick" 0.0625 nil)
schCreatePin(cv nil "VIOH" "inputOutput" nil '(5.000 24.750) "R270")
schCreateWire(cv "route" "full" '((4.688 23.000) (4.688 22.250)) 0 0 0 nil nil)
schCreateWireLabel(cv nil '(4.688 22.750) "GIOH" "lowerRight" "R90" "stick" 0.0625 nil)
pvss2dgz_v_gMaster = dbOpenCellView("tphn28hpcpgv18" "PVSS2DGZ_V_G" "symbol")
dbCreateInst(cv pvss2dgz_v_gMaster "GIOH_top9" '(4.0 24.0) "R180")
schCreateWire(cv "route" "full" '((3.625 23.000) (3.625 22.250)) 0 0 0 nil nil)
schCreateWireLabel(cv nil '(3.625 22.750) "POC" "lowerRight" "R90" "stick" 0.0625 nil)
schCreateWire(cv "route" "full" '((3.438 23.000) (3.438 22.250)) 0 0 0 nil nil)
schCreateWireLabel(cv nil '(3.438 22.750) "VIOL" "lowerRight" "R90" "stick" 0.0625 nil)
schCreateWire(cv "route" "full" '((3.250 23.000) (3.250 22.250)) 0 0 0 nil nil)
schCreateWireLabel(cv nil '(3.250 22.750) "GIOL" "lowerRight" "R90" "stick" 0.0625 nil)
schCreateWire(cv "route" "full" '((3.062 23.000) (3.062 22.250)) 0 0 0 nil nil)
schCreateWireLabel(cv nil '(3.062 22.750) "VIOH" "lowerRight" "R90" "stick" 0.0625 nil)
schCreateWire(cv "route" "full" '((3.000 24.000) (3.000 24.750)) 0 0 0 nil nil)
schCreateWireLabel(cv nil '(3.000 24.250) "GIOH" "lowerLeft" "R90" "stick" 0.0625 nil)
schCreatePin(cv nil "GIOH" "inputOutput" nil '(3.000 24.750) "R270")
dbCreateInst(cv pvdd3ac_h_gMaster "VREF_CORE_left56" '(4.0 9.625) "R270")
schCreateWire(cv "route" "full" '((4.875 10.250) (5.625 10.250)) 0 0 0 nil nil)
schCreateWireLabel(cv nil '(5.125 10.250) "VREF_CORE_CORE" "lowerLeft" "R0" "stick" 0.0625 nil)
schCreatePin(cv nil "VREF_CORE_CORE" "inputOutput" nil '(5.625 10.250) "R180")
schCreateWire(cv "route" "full" '((4.875 9.875) (5.625 9.875)) 0 0 0 nil nil)
schCreateWireLabel(cv nil '(5.125 9.875) "AVSS" "lowerLeft" "R0" "stick" 0.0625 nil)
schCreateWire(cv "route" "full" '((4.875 9.500) (5.625 9.500)) 0 0 0 nil nil)
schCreateWireLabel(cv nil '(5.125 9.500) "GIOL" "lowerLeft" "R0" "stick" 0.0625 nil)
schCreateWire(cv "route" "full" '((4.000 9.813) (3.250 9.813)) 0 0 0 nil nil)
schCreateWireLabel(cv nil '(3.750 9.813) "AVDD" "lowerRight" "R0" "stick" 0.0625 nil)
schCreatePin(cv nil "AVDD" "inputOutput" nil '(3.250 9.813) "R0")
dbCreateInst(cv pvdd3ac_h_gMaster "VAMP_CORE_left01" '(4.0 19.625) "R270")
schCreateWire(cv "route" "full" '((4.875 20.250) (5.625 20.250)) 0 0 0 nil nil)
schCreateWireLabel(cv nil '(5.125 20.250) "VAMP_CORE_CORE" "lowerLeft" "R0" "stick" 0.0625 nil)
schCreatePin(cv nil "VAMP_CORE_CORE" "inputOutput" nil '(5.625 20.250) "R180")
schCreateWire(cv "route" "full" '((4.875 19.875) (5.625 19.875)) 0 0 0 nil nil)
schCreateWireLabel(cv nil '(5.125 19.875) "AVSS" "lowerLeft" "R0" "stick" 0.0625 nil)
schCreateWire(cv "route" "full" '((4.875 19.500) (5.625 19.500)) 0 0 0 nil nil)
schCreateWireLabel(cv nil '(5.125 19.500) "GIOL" "lowerLeft" "R0" "stick" 0.0625 nil)
schCreateWire(cv "route" "full" '((4.000 19.813) (3.250 19.813)) 0 0 0 nil nil)
schCreateWireLabel(cv nil '(3.750 19.813) "AVDD" "lowerRight" "R0" "stick" 0.0625 nil)
schCreatePin(cv nil "AVDD" "inputOutput" nil '(3.250 19.813) "R0")
dbCreateInst(cv pvdd3ac_h_gMaster "IBIAS_CORE_left23" '(4.0 15.625) "R270")
schCreateWire(cv "route" "full" '((4.875 16.250) (5.625 16.250)) 0 0 0 nil nil)
schCreateWireLabel(cv nil '(5.125 16.250) "IBIAS_CORE_CORE" "lowerLeft" "R0" "stick" 0.0625 nil)
schCreatePin(cv nil "IBIAS_CORE_CORE" "inputOutput" nil '(5.625 16.250) "R180")
schCreateWire(cv "route" "full" '((4.875 15.875) (5.625 15.875)) 0 0 0 nil nil)
schCreateWireLabel(cv nil '(5.125 15.875) "AVSS" "lowerLeft" "R0" "stick" 0.0625 nil)
schCreateWire(cv "route" "full" '((4.875 15.500) (5.625 15.500)) 0 0 0 nil nil)
schCreateWireLabel(cv nil '(5.125 15.500) "GIOL" "lowerLeft" "R0" "stick" 0.0625 nil)
schCreateWire(cv "route" "full" '((4.000 15.813) (3.250 15.813)) 0 0 0 nil nil)
schCreateWireLabel(cv nil '(3.750 15.813) "AVDD" "lowerRight" "R0" "stick" 0.0625 nil)
schCreatePin(cv nil "AVDD" "inputOutput" nil '(3.250 15.813) "R0")
dbCreateInst(cv pvdd3ac_v_gMaster "ADC_CORE_bottom67" '(16.375 4.0) "R0")
schCreateWire(cv "route" "full" '((15.750 4.875) (15.750 5.625)) 0 0 0 nil nil)
schCreateWireLabel(cv nil '(15.750 5.125) "ADC_CORE_CORE" "lowerLeft" "R90" "stick" 0.0625 nil)
schCreatePin(cv nil "ADC_CORE_CORE" "inputOutput" nil '(15.750 5.625) "R270")
schCreateWire(cv "route" "full" '((16.125 4.875) (16.125 5.625)) 0 0 0 nil nil)
schCreateWireLabel(cv nil '(16.125 5.125) "VSS_ADC" "lowerLeft" "R90" "stick" 0.0625 nil)
schCreateWire(cv "route" "full" '((16.500 4.875) (16.500 5.625)) 0 0 0 nil nil)
schCreateWireLabel(cv nil '(16.500 5.125) "GIOL" "lowerLeft" "R90" "stick" 0.0625 nil)
schCreateWire(cv "route" "full" '((16.187 4.000) (16.187 3.250)) 0 0 0 nil nil)
schCreateWireLabel(cv nil '(16.187 3.750) "VDD_ADC" "lowerRight" "R90" "stick" 0.0625 nil)
schCreatePin(cv nil "VDD_ADC" "inputOutput" nil '(16.187 3.250) "R90")
schCheck(cv)
dbSave(cv)
t
