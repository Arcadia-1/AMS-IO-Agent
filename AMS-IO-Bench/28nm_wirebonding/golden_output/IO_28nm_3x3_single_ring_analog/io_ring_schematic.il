pdb3ac_h_gMaster = dbOpenCellView("tphn28hpcpgv18" "PDB3AC_H_G" "symbol")
dbCreateInst(cv pdb3ac_h_gMaster "VCM_left0" '(0 6.8125) "R270")
schCreateWire(cv "route" "full" '((0.000 7.000) (-0.750 7.000)) 0 0 0 nil nil)
schCreateWireLabel(cv nil '(-0.250 7.000) "VCM" "lowerRight" "R0" "stick" 0.0625 nil)
schCreatePin(cv nil "VCM" "inputOutput" nil '(-0.750 7.000) "R0")
schCreateWire(cv "route" "full" '((0.875 7.062) (1.625 7.062)) 0 0 0 nil nil)
schCreateWireLabel(cv nil '(1.125 7.062) "VSSIB" "lowerLeft" "R0" "stick" 0.0625 nil)
schCreateWire(cv "route" "full" '((0.875 6.688) (1.625 6.688)) 0 0 0 nil nil)
schCreateWireLabel(cv nil '(1.125 6.688) "GIOL" "lowerLeft" "R0" "stick" 0.0625 nil)
schCreateWire(cv "route" "full" '((0.875 7.438) (1.625 7.438)) 0 0 0 nil nil)
schCreateWireLabel(cv nil '(1.125 7.438) "VDDIB" "lowerLeft" "R0" "stick" 0.0625 nil)
dbCreateInst(cv pdb3ac_h_gMaster "IBAMP_left1" '(0 4.8125) "R270")
schCreateWire(cv "route" "full" '((0.000 5.000) (-0.750 5.000)) 0 0 0 nil nil)
schCreateWireLabel(cv nil '(-0.250 5.000) "IBAMP" "lowerRight" "R0" "stick" 0.0625 nil)
schCreatePin(cv nil "IBAMP" "inputOutput" nil '(-0.750 5.000) "R0")
schCreateWire(cv "route" "full" '((0.875 5.062) (1.625 5.062)) 0 0 0 nil nil)
schCreateWireLabel(cv nil '(1.125 5.062) "VSSIB" "lowerLeft" "R0" "stick" 0.0625 nil)
schCreateWire(cv "route" "full" '((0.875 4.688) (1.625 4.688)) 0 0 0 nil nil)
schCreateWireLabel(cv nil '(1.125 4.688) "GIOL" "lowerLeft" "R0" "stick" 0.0625 nil)
schCreateWire(cv "route" "full" '((0.875 5.438) (1.625 5.438)) 0 0 0 nil nil)
schCreateWireLabel(cv nil '(1.125 5.438) "VDDIB" "lowerLeft" "R0" "stick" 0.0625 nil)
dbCreateInst(cv pdb3ac_h_gMaster "IBREF_left2" '(0 2.8125) "R270")
schCreateWire(cv "route" "full" '((0.000 3.001) (-0.750 3.001)) 0 0 0 nil nil)
schCreateWireLabel(cv nil '(-0.250 3.001) "IBREF" "lowerRight" "R0" "stick" 0.0625 nil)
schCreatePin(cv nil "IBREF" "inputOutput" nil '(-0.750 3.001) "R0")
schCreateWire(cv "route" "full" '((0.875 3.062) (1.625 3.062)) 0 0 0 nil nil)
schCreateWireLabel(cv nil '(1.125 3.062) "VSSIB" "lowerLeft" "R0" "stick" 0.0625 nil)
schCreateWire(cv "route" "full" '((0.875 2.688) (1.625 2.688)) 0 0 0 nil nil)
schCreateWireLabel(cv nil '(1.125 2.688) "GIOL" "lowerLeft" "R0" "stick" 0.0625 nil)
schCreateWire(cv "route" "full" '((0.875 3.438) (1.625 3.438)) 0 0 0 nil nil)
schCreateWireLabel(cv nil '(1.125 3.438) "VDDIB" "lowerLeft" "R0" "stick" 0.0625 nil)
pvdd1ac_v_gMaster = dbOpenCellView("tphn28hpcpgv18" "PVDD1AC_V_G" "symbol")
dbCreateInst(cv pvdd1ac_v_gMaster "AVDD_bottom0" '(3.1875 0) "R0")
schCreateWire(cv "route" "full" '((2.938 0.875) (2.938 1.625)) 0 0 0 nil nil)
schCreateWireLabel(cv nil '(2.938 1.125) "VSSIB" "lowerLeft" "R90" "stick" 0.0625 nil)
schCreateWire(cv "route" "full" '((3.312 0.875) (3.312 1.625)) 0 0 0 nil nil)
schCreateWireLabel(cv nil '(3.312 1.125) "GIOL" "lowerLeft" "R90" "stick" 0.0625 nil)
schCreateWire(cv "route" "full" '((2.999 0.000) (2.999 -0.750)) 0 0 0 nil nil)
schCreateWireLabel(cv nil '(2.999 -0.250) "AVDD" "lowerRight" "R90" "stick" 0.0625 nil)
schCreatePin(cv nil "AVDD" "inputOutput" nil '(2.999 -0.750) "R90")
schCreateWire(cv "route" "full" '((2.562 0.875) (2.562 1.625)) 0 0 0 nil nil)
schCreateWireLabel(cv nil '(2.562 1.125) "VDDIB" "lowerLeft" "R90" "stick" 0.0625 nil)
pvss1ac_v_gMaster = dbOpenCellView("tphn28hpcpgv18" "PVSS1AC_V_G" "symbol")
dbCreateInst(cv pvss1ac_v_gMaster "AVSS_bottom1" '(5.1875 0) "R0")
schCreateWire(cv "route" "full" '((5.000 0.000) (5.000 -0.750)) 0 0 0 nil nil)
schCreateWireLabel(cv nil '(5.000 -0.250) "AVSS" "lowerRight" "R90" "stick" 0.0625 nil)
schCreatePin(cv nil "AVSS" "inputOutput" nil '(5.000 -0.750) "R90")
schCreateWire(cv "route" "full" '((4.938 0.875) (4.938 1.625)) 0 0 0 nil nil)
schCreateWireLabel(cv nil '(4.938 1.125) "VSSIB" "lowerLeft" "R90" "stick" 0.0625 nil)
schCreateWire(cv "route" "full" '((5.312 0.875) (5.312 1.625)) 0 0 0 nil nil)
schCreateWireLabel(cv nil '(5.312 1.125) "GIOL" "lowerLeft" "R90" "stick" 0.0625 nil)
schCreateWire(cv "route" "full" '((4.562 0.875) (4.562 1.625)) 0 0 0 nil nil)
schCreateWireLabel(cv nil '(4.562 1.125) "VDDIB" "lowerLeft" "R90" "stick" 0.0625 nil)
pdb3ac_v_gMaster = dbOpenCellView("tphn28hpcpgv18" "PDB3AC_V_G" "symbol")
dbCreateInst(cv pdb3ac_v_gMaster "VIN_bottom2" '(7.1875 0) "R0")
schCreateWire(cv "route" "full" '((7.000 0.000) (7.000 -0.750)) 0 0 0 nil nil)
schCreateWireLabel(cv nil '(7.000 -0.250) "VIN" "lowerRight" "R90" "stick" 0.0625 nil)
schCreatePin(cv nil "VIN" "inputOutput" nil '(7.000 -0.750) "R90")
schCreateWire(cv "route" "full" '((6.938 0.875) (6.938 1.625)) 0 0 0 nil nil)
schCreateWireLabel(cv nil '(6.938 1.125) "VSSIB" "lowerLeft" "R90" "stick" 0.0625 nil)
schCreateWire(cv "route" "full" '((7.312 0.875) (7.312 1.625)) 0 0 0 nil nil)
schCreateWireLabel(cv nil '(7.312 1.125) "GIOL" "lowerLeft" "R90" "stick" 0.0625 nil)
schCreateWire(cv "route" "full" '((6.562 0.875) (6.562 1.625)) 0 0 0 nil nil)
schCreateWireLabel(cv nil '(6.562 1.125) "VDDIB" "lowerLeft" "R90" "stick" 0.0625 nil)
dbCreateInst(cv pdb3ac_h_gMaster "VIP_right0" '(10.0 3.1875) "R90")
schCreateWire(cv "route" "full" '((10.000 2.999) (10.750 2.999)) 0 0 0 nil nil)
schCreateWireLabel(cv nil '(10.250 2.999) "VIP" "lowerLeft" "R0" "stick" 0.0625 nil)
schCreatePin(cv nil "VIP" "inputOutput" nil '(10.750 2.999) "R180")
schCreateWire(cv "route" "full" '((9.125 2.938) (8.375 2.938)) 0 0 0 nil nil)
schCreateWireLabel(cv nil '(8.875 2.938) "VSSIB" "lowerRight" "R0" "stick" 0.0625 nil)
schCreateWire(cv "route" "full" '((9.125 3.312) (8.375 3.312)) 0 0 0 nil nil)
schCreateWireLabel(cv nil '(8.875 3.312) "GIOL" "lowerRight" "R0" "stick" 0.0625 nil)
schCreateWire(cv "route" "full" '((9.125 2.562) (8.375 2.562)) 0 0 0 nil nil)
schCreateWireLabel(cv nil '(8.875 2.562) "VDDIB" "lowerRight" "R0" "stick" 0.0625 nil)
dbCreateInst(cv pdb3ac_h_gMaster "VAMP_right1" '(10.0 5.1875) "R90")
schCreateWire(cv "route" "full" '((10.000 5.000) (10.750 5.000)) 0 0 0 nil nil)
schCreateWireLabel(cv nil '(10.250 5.000) "VAMP" "lowerLeft" "R0" "stick" 0.0625 nil)
schCreatePin(cv nil "VAMP" "inputOutput" nil '(10.750 5.000) "R180")
schCreateWire(cv "route" "full" '((9.125 4.938) (8.375 4.938)) 0 0 0 nil nil)
schCreateWireLabel(cv nil '(8.875 4.938) "VSSIB" "lowerRight" "R0" "stick" 0.0625 nil)
schCreateWire(cv "route" "full" '((9.125 5.312) (8.375 5.312)) 0 0 0 nil nil)
schCreateWireLabel(cv nil '(8.875 5.312) "GIOL" "lowerRight" "R0" "stick" 0.0625 nil)
schCreateWire(cv "route" "full" '((9.125 4.562) (8.375 4.562)) 0 0 0 nil nil)
schCreateWireLabel(cv nil '(8.875 4.562) "VDDIB" "lowerRight" "R0" "stick" 0.0625 nil)
dbCreateInst(cv pdb3ac_h_gMaster "IBAMP_right2" '(10.0 7.1875) "R90")
schCreateWire(cv "route" "full" '((10.000 7.000) (10.750 7.000)) 0 0 0 nil nil)
schCreateWireLabel(cv nil '(10.250 7.000) "IBAMP" "lowerLeft" "R0" "stick" 0.0625 nil)
schCreatePin(cv nil "IBAMP" "inputOutput" nil '(10.750 7.000) "R180")
schCreateWire(cv "route" "full" '((9.125 6.938) (8.375 6.938)) 0 0 0 nil nil)
schCreateWireLabel(cv nil '(8.875 6.938) "VSSIB" "lowerRight" "R0" "stick" 0.0625 nil)
schCreateWire(cv "route" "full" '((9.125 7.312) (8.375 7.312)) 0 0 0 nil nil)
schCreateWireLabel(cv nil '(8.875 7.312) "GIOL" "lowerRight" "R0" "stick" 0.0625 nil)
schCreateWire(cv "route" "full" '((9.125 6.562) (8.375 6.562)) 0 0 0 nil nil)
schCreateWireLabel(cv nil '(8.875 6.562) "VDDIB" "lowerRight" "R0" "stick" 0.0625 nil)
dbCreateInst(cv pdb3ac_v_gMaster "IBREF_top0" '(6.8125 10.0) "R180")
schCreateWire(cv "route" "full" '((7.000 10.000) (7.000 10.750)) 0 0 0 nil nil)
schCreateWireLabel(cv nil '(7.000 10.250) "IBREF" "lowerLeft" "R90" "stick" 0.0625 nil)
schCreatePin(cv nil "IBREF" "inputOutput" nil '(7.000 10.750) "R270")
schCreateWire(cv "route" "full" '((7.062 9.125) (7.062 8.375)) 0 0 0 nil nil)
schCreateWireLabel(cv nil '(7.062 8.875) "VSSIB" "lowerRight" "R90" "stick" 0.0625 nil)
schCreateWire(cv "route" "full" '((6.688 9.125) (6.688 8.375)) 0 0 0 nil nil)
schCreateWireLabel(cv nil '(6.688 8.875) "GIOL" "lowerRight" "R90" "stick" 0.0625 nil)
schCreateWire(cv "route" "full" '((7.438 9.125) (7.438 8.375)) 0 0 0 nil nil)
schCreateWireLabel(cv nil '(7.438 8.875) "VDDIB" "lowerRight" "R90" "stick" 0.0625 nil)
pvdd3ac_v_gMaster = dbOpenCellView("tphn28hpcpgv18" "PVDD3AC_V_G" "symbol")
dbCreateInst(cv pvdd3ac_v_gMaster "VDDIB_top1" '(4.8125 10.0) "R180")
schCreateWire(cv "route" "full" '((5.438 9.125) (5.438 8.375)) 0 0 0 nil nil)
schCreateWireLabel(cv nil '(5.438 8.875) "VDDIB_CORE" "lowerRight" "R90" "stick" 0.0625 nil)
schCreatePin(cv nil "VDDIB_CORE" "inputOutput" nil '(5.438 8.375) "R90")
schCreateWire(cv "route" "full" '((5.062 9.125) (5.062 8.375)) 0 0 0 nil nil)
schCreateWireLabel(cv nil '(5.062 8.875) "VSSIB" "lowerRight" "R90" "stick" 0.0625 nil)
schCreateWire(cv "route" "full" '((4.688 9.125) (4.688 8.375)) 0 0 0 nil nil)
schCreateWireLabel(cv nil '(4.688 8.875) "GIOL" "lowerRight" "R90" "stick" 0.0625 nil)
schCreateWire(cv "route" "full" '((5.000 10.000) (5.000 10.750)) 0 0 0 nil nil)
schCreateWireLabel(cv nil '(5.000 10.250) "VDDIB" "lowerLeft" "R90" "stick" 0.0625 nil)
schCreatePin(cv nil "VDDIB" "inputOutput" nil '(5.000 10.750) "R270")
pvss3ac_v_gMaster = dbOpenCellView("tphn28hpcpgv18" "PVSS3AC_V_G" "symbol")
dbCreateInst(cv pvss3ac_v_gMaster "VSSIB_top2" '(2.8125 10.0) "R180")
schCreateWire(cv "route" "full" '((3.001 10.000) (3.001 10.750)) 0 0 0 nil nil)
schCreateWireLabel(cv nil '(3.001 10.250) "VSSIB" "lowerLeft" "R90" "stick" 0.0625 nil)
schCreatePin(cv nil "VSSIB" "inputOutput" nil '(3.001 10.750) "R270")
schCreateWire(cv "route" "full" '((2.688 9.125) (2.688 8.375)) 0 0 0 nil nil)
schCreateWireLabel(cv nil '(2.688 8.875) "GIOL" "lowerRight" "R90" "stick" 0.0625 nil)
schCreateWire(cv "route" "full" '((3.438 9.125) (3.438 8.375)) 0 0 0 nil nil)
schCreateWireLabel(cv nil '(3.438 8.875) "VSSIB_CORE" "lowerRight" "R90" "stick" 0.0625 nil)
schCreatePin(cv nil "VSSIB_CORE" "inputOutput" nil '(3.438 8.375) "R90")
schCreateWire(cv "route" "full" '((3.062 9.125) (3.062 8.375)) 0 0 0 nil nil)
schCreateWireLabel(cv nil '(3.062 8.875) "VDDIB" "lowerRight" "R90" "stick" 0.0625 nil)
schCheck(cv)
dbSave(cv)
t
