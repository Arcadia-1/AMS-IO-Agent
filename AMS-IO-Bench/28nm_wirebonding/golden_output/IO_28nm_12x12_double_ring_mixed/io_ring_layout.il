; Generated Layout Script with Dual Ring Support

; ==================== All Components (Sorted by Placement Order) ====================
dbCreateParamInstByMasterName(cv "tphn28hpcpgv18" "PDDW16SDGZ_H_G" "layout" "D3_left_11" list(0 150) "R270")
dbCreateParamInstByMasterName(cv "PAD" "PAD60GU" "layout" "pad60gu_D3_left_11" list(0 150) "R270")
dbCreateParamInstByMasterName(cv "tphn28hpcpgv18" "PDDW16SDGZ_H_G" "layout" "D2_left_10" list(0 210) "R270")
dbCreateParamInstByMasterName(cv "PAD" "PAD60GU" "layout" "pad60gu_D2_left_10" list(0 210) "R270")
dbCreateParamInstByMasterName(cv "tphn28hpcpgv18" "PDDW16SDGZ_H_G" "layout" "D1_left_9" list(0 270) "R270")
dbCreateParamInstByMasterName(cv "PAD" "PAD60GU" "layout" "pad60gu_D1_left_9" list(0 270) "R270")
dbCreateParamInstByMasterName(cv "tphn28hpcpgv18" "PDDW16SDGZ_H_G" "layout" "D0_left_8" list(0 330) "R270")
dbCreateParamInstByMasterName(cv "PAD" "PAD60GU" "layout" "pad60gu_D0_left_8" list(0 330) "R270")
dbCreateParamInstByMasterName(cv "tphn28hpcpgv18" "PVSS3AC_H_G" "layout" "AVSS_left_7" list(0 390) "R270")
dbCreateParamInstByMasterName(cv "PAD" "PAD60GU" "layout" "pad60gu_AVSS_left_7" list(0 390) "R270")
dbCreateParamInstByMasterName(cv "tphn28hpcpgv18" "PVDD3AC_H_G" "layout" "AVDD_left_6" list(0 450) "R270")
dbCreateParamInstByMasterName(cv "PAD" "PAD60GU" "layout" "pad60gu_AVDD_left_6" list(0 450) "R270")
dbCreateParamInstByMasterName(cv "tphn28hpcpgv18" "PDB3AC_H_G" "layout" "VREF_left_5" list(0 510) "R270")
dbCreateParamInstByMasterName(cv "PAD" "PAD60GU" "layout" "pad60gu_VREF_left_5" list(0 510) "R270")
dbCreateParamInstByMasterName(cv "tphn28hpcpgv18" "PDB3AC_H_G" "layout" "VCM_left_4" list(0 570) "R270")
dbCreateParamInstByMasterName(cv "PAD" "PAD60GU" "layout" "pad60gu_VCM_left_4" list(0 570) "R270")
dbCreateParamInstByMasterName(cv "tphn28hpcpgv18" "PDB3AC_H_G" "layout" "VIM_left_3" list(0 630) "R270")
dbCreateParamInstByMasterName(cv "PAD" "PAD60GU" "layout" "pad60gu_VIM_left_3" list(0 630) "R270")
dbCreateParamInstByMasterName(cv "tphn28hpcpgv18" "PDB3AC_H_G" "layout" "VIP_left_2" list(0 690) "R270")
dbCreateParamInstByMasterName(cv "PAD" "PAD60GU" "layout" "pad60gu_VIP_left_2" list(0 690) "R270")
dbCreateParamInstByMasterName(cv "tphn28hpcpgv18" "PDB3AC_H_G" "layout" "VINN_left_1" list(0 750) "R270")
dbCreateParamInstByMasterName(cv "PAD" "PAD60GU" "layout" "pad60gu_VINN_left_1" list(0 750) "R270")
dbCreateParamInstByMasterName(cv "tphn28hpcpgv18" "PDB3AC_H_G" "layout" "VINP_left_0" list(0 810) "R270")
dbCreateParamInstByMasterName(cv "PAD" "PAD60GU" "layout" "pad60gu_VINP_left_0" list(0 810) "R270")
dbCreateParamInstByMasterName(cv "tphn28hpcpgv18" "PCORNERA_G" "layout" "CORNER_TL_top_left" list(0 940) "R270")
dbCreateParamInstByMasterName(cv "tphn28hpcpgv18" "PDDW16SDGZ_V_G" "layout" "D15_bottom_11" list(790 0) "R0")
dbCreateParamInstByMasterName(cv "PAD" "PAD60GU" "layout" "pad60gu_D15_bottom_11" list(790 0) "R0")
dbCreateParamInstByMasterName(cv "tphn28hpcpgv18" "PDDW16SDGZ_V_G" "layout" "D14_bottom_10" list(730 0) "R0")
dbCreateParamInstByMasterName(cv "PAD" "PAD60GU" "layout" "pad60gu_D14_bottom_10" list(730 0) "R0")
dbCreateParamInstByMasterName(cv "tphn28hpcpgv18" "PDDW16SDGZ_V_G" "layout" "D13_bottom_9" list(670 0) "R0")
dbCreateParamInstByMasterName(cv "PAD" "PAD60GU" "layout" "pad60gu_D13_bottom_9" list(670 0) "R0")
dbCreateParamInstByMasterName(cv "tphn28hpcpgv18" "PDDW16SDGZ_V_G" "layout" "D12_bottom_8" list(610 0) "R0")
dbCreateParamInstByMasterName(cv "PAD" "PAD60GU" "layout" "pad60gu_D12_bottom_8" list(610 0) "R0")
dbCreateParamInstByMasterName(cv "tphn28hpcpgv18" "PDDW16SDGZ_V_G" "layout" "D11_bottom_7" list(550 0) "R0")
dbCreateParamInstByMasterName(cv "PAD" "PAD60GU" "layout" "pad60gu_D11_bottom_7" list(550 0) "R0")
dbCreateParamInstByMasterName(cv "tphn28hpcpgv18" "PDDW16SDGZ_V_G" "layout" "D10_bottom_6" list(490 0) "R0")
dbCreateParamInstByMasterName(cv "PAD" "PAD60GU" "layout" "pad60gu_D10_bottom_6" list(490 0) "R0")
dbCreateParamInstByMasterName(cv "tphn28hpcpgv18" "PDDW16SDGZ_V_G" "layout" "D9_bottom_5" list(430 0) "R0")
dbCreateParamInstByMasterName(cv "PAD" "PAD60GU" "layout" "pad60gu_D9_bottom_5" list(430 0) "R0")
dbCreateParamInstByMasterName(cv "tphn28hpcpgv18" "PDDW16SDGZ_V_G" "layout" "D8_bottom_4" list(370 0) "R0")
dbCreateParamInstByMasterName(cv "PAD" "PAD60GU" "layout" "pad60gu_D8_bottom_4" list(370 0) "R0")
dbCreateParamInstByMasterName(cv "tphn28hpcpgv18" "PDDW16SDGZ_V_G" "layout" "D7_bottom_3" list(310 0) "R0")
dbCreateParamInstByMasterName(cv "PAD" "PAD60GU" "layout" "pad60gu_D7_bottom_3" list(310 0) "R0")
dbCreateParamInstByMasterName(cv "tphn28hpcpgv18" "PDDW16SDGZ_V_G" "layout" "D6_bottom_2" list(250 0) "R0")
dbCreateParamInstByMasterName(cv "PAD" "PAD60GU" "layout" "pad60gu_D6_bottom_2" list(250 0) "R0")
dbCreateParamInstByMasterName(cv "tphn28hpcpgv18" "PDDW16SDGZ_V_G" "layout" "D5_bottom_1" list(190 0) "R0")
dbCreateParamInstByMasterName(cv "PAD" "PAD60GU" "layout" "pad60gu_D5_bottom_1" list(190 0) "R0")
dbCreateParamInstByMasterName(cv "tphn28hpcpgv18" "PDDW16SDGZ_V_G" "layout" "D4_bottom_0" list(130 0) "R0")
dbCreateParamInstByMasterName(cv "PAD" "PAD60GU" "layout" "pad60gu_D4_bottom_0" list(130 0) "R0")
dbCreateParamInstByMasterName(cv "tphn28hpcpgv18" "PCORNER_G" "layout" "CORNER_BL_bottom_left" list(0 0) "R0")
dbCreateParamInstByMasterName(cv "tphn28hpcpgv18" "PDDW16SDGZ_H_G" "layout" "D27_right_11" list(940 790) "R90")
dbCreateParamInstByMasterName(cv "PAD" "PAD60GU" "layout" "pad60gu_D27_right_11" list(940 790) "R90")
dbCreateParamInstByMasterName(cv "tphn28hpcpgv18" "PDDW16SDGZ_H_G" "layout" "D26_right_10" list(940 730) "R90")
dbCreateParamInstByMasterName(cv "PAD" "PAD60GU" "layout" "pad60gu_D26_right_10" list(940 730) "R90")
dbCreateParamInstByMasterName(cv "tphn28hpcpgv18" "PDDW16SDGZ_H_G" "layout" "D25_right_9" list(940 670) "R90")
dbCreateParamInstByMasterName(cv "PAD" "PAD60GU" "layout" "pad60gu_D25_right_9" list(940 670) "R90")
dbCreateParamInstByMasterName(cv "tphn28hpcpgv18" "PDDW16SDGZ_H_G" "layout" "D24_right_8" list(940 610) "R90")
dbCreateParamInstByMasterName(cv "PAD" "PAD60GU" "layout" "pad60gu_D24_right_8" list(940 610) "R90")
dbCreateParamInstByMasterName(cv "tphn28hpcpgv18" "PDDW16SDGZ_H_G" "layout" "D23_right_7" list(940 550) "R90")
dbCreateParamInstByMasterName(cv "PAD" "PAD60GU" "layout" "pad60gu_D23_right_7" list(940 550) "R90")
dbCreateParamInstByMasterName(cv "tphn28hpcpgv18" "PDDW16SDGZ_H_G" "layout" "D22_right_6" list(940 490) "R90")
dbCreateParamInstByMasterName(cv "PAD" "PAD60GU" "layout" "pad60gu_D22_right_6" list(940 490) "R90")
dbCreateParamInstByMasterName(cv "tphn28hpcpgv18" "PDDW16SDGZ_H_G" "layout" "D21_right_5" list(940 430) "R90")
dbCreateParamInstByMasterName(cv "PAD" "PAD60GU" "layout" "pad60gu_D21_right_5" list(940 430) "R90")
dbCreateParamInstByMasterName(cv "tphn28hpcpgv18" "PDDW16SDGZ_H_G" "layout" "D20_right_4" list(940 370) "R90")
dbCreateParamInstByMasterName(cv "PAD" "PAD60GU" "layout" "pad60gu_D20_right_4" list(940 370) "R90")
dbCreateParamInstByMasterName(cv "tphn28hpcpgv18" "PDDW16SDGZ_H_G" "layout" "D19_right_3" list(940 310) "R90")
dbCreateParamInstByMasterName(cv "PAD" "PAD60GU" "layout" "pad60gu_D19_right_3" list(940 310) "R90")
dbCreateParamInstByMasterName(cv "tphn28hpcpgv18" "PDDW16SDGZ_H_G" "layout" "D18_right_2" list(940 250) "R90")
dbCreateParamInstByMasterName(cv "PAD" "PAD60GU" "layout" "pad60gu_D18_right_2" list(940 250) "R90")
dbCreateParamInstByMasterName(cv "tphn28hpcpgv18" "PDDW16SDGZ_H_G" "layout" "D17_right_1" list(940 190) "R90")
dbCreateParamInstByMasterName(cv "PAD" "PAD60GU" "layout" "pad60gu_D17_right_1" list(940 190) "R90")
dbCreateParamInstByMasterName(cv "tphn28hpcpgv18" "PDDW16SDGZ_H_G" "layout" "D16_right_0" list(940 130) "R90")
dbCreateParamInstByMasterName(cv "PAD" "PAD60GU" "layout" "pad60gu_D16_right_0" list(940 130) "R90")
dbCreateParamInstByMasterName(cv "tphn28hpcpgv18" "PCORNER_G" "layout" "CORNER_BR_bottom_right" list(940 0) "R90")
dbCreateParamInstByMasterName(cv "tphn28hpcpgv18" "PVSS2DGZ_V_G" "layout" "GIOH_top_11" list(150 940) "R180")
dbCreateParamInstByMasterName(cv "PAD" "PAD60GU" "layout" "pad60gu_GIOH_top_11" list(150 940) "R180")
dbCreateParamInstByMasterName(cv "tphn28hpcpgv18" "PVDD2POC_V_G" "layout" "VIOH_top_10" list(210 940) "R180")
dbCreateParamInstByMasterName(cv "PAD" "PAD60GU" "layout" "pad60gu_VIOH_top_10" list(210 940) "R180")
dbCreateParamInstByMasterName(cv "tphn28hpcpgv18" "PVSS1DGZ_V_G" "layout" "GIOL_top_9" list(270 940) "R180")
dbCreateParamInstByMasterName(cv "PAD" "PAD60GU" "layout" "pad60gu_GIOL_top_9" list(270 940) "R180")
dbCreateParamInstByMasterName(cv "tphn28hpcpgv18" "PVDD1DGZ_V_G" "layout" "VIOL_top_8" list(330 940) "R180")
dbCreateParamInstByMasterName(cv "PAD" "PAD60GU" "layout" "pad60gu_VIOL_top_8" list(330 940) "R180")
dbCreateParamInstByMasterName(cv "tphn28hpcpgv18" "PDDW16SDGZ_V_G" "layout" "D35_top_7" list(390 940) "R180")
dbCreateParamInstByMasterName(cv "PAD" "PAD60GU" "layout" "pad60gu_D35_top_7" list(390 940) "R180")
dbCreateParamInstByMasterName(cv "tphn28hpcpgv18" "PDDW16SDGZ_V_G" "layout" "D34_top_6" list(450 940) "R180")
dbCreateParamInstByMasterName(cv "PAD" "PAD60GU" "layout" "pad60gu_D34_top_6" list(450 940) "R180")
dbCreateParamInstByMasterName(cv "tphn28hpcpgv18" "PDDW16SDGZ_V_G" "layout" "D33_top_5" list(510 940) "R180")
dbCreateParamInstByMasterName(cv "PAD" "PAD60GU" "layout" "pad60gu_D33_top_5" list(510 940) "R180")
dbCreateParamInstByMasterName(cv "tphn28hpcpgv18" "PDDW16SDGZ_V_G" "layout" "D32_top_4" list(570 940) "R180")
dbCreateParamInstByMasterName(cv "PAD" "PAD60GU" "layout" "pad60gu_D32_top_4" list(570 940) "R180")
dbCreateParamInstByMasterName(cv "tphn28hpcpgv18" "PDDW16SDGZ_V_G" "layout" "D31_top_3" list(630 940) "R180")
dbCreateParamInstByMasterName(cv "PAD" "PAD60GU" "layout" "pad60gu_D31_top_3" list(630 940) "R180")
dbCreateParamInstByMasterName(cv "tphn28hpcpgv18" "PDDW16SDGZ_V_G" "layout" "D30_top_2" list(690 940) "R180")
dbCreateParamInstByMasterName(cv "PAD" "PAD60GU" "layout" "pad60gu_D30_top_2" list(690 940) "R180")
dbCreateParamInstByMasterName(cv "tphn28hpcpgv18" "PDDW16SDGZ_V_G" "layout" "D29_top_1" list(750 940) "R180")
dbCreateParamInstByMasterName(cv "PAD" "PAD60GU" "layout" "pad60gu_D29_top_1" list(750 940) "R180")
dbCreateParamInstByMasterName(cv "tphn28hpcpgv18" "PDDW16SDGZ_V_G" "layout" "D28_top_0" list(810 940) "R180")
dbCreateParamInstByMasterName(cv "PAD" "PAD60GU" "layout" "pad60gu_D28_top_0" list(810 940) "R180")
dbCreateParamInstByMasterName(cv "tphn28hpcpgv18" "PCORNER_G" "layout" "CORNER_TR_top_right" list(940 940) "R180")

; ==================== Inner Ring Pads ====================
dbCreateParamInstByMasterName(cv "tphn28hpcpgv18" "PDB3AC_H_G" "layout" "inner_pad_VREF_CORE_left_4_5" list(0 540) "R270")
dbCreateParamInstByMasterName(cv "PAD" "PAD60NU" "layout" "inner_pad60nu_VREF_CORE_left_4_5" list(0 540) "R270")
dbCreateParamInstByMasterName(cv "tphn28hpcpgv18" "PDB3AC_H_G" "layout" "inner_pad_VAMP_CORE_left_0_1" list(0 780) "R270")
dbCreateParamInstByMasterName(cv "PAD" "PAD60NU" "layout" "inner_pad60nu_VAMP_CORE_left_0_1" list(0 780) "R270")
dbCreateParamInstByMasterName(cv "tphn28hpcpgv18" "PDB3AC_H_G" "layout" "inner_pad_IBIAS_CORE_left_2_3" list(0 660) "R270")
dbCreateParamInstByMasterName(cv "PAD" "PAD60NU" "layout" "inner_pad60nu_IBIAS_CORE_left_2_3" list(0 660) "R270")

; ==================== Filler Components ====================
dbCreateParamInstByMasterName(cv "tphn28hpcpgv18" "PFILLER20_G" "layout" "sep_bottom_right_corner" list(810 0) "R0")
dbCreateParamInstByMasterName(cv "tphn28hpcpgv18" "PFILLER20_G" "layout" "filler_bottom_left_corner" list(110 0) "R0")
dbCreateParamInstByMasterName(cv "tphn28hpcpgv18" "PFILLER20_G" "layout" "filler_R0_1_1" list(770 0) "R0")
dbCreateParamInstByMasterName(cv "tphn28hpcpgv18" "PFILLER20_G" "layout" "filler_R0_1_2" list(750 0) "R0")
dbCreateParamInstByMasterName(cv "tphn28hpcpgv18" "PFILLER20_G" "layout" "filler_R0_2_1" list(710 0) "R0")
dbCreateParamInstByMasterName(cv "tphn28hpcpgv18" "PFILLER20_G" "layout" "filler_R0_2_2" list(690 0) "R0")
dbCreateParamInstByMasterName(cv "tphn28hpcpgv18" "PFILLER20_G" "layout" "filler_R0_3_1" list(650 0) "R0")
dbCreateParamInstByMasterName(cv "tphn28hpcpgv18" "PFILLER20_G" "layout" "filler_R0_3_2" list(630 0) "R0")
dbCreateParamInstByMasterName(cv "tphn28hpcpgv18" "PFILLER20_G" "layout" "filler_R0_4_1" list(590 0) "R0")
dbCreateParamInstByMasterName(cv "tphn28hpcpgv18" "PFILLER20_G" "layout" "filler_R0_4_2" list(570 0) "R0")
dbCreateParamInstByMasterName(cv "tphn28hpcpgv18" "PFILLER20_G" "layout" "filler_R0_5_1" list(530 0) "R0")
dbCreateParamInstByMasterName(cv "tphn28hpcpgv18" "PFILLER20_G" "layout" "filler_R0_5_2" list(510 0) "R0")
dbCreateParamInstByMasterName(cv "tphn28hpcpgv18" "PFILLER20_G" "layout" "filler_R0_6_1" list(470 0) "R0")
dbCreateParamInstByMasterName(cv "tphn28hpcpgv18" "PFILLER20_G" "layout" "filler_R0_6_2" list(450 0) "R0")
dbCreateParamInstByMasterName(cv "tphn28hpcpgv18" "PFILLER20_G" "layout" "filler_R0_7_1" list(410 0) "R0")
dbCreateParamInstByMasterName(cv "tphn28hpcpgv18" "PFILLER20_G" "layout" "filler_R0_7_2" list(390 0) "R0")
dbCreateParamInstByMasterName(cv "tphn28hpcpgv18" "PFILLER20_G" "layout" "filler_R0_8_1" list(350 0) "R0")
dbCreateParamInstByMasterName(cv "tphn28hpcpgv18" "PFILLER20_G" "layout" "filler_R0_8_2" list(330 0) "R0")
dbCreateParamInstByMasterName(cv "tphn28hpcpgv18" "PFILLER20_G" "layout" "filler_R0_9_1" list(290 0) "R0")
dbCreateParamInstByMasterName(cv "tphn28hpcpgv18" "PFILLER20_G" "layout" "filler_R0_9_2" list(270 0) "R0")
dbCreateParamInstByMasterName(cv "tphn28hpcpgv18" "PFILLER20_G" "layout" "filler_R0_10_1" list(230 0) "R0")
dbCreateParamInstByMasterName(cv "tphn28hpcpgv18" "PFILLER20_G" "layout" "filler_R0_10_2" list(210 0) "R0")
dbCreateParamInstByMasterName(cv "tphn28hpcpgv18" "PFILLER20_G" "layout" "filler_R0_11_1" list(170 0) "R0")
dbCreateParamInstByMasterName(cv "tphn28hpcpgv18" "PFILLER20_G" "layout" "filler_R0_11_2" list(150 0) "R0")
dbCreateParamInstByMasterName(cv "tphn28hpcpgv18" "PFILLER20_G" "layout" "filler_right_top_corner" list(940 810) "R90")
dbCreateParamInstByMasterName(cv "tphn28hpcpgv18" "PFILLER20_G" "layout" "filler_right_bottom_corner" list(940 110) "R90")
dbCreateParamInstByMasterName(cv "tphn28hpcpgv18" "PFILLER20_G" "layout" "filler_R90_1_1" list(940 770) "R90")
dbCreateParamInstByMasterName(cv "tphn28hpcpgv18" "PFILLER20_G" "layout" "filler_R90_1_2" list(940 750) "R90")
dbCreateParamInstByMasterName(cv "tphn28hpcpgv18" "PFILLER20_G" "layout" "filler_R90_2_1" list(940 710) "R90")
dbCreateParamInstByMasterName(cv "tphn28hpcpgv18" "PFILLER20_G" "layout" "filler_R90_2_2" list(940 690) "R90")
dbCreateParamInstByMasterName(cv "tphn28hpcpgv18" "PFILLER20_G" "layout" "filler_R90_3_1" list(940 650) "R90")
dbCreateParamInstByMasterName(cv "tphn28hpcpgv18" "PFILLER20_G" "layout" "filler_R90_3_2" list(940 630) "R90")
dbCreateParamInstByMasterName(cv "tphn28hpcpgv18" "PFILLER20_G" "layout" "filler_R90_4_1" list(940 590) "R90")
dbCreateParamInstByMasterName(cv "tphn28hpcpgv18" "PFILLER20_G" "layout" "filler_R90_4_2" list(940 570) "R90")
dbCreateParamInstByMasterName(cv "tphn28hpcpgv18" "PFILLER20_G" "layout" "filler_R90_5_1" list(940 530) "R90")
dbCreateParamInstByMasterName(cv "tphn28hpcpgv18" "PFILLER20_G" "layout" "filler_R90_5_2" list(940 510) "R90")
dbCreateParamInstByMasterName(cv "tphn28hpcpgv18" "PFILLER20_G" "layout" "filler_R90_6_1" list(940 470) "R90")
dbCreateParamInstByMasterName(cv "tphn28hpcpgv18" "PFILLER20_G" "layout" "filler_R90_6_2" list(940 450) "R90")
dbCreateParamInstByMasterName(cv "tphn28hpcpgv18" "PFILLER20_G" "layout" "filler_R90_7_1" list(940 410) "R90")
dbCreateParamInstByMasterName(cv "tphn28hpcpgv18" "PFILLER20_G" "layout" "filler_R90_7_2" list(940 390) "R90")
dbCreateParamInstByMasterName(cv "tphn28hpcpgv18" "PFILLER20_G" "layout" "filler_R90_8_1" list(940 350) "R90")
dbCreateParamInstByMasterName(cv "tphn28hpcpgv18" "PFILLER20_G" "layout" "filler_R90_8_2" list(940 330) "R90")
dbCreateParamInstByMasterName(cv "tphn28hpcpgv18" "PFILLER20_G" "layout" "filler_R90_9_1" list(940 290) "R90")
dbCreateParamInstByMasterName(cv "tphn28hpcpgv18" "PFILLER20_G" "layout" "filler_R90_9_2" list(940 270) "R90")
dbCreateParamInstByMasterName(cv "tphn28hpcpgv18" "PFILLER20_G" "layout" "filler_R90_10_1" list(940 230) "R90")
dbCreateParamInstByMasterName(cv "tphn28hpcpgv18" "PFILLER20_G" "layout" "filler_R90_10_2" list(940 210) "R90")
dbCreateParamInstByMasterName(cv "tphn28hpcpgv18" "PFILLER20_G" "layout" "filler_R90_11_1" list(940 170) "R90")
dbCreateParamInstByMasterName(cv "tphn28hpcpgv18" "PFILLER20_G" "layout" "filler_R90_11_2" list(940 150) "R90")
dbCreateParamInstByMasterName(cv "tphn28hpcpgv18" "PRCUTA_G" "layout" "sep_top_left_corner" list(130 940) "R180")
dbCreateParamInstByMasterName(cv "tphn28hpcpgv18" "PFILLER20_G" "layout" "filler_top_right_corner" list(830 940) "R180")
dbCreateParamInstByMasterName(cv "tphn28hpcpgv18" "PFILLER20_G" "layout" "filler_R180_1_1" list(170 940) "R180")
dbCreateParamInstByMasterName(cv "tphn28hpcpgv18" "PFILLER20_G" "layout" "filler_R180_1_2" list(190 940) "R180")
dbCreateParamInstByMasterName(cv "tphn28hpcpgv18" "PFILLER20_G" "layout" "filler_R180_2_1" list(230 940) "R180")
dbCreateParamInstByMasterName(cv "tphn28hpcpgv18" "PFILLER20_G" "layout" "filler_R180_2_2" list(250 940) "R180")
dbCreateParamInstByMasterName(cv "tphn28hpcpgv18" "PFILLER20_G" "layout" "filler_R180_3_1" list(290 940) "R180")
dbCreateParamInstByMasterName(cv "tphn28hpcpgv18" "PFILLER20_G" "layout" "filler_R180_3_2" list(310 940) "R180")
dbCreateParamInstByMasterName(cv "tphn28hpcpgv18" "PFILLER20_G" "layout" "filler_R180_4_1" list(350 940) "R180")
dbCreateParamInstByMasterName(cv "tphn28hpcpgv18" "PFILLER20_G" "layout" "filler_R180_4_2" list(370 940) "R180")
dbCreateParamInstByMasterName(cv "tphn28hpcpgv18" "PFILLER20_G" "layout" "filler_R180_5_1" list(410 940) "R180")
dbCreateParamInstByMasterName(cv "tphn28hpcpgv18" "PFILLER20_G" "layout" "filler_R180_5_2" list(430 940) "R180")
dbCreateParamInstByMasterName(cv "tphn28hpcpgv18" "PFILLER20_G" "layout" "filler_R180_6_1" list(470 940) "R180")
dbCreateParamInstByMasterName(cv "tphn28hpcpgv18" "PFILLER20_G" "layout" "filler_R180_6_2" list(490 940) "R180")
dbCreateParamInstByMasterName(cv "tphn28hpcpgv18" "PFILLER20_G" "layout" "filler_R180_7_1" list(530 940) "R180")
dbCreateParamInstByMasterName(cv "tphn28hpcpgv18" "PFILLER20_G" "layout" "filler_R180_7_2" list(550 940) "R180")
dbCreateParamInstByMasterName(cv "tphn28hpcpgv18" "PFILLER20_G" "layout" "filler_R180_8_1" list(590 940) "R180")
dbCreateParamInstByMasterName(cv "tphn28hpcpgv18" "PFILLER20_G" "layout" "filler_R180_8_2" list(610 940) "R180")
dbCreateParamInstByMasterName(cv "tphn28hpcpgv18" "PFILLER20_G" "layout" "filler_R180_9_1" list(650 940) "R180")
dbCreateParamInstByMasterName(cv "tphn28hpcpgv18" "PFILLER20_G" "layout" "filler_R180_9_2" list(670 940) "R180")
dbCreateParamInstByMasterName(cv "tphn28hpcpgv18" "PFILLER20_G" "layout" "filler_R180_10_1" list(710 940) "R180")
dbCreateParamInstByMasterName(cv "tphn28hpcpgv18" "PFILLER20_G" "layout" "filler_R180_10_2" list(730 940) "R180")
dbCreateParamInstByMasterName(cv "tphn28hpcpgv18" "PFILLER20_G" "layout" "filler_R180_11_1" list(770 940) "R180")
dbCreateParamInstByMasterName(cv "tphn28hpcpgv18" "PFILLER20_G" "layout" "filler_R180_11_2" list(790 940) "R180")
dbCreateParamInstByMasterName(cv "tphn28hpcpgv18" "PFILLER20_G" "layout" "filler_left_bottom_corner" list(0 130) "R270")
dbCreateParamInstByMasterName(cv "tphn28hpcpgv18" "PRCUTA_G" "layout" "sep_left_top_corner" list(0 830) "R270")
dbCreateParamInstByMasterName(cv "tphn28hpcpgv18" "PFILLER20_G" "layout" "filler_R270_1_1" list(0 170) "R270")
dbCreateParamInstByMasterName(cv "tphn28hpcpgv18" "PFILLER20_G" "layout" "filler_R270_1_2" list(0 190) "R270")
dbCreateParamInstByMasterName(cv "tphn28hpcpgv18" "PFILLER20_G" "layout" "filler_R270_2_1" list(0 230) "R270")
dbCreateParamInstByMasterName(cv "tphn28hpcpgv18" "PFILLER20_G" "layout" "filler_R270_2_2" list(0 250) "R270")
dbCreateParamInstByMasterName(cv "tphn28hpcpgv18" "PFILLER20_G" "layout" "filler_R270_3_1" list(0 290) "R270")
dbCreateParamInstByMasterName(cv "tphn28hpcpgv18" "PFILLER20_G" "layout" "filler_R270_3_2" list(0 310) "R270")
dbCreateParamInstByMasterName(cv "tphn28hpcpgv18" "PRCUTA_G" "layout" "filler_R270_4_1" list(0 350) "R270")
dbCreateParamInstByMasterName(cv "tphn28hpcpgv18" "PRCUTA_G" "layout" "filler_R270_4_2" list(0 370) "R270")
dbCreateParamInstByMasterName(cv "tphn28hpcpgv18" "PFILLER20A_G" "layout" "filler_R270_5_1" list(0 410) "R270")
dbCreateParamInstByMasterName(cv "tphn28hpcpgv18" "PFILLER20A_G" "layout" "filler_R270_5_2" list(0 430) "R270")
dbCreateParamInstByMasterName(cv "tphn28hpcpgv18" "PFILLER20A_G" "layout" "filler_R270_6_1" list(0 470) "R270")
dbCreateParamInstByMasterName(cv "tphn28hpcpgv18" "PFILLER20A_G" "layout" "filler_R270_6_2" list(0 490) "R270")
dbCreateParamInstByMasterName(cv "tphn28hpcpgv18" "PFILLER10A_G" "layout" "filler_R270_7_1" list(0 520) "R270")
dbCreateParamInstByMasterName(cv "tphn28hpcpgv18" "PFILLER10A_G" "layout" "filler_R270_7_2" list(0 550) "R270")
dbCreateParamInstByMasterName(cv "tphn28hpcpgv18" "PFILLER20A_G" "layout" "filler_R270_8_1" list(0 590) "R270")
dbCreateParamInstByMasterName(cv "tphn28hpcpgv18" "PFILLER20A_G" "layout" "filler_R270_8_2" list(0 610) "R270")
dbCreateParamInstByMasterName(cv "tphn28hpcpgv18" "PFILLER10A_G" "layout" "filler_R270_9_1" list(0 640) "R270")
dbCreateParamInstByMasterName(cv "tphn28hpcpgv18" "PFILLER10A_G" "layout" "filler_R270_9_2" list(0 670) "R270")
dbCreateParamInstByMasterName(cv "tphn28hpcpgv18" "PFILLER20A_G" "layout" "filler_R270_10_1" list(0 710) "R270")
dbCreateParamInstByMasterName(cv "tphn28hpcpgv18" "PFILLER20A_G" "layout" "filler_R270_10_2" list(0 730) "R270")
dbCreateParamInstByMasterName(cv "tphn28hpcpgv18" "PFILLER10A_G" "layout" "filler_R270_11_1" list(0 760) "R270")
dbCreateParamInstByMasterName(cv "tphn28hpcpgv18" "PFILLER10A_G" "layout" "filler_R270_11_2" list(0 790) "R270")

; ==================== Digital IO Features (with Inner Pad Support) ====================
dbCreatePath(cv list("M3" "drawing") list(list(130 110.5) list(810 110.5)) 0.2)
dbCreatePath(cv list("M3" "drawing") list(list(130 109.24) list(810 109.24)) 0.2)
dbCreatePath(cv list("M3" "drawing") list(list(829.5 130) list(829.5 810)) 0.2)
dbCreatePath(cv list("M3" "drawing") list(list(830.76 130) list(830.76 810)) 0.2)
dbCreatePath(cv list("M3" "drawing") list(list(130 829.5) list(810 829.5)) 0.2)
dbCreatePath(cv list("M3" "drawing") list(list(130 830.76) list(810 830.76)) 0.2)
dbCreatePath(cv list("M3" "drawing") list(list(110.5 130) list(110.5 330)) 0.2)
dbCreatePath(cv list("M3" "drawing") list(list(109.24 130) list(109.24 330)) 0.2)
dbCreatePath(cv list("M3" "drawing") list(list(130 829.5) list(110.5 829.5)) 0.2 "extendExtend")
dbCreatePath(cv list("M3" "drawing") list(list(110.5 829.5) list(110.5 330)) 0.2 "extendExtend")
dbCreatePath(cv list("M3" "drawing") list(list(130 830.76) list(109.24 830.76)) 0.2 "extendExtend")
dbCreatePath(cv list("M3" "drawing") list(list(109.24 830.76) list(109.24 330)) 0.2 "extendExtend")
dbCreatePath(cv list("M3" "drawing") list(list(810 829.5) list(829.5 829.5)) 0.2 "extendExtend")
dbCreatePath(cv list("M3" "drawing") list(list(829.5 829.5) list(829.5 810)) 0.2 "extendExtend")
dbCreatePath(cv list("M3" "drawing") list(list(810 830.76) list(830.76 830.76)) 0.2 "extendExtend")
dbCreatePath(cv list("M3" "drawing") list(list(830.76 830.76) list(830.76 810)) 0.2 "extendExtend")
dbCreatePath(cv list("M3" "drawing") list(list(130 110.5) list(110.5 110.5)) 0.2 "extendExtend")
dbCreatePath(cv list("M3" "drawing") list(list(110.5 110.5) list(110.5 130)) 0.2 "extendExtend")
dbCreatePath(cv list("M3" "drawing") list(list(130 109.24) list(109.24 109.24)) 0.2 "extendExtend")
dbCreatePath(cv list("M3" "drawing") list(list(109.24 109.24) list(109.24 130)) 0.2 "extendExtend")
dbCreatePath(cv list("M3" "drawing") list(list(810 110.5) list(829.5 110.5)) 0.2 "extendExtend")
dbCreatePath(cv list("M3" "drawing") list(list(829.5 110.5) list(829.5 130)) 0.2 "extendExtend")
dbCreatePath(cv list("M3" "drawing") list(list(810 109.24) list(830.76 109.24)) 0.2 "extendExtend")
dbCreatePath(cv list("M3" "drawing") list(list(830.76 109.24) list(830.76 130)) 0.2 "extendExtend")
dbCreatePath(cv list("M3" "drawing") list(list(327.655 829.88) list(327.655 829.5)) 0.2)
tech = techGetTechFile(cv)
viaParams = list(list("cutRows" 2) list("cutColumns" 4))
viaDefId = techFindViaDefByName(tech "M3_M2")
newVia = dbCreateVia(cv viaDefId list(327.655 829.88) "R180" viaParams)
dbCreatePath(cv list("M3" "drawing") list(list(267.61 829.88) list(267.61 830.76)) 0.2)
tech = techGetTechFile(cv)
viaParams = list(list("cutRows" 2) list("cutColumns" 4))
viaDefId = techFindViaDefByName(tech "M3_M2")
newVia = dbCreateVia(cv viaDefId list(267.61 829.88) "R180" viaParams)
dbCreatePath(cv list("M3" "drawing") list(list(109.875 319.8) list(110.5 319.8)) 0.26)
dbCreatePath(cv list("M3" "drawing") list(list(109.875 324.1) list(109.24 324.1)) 0.26)
dbCreateLabel(cv list("M4" "pin") list(109.875 328.275) "D0_CORE" "centerLeft" "R0" "roman" 2)
dbCreatePath(cv list("M3" "drawing") list(list(109.875 259.8) list(110.5 259.8)) 0.26)
dbCreatePath(cv list("M3" "drawing") list(list(109.875 264.1) list(109.24 264.1)) 0.26)
dbCreateLabel(cv list("M4" "pin") list(109.875 268.275) "D1_CORE" "centerLeft" "R0" "roman" 2)
dbCreatePath(cv list("M3" "drawing") list(list(109.875 199.8) list(110.5 199.8)) 0.26)
dbCreatePath(cv list("M3" "drawing") list(list(109.875 204.1) list(109.24 204.1)) 0.26)
dbCreateLabel(cv list("M4" "pin") list(109.875 208.275) "D2_CORE" "centerLeft" "R0" "roman" 2)
dbCreatePath(cv list("M3" "drawing") list(list(109.875 139.8) list(110.5 139.8)) 0.26)
dbCreatePath(cv list("M3" "drawing") list(list(109.875 144.1) list(109.24 144.1)) 0.26)
dbCreateLabel(cv list("M4" "pin") list(109.875 148.275) "D3_CORE" "centerLeft" "R0" "roman" 2)
dbCreatePath(cv list("M3" "drawing") list(list(140.2 109.875) list(140.2 110.5)) 0.26)
dbCreatePath(cv list("M3" "drawing") list(list(135.9 109.875) list(135.9 109.24)) 0.26)
dbCreateLabel(cv list("M4" "pin") list(131.725 109.875) "D4_CORE" "centerLeft" "R90" "roman" 2)
dbCreatePath(cv list("M3" "drawing") list(list(200.2 109.875) list(200.2 110.5)) 0.26)
dbCreatePath(cv list("M3" "drawing") list(list(195.9 109.875) list(195.9 109.24)) 0.26)
dbCreateLabel(cv list("M4" "pin") list(191.725 109.875) "D5_CORE" "centerLeft" "R90" "roman" 2)
dbCreatePath(cv list("M3" "drawing") list(list(260.2 109.875) list(260.2 110.5)) 0.26)
dbCreatePath(cv list("M3" "drawing") list(list(255.9 109.875) list(255.9 109.24)) 0.26)
dbCreateLabel(cv list("M4" "pin") list(251.725 109.875) "D6_CORE" "centerLeft" "R90" "roman" 2)
dbCreatePath(cv list("M3" "drawing") list(list(320.2 109.875) list(320.2 110.5)) 0.26)
dbCreatePath(cv list("M3" "drawing") list(list(315.9 109.875) list(315.9 109.24)) 0.26)
dbCreateLabel(cv list("M4" "pin") list(311.725 109.875) "D7_CORE" "centerLeft" "R90" "roman" 2)
dbCreatePath(cv list("M3" "drawing") list(list(380.2 109.875) list(380.2 110.5)) 0.26)
dbCreatePath(cv list("M3" "drawing") list(list(375.9 109.875) list(375.9 109.24)) 0.26)
dbCreateLabel(cv list("M4" "pin") list(371.725 109.875) "D8_CORE" "centerLeft" "R90" "roman" 2)
dbCreatePath(cv list("M3" "drawing") list(list(440.2 109.875) list(440.2 110.5)) 0.26)
dbCreatePath(cv list("M3" "drawing") list(list(435.9 109.875) list(435.9 109.24)) 0.26)
dbCreateLabel(cv list("M4" "pin") list(431.725 109.875) "D9_CORE" "centerLeft" "R90" "roman" 2)
dbCreatePath(cv list("M3" "drawing") list(list(500.2 109.875) list(500.2 110.5)) 0.26)
dbCreatePath(cv list("M3" "drawing") list(list(495.9 109.875) list(495.9 109.24)) 0.26)
dbCreateLabel(cv list("M4" "pin") list(491.725 109.875) "D10_CORE" "centerLeft" "R90" "roman" 2)
dbCreatePath(cv list("M3" "drawing") list(list(560.2 109.875) list(560.2 110.5)) 0.26)
dbCreatePath(cv list("M3" "drawing") list(list(555.9 109.875) list(555.9 109.24)) 0.26)
dbCreateLabel(cv list("M4" "pin") list(551.725 109.875) "D11_CORE" "centerLeft" "R90" "roman" 2)
dbCreatePath(cv list("M3" "drawing") list(list(620.2 109.875) list(620.2 110.5)) 0.26)
dbCreatePath(cv list("M3" "drawing") list(list(615.9 109.875) list(615.9 109.24)) 0.26)
dbCreateLabel(cv list("M4" "pin") list(611.725 109.875) "D12_CORE" "centerLeft" "R90" "roman" 2)
dbCreatePath(cv list("M3" "drawing") list(list(680.2 109.875) list(680.2 110.5)) 0.26)
dbCreatePath(cv list("M3" "drawing") list(list(675.9 109.875) list(675.9 109.24)) 0.26)
dbCreateLabel(cv list("M4" "pin") list(671.725 109.875) "D13_CORE" "centerLeft" "R90" "roman" 2)
dbCreatePath(cv list("M3" "drawing") list(list(740.2 109.875) list(740.2 110.5)) 0.26)
dbCreatePath(cv list("M3" "drawing") list(list(735.9 109.875) list(735.9 109.24)) 0.26)
dbCreateLabel(cv list("M4" "pin") list(731.725 109.875) "D14_CORE" "centerLeft" "R90" "roman" 2)
dbCreatePath(cv list("M3" "drawing") list(list(800.2 109.875) list(800.2 110.5)) 0.26)
dbCreatePath(cv list("M3" "drawing") list(list(795.9 109.875) list(795.9 109.24)) 0.26)
dbCreateLabel(cv list("M4" "pin") list(791.725 109.875) "D15_CORE" "centerLeft" "R90" "roman" 2)
dbCreatePath(cv list("M3" "drawing") list(list(829.5 140.2) list(830.125 140.2)) 0.26)
dbCreatePath(cv list("M3" "drawing") list(list(830.76 135.9) list(830.125 135.9)) 0.26)
dbCreateLabel(cv list("M4" "pin") list(830.125 131.725) "D16_CORE" "centerRight" "R0" "roman" 2)
dbCreatePath(cv list("M3" "drawing") list(list(829.5 200.2) list(830.125 200.2)) 0.26)
dbCreatePath(cv list("M3" "drawing") list(list(830.76 195.9) list(830.125 195.9)) 0.26)
dbCreateLabel(cv list("M4" "pin") list(830.125 191.725) "D17_CORE" "centerRight" "R0" "roman" 2)
dbCreatePath(cv list("M3" "drawing") list(list(829.5 260.2) list(830.125 260.2)) 0.26)
dbCreatePath(cv list("M3" "drawing") list(list(830.76 255.9) list(830.125 255.9)) 0.26)
dbCreateLabel(cv list("M4" "pin") list(830.125 251.725) "D18_CORE" "centerRight" "R0" "roman" 2)
dbCreatePath(cv list("M3" "drawing") list(list(829.5 320.2) list(830.125 320.2)) 0.26)
dbCreatePath(cv list("M3" "drawing") list(list(830.76 315.9) list(830.125 315.9)) 0.26)
dbCreateLabel(cv list("M4" "pin") list(830.125 311.725) "D19_CORE" "centerRight" "R0" "roman" 2)
dbCreatePath(cv list("M3" "drawing") list(list(829.5 380.2) list(830.125 380.2)) 0.26)
dbCreatePath(cv list("M3" "drawing") list(list(830.76 375.9) list(830.125 375.9)) 0.26)
dbCreateLabel(cv list("M4" "pin") list(830.125 371.725) "D20_CORE" "centerRight" "R0" "roman" 2)
dbCreatePath(cv list("M3" "drawing") list(list(829.5 440.2) list(830.125 440.2)) 0.26)
dbCreatePath(cv list("M3" "drawing") list(list(830.76 435.9) list(830.125 435.9)) 0.26)
dbCreateLabel(cv list("M4" "pin") list(830.125 431.725) "D21_CORE" "centerRight" "R0" "roman" 2)
dbCreatePath(cv list("M3" "drawing") list(list(829.5 500.2) list(830.125 500.2)) 0.26)
dbCreatePath(cv list("M3" "drawing") list(list(830.76 495.9) list(830.125 495.9)) 0.26)
dbCreateLabel(cv list("M4" "pin") list(830.125 491.725) "D22_CORE" "centerRight" "R0" "roman" 2)
dbCreatePath(cv list("M3" "drawing") list(list(829.5 560.2) list(830.125 560.2)) 0.26)
dbCreatePath(cv list("M3" "drawing") list(list(830.76 555.9) list(830.125 555.9)) 0.26)
dbCreateLabel(cv list("M4" "pin") list(830.125 551.725) "D23_CORE" "centerRight" "R0" "roman" 2)
dbCreatePath(cv list("M3" "drawing") list(list(829.5 620.2) list(830.125 620.2)) 0.26)
dbCreatePath(cv list("M3" "drawing") list(list(830.76 615.9) list(830.125 615.9)) 0.26)
dbCreateLabel(cv list("M4" "pin") list(830.125 611.725) "D24_CORE" "centerRight" "R0" "roman" 2)
dbCreatePath(cv list("M3" "drawing") list(list(829.5 680.2) list(830.125 680.2)) 0.26)
dbCreatePath(cv list("M3" "drawing") list(list(830.76 675.9) list(830.125 675.9)) 0.26)
dbCreateLabel(cv list("M4" "pin") list(830.125 671.725) "D25_CORE" "centerRight" "R0" "roman" 2)
dbCreatePath(cv list("M3" "drawing") list(list(829.5 740.2) list(830.125 740.2)) 0.26)
dbCreatePath(cv list("M3" "drawing") list(list(830.76 735.9) list(830.125 735.9)) 0.26)
dbCreateLabel(cv list("M4" "pin") list(830.125 731.725) "D26_CORE" "centerRight" "R0" "roman" 2)
dbCreatePath(cv list("M3" "drawing") list(list(829.5 800.2) list(830.125 800.2)) 0.26)
dbCreatePath(cv list("M3" "drawing") list(list(830.76 795.9) list(830.125 795.9)) 0.26)
dbCreateLabel(cv list("M4" "pin") list(830.125 791.725) "D27_CORE" "centerRight" "R0" "roman" 2)
dbCreatePath(cv list("M3" "drawing") list(list(799.8 830.125) list(799.8 829.5)) 0.26)
dbCreatePath(cv list("M3" "drawing") list(list(804.1 830.125) list(804.1 830.76)) 0.26)
dbCreateLabel(cv list("M4" "pin") list(808.275 830.125) "D28_CORE" "centerRight" "R90" "roman" 2)
dbCreatePath(cv list("M3" "drawing") list(list(739.8 830.125) list(739.8 829.5)) 0.26)
dbCreatePath(cv list("M3" "drawing") list(list(744.1 830.125) list(744.1 830.76)) 0.26)
dbCreateLabel(cv list("M4" "pin") list(748.275 830.125) "D29_CORE" "centerRight" "R90" "roman" 2)
dbCreatePath(cv list("M3" "drawing") list(list(679.8 830.125) list(679.8 829.5)) 0.26)
dbCreatePath(cv list("M3" "drawing") list(list(684.1 830.125) list(684.1 830.76)) 0.26)
dbCreateLabel(cv list("M4" "pin") list(688.275 830.125) "D30_CORE" "centerRight" "R90" "roman" 2)
dbCreatePath(cv list("M3" "drawing") list(list(619.8 830.125) list(619.8 829.5)) 0.26)
dbCreatePath(cv list("M3" "drawing") list(list(624.1 830.125) list(624.1 830.76)) 0.26)
dbCreateLabel(cv list("M4" "pin") list(628.275 830.125) "D31_CORE" "centerRight" "R90" "roman" 2)
dbCreatePath(cv list("M3" "drawing") list(list(559.8 830.125) list(559.8 829.5)) 0.26)
dbCreatePath(cv list("M3" "drawing") list(list(564.1 830.125) list(564.1 830.76)) 0.26)
dbCreateLabel(cv list("M4" "pin") list(568.275 830.125) "D32_CORE" "centerRight" "R90" "roman" 2)
dbCreatePath(cv list("M3" "drawing") list(list(499.8 830.125) list(499.8 829.5)) 0.26)
dbCreatePath(cv list("M3" "drawing") list(list(504.1 830.125) list(504.1 830.76)) 0.26)
dbCreateLabel(cv list("M4" "pin") list(508.275 830.125) "D33_CORE" "centerRight" "R90" "roman" 2)
dbCreatePath(cv list("M3" "drawing") list(list(439.8 830.125) list(439.8 829.5)) 0.26)
dbCreatePath(cv list("M3" "drawing") list(list(444.1 830.125) list(444.1 830.76)) 0.26)
dbCreateLabel(cv list("M4" "pin") list(448.275 830.125) "D34_CORE" "centerRight" "R90" "roman" 2)
dbCreatePath(cv list("M3" "drawing") list(list(379.8 830.125) list(379.8 829.5)) 0.26)
dbCreatePath(cv list("M3" "drawing") list(list(384.1 830.125) list(384.1 830.76)) 0.26)
dbCreateLabel(cv list("M4" "pin") list(388.275 830.125) "D35_CORE" "centerRight" "R90" "roman" 2)

; ==================== Pin Labels (with Inner Pad Support) ====================
dbCreateLabel(cv list("AP" "pin") list(-11 800) "VINP" "centerRight" "R0" "roman" 10)
dbCreateLabel(cv list("AP" "pin") list(-11 740) "VINN" "centerRight" "R0" "roman" 10)
dbCreateLabel(cv list("AP" "pin") list(-11 680) "VIP" "centerRight" "R0" "roman" 10)
dbCreateLabel(cv list("AP" "pin") list(-11 620) "VIM" "centerRight" "R0" "roman" 10)
dbCreateLabel(cv list("AP" "pin") list(-11 560) "VCM" "centerRight" "R0" "roman" 10)
dbCreateLabel(cv list("AP" "pin") list(-11 500) "VREF" "centerRight" "R0" "roman" 10)
dbCreateLabel(cv list("AP" "pin") list(-11 440) "AVDD" "centerRight" "R0" "roman" 10)
dbCreateLabel(cv list("M2" "pin") list(109.9 440) "AVDD_CORE" "centerLeft" "R0" "roman" 2)
dbCreateLabel(cv list("AP" "pin") list(-11 380) "AVSS" "centerRight" "R0" "roman" 10)
dbCreateLabel(cv list("M2" "pin") list(109.9 380) "AVSS_CORE" "centerLeft" "R0" "roman" 2)
dbCreateLabel(cv list("AP" "pin") list(-11 320) "D0" "centerRight" "R0" "roman" 10)
dbCreateLabel(cv list("AP" "pin") list(-11 260) "D1" "centerRight" "R0" "roman" 10)
dbCreateLabel(cv list("AP" "pin") list(-11 200) "D2" "centerRight" "R0" "roman" 10)
dbCreateLabel(cv list("AP" "pin") list(-11 140) "D3" "centerRight" "R0" "roman" 10)
dbCreateLabel(cv list("AP" "pin") list(140 -11) "D4" "centerRight" "R90" "roman" 10)
dbCreateLabel(cv list("AP" "pin") list(200 -11) "D5" "centerRight" "R90" "roman" 10)
dbCreateLabel(cv list("AP" "pin") list(260 -11) "D6" "centerRight" "R90" "roman" 10)
dbCreateLabel(cv list("AP" "pin") list(320 -11) "D7" "centerRight" "R90" "roman" 10)
dbCreateLabel(cv list("AP" "pin") list(380 -11) "D8" "centerRight" "R90" "roman" 10)
dbCreateLabel(cv list("AP" "pin") list(440 -11) "D9" "centerRight" "R90" "roman" 10)
dbCreateLabel(cv list("AP" "pin") list(500 -11) "D10" "centerRight" "R90" "roman" 10)
dbCreateLabel(cv list("AP" "pin") list(560 -11) "D11" "centerRight" "R90" "roman" 10)
dbCreateLabel(cv list("AP" "pin") list(620 -11) "D12" "centerRight" "R90" "roman" 10)
dbCreateLabel(cv list("AP" "pin") list(680 -11) "D13" "centerRight" "R90" "roman" 10)
dbCreateLabel(cv list("AP" "pin") list(740 -11) "D14" "centerRight" "R90" "roman" 10)
dbCreateLabel(cv list("AP" "pin") list(800 -11) "D15" "centerRight" "R90" "roman" 10)
dbCreateLabel(cv list("AP" "pin") list(951 140) "D16" "centerLeft" "R0" "roman" 10)
dbCreateLabel(cv list("AP" "pin") list(951 200) "D17" "centerLeft" "R0" "roman" 10)
dbCreateLabel(cv list("AP" "pin") list(951 260) "D18" "centerLeft" "R0" "roman" 10)
dbCreateLabel(cv list("AP" "pin") list(951 320) "D19" "centerLeft" "R0" "roman" 10)
dbCreateLabel(cv list("AP" "pin") list(951 380) "D20" "centerLeft" "R0" "roman" 10)
dbCreateLabel(cv list("AP" "pin") list(951 440) "D21" "centerLeft" "R0" "roman" 10)
dbCreateLabel(cv list("AP" "pin") list(951 500) "D22" "centerLeft" "R0" "roman" 10)
dbCreateLabel(cv list("AP" "pin") list(951 560) "D23" "centerLeft" "R0" "roman" 10)
dbCreateLabel(cv list("AP" "pin") list(951 620) "D24" "centerLeft" "R0" "roman" 10)
dbCreateLabel(cv list("AP" "pin") list(951 680) "D25" "centerLeft" "R0" "roman" 10)
dbCreateLabel(cv list("AP" "pin") list(951 740) "D26" "centerLeft" "R0" "roman" 10)
dbCreateLabel(cv list("AP" "pin") list(951 800) "D27" "centerLeft" "R0" "roman" 10)
dbCreateLabel(cv list("AP" "pin") list(800 951) "D28" "centerLeft" "R90" "roman" 10)
dbCreateLabel(cv list("AP" "pin") list(740 951) "D29" "centerLeft" "R90" "roman" 10)
dbCreateLabel(cv list("AP" "pin") list(680 951) "D30" "centerLeft" "R90" "roman" 10)
dbCreateLabel(cv list("AP" "pin") list(620 951) "D31" "centerLeft" "R90" "roman" 10)
dbCreateLabel(cv list("AP" "pin") list(560 951) "D32" "centerLeft" "R90" "roman" 10)
dbCreateLabel(cv list("AP" "pin") list(500 951) "D33" "centerLeft" "R90" "roman" 10)
dbCreateLabel(cv list("AP" "pin") list(440 951) "D34" "centerLeft" "R90" "roman" 10)
dbCreateLabel(cv list("AP" "pin") list(380 951) "D35" "centerLeft" "R90" "roman" 10)
dbCreateLabel(cv list("AP" "pin") list(320 951) "VIOL" "centerLeft" "R90" "roman" 10)
dbCreateLabel(cv list("AP" "pin") list(260 951) "GIOL" "centerLeft" "R90" "roman" 10)
dbCreateLabel(cv list("AP" "pin") list(200 951) "VIOH" "centerLeft" "R90" "roman" 10)
dbCreateLabel(cv list("AP" "pin") list(140 951) "GIOH" "centerLeft" "R90" "roman" 10)
dbCreateLabel(cv list("AP" "pin") list(152 530) "VREF_CORE" "centerLeft" "R0" "roman" 10)
dbCreateLabel(cv list("AP" "pin") list(152 770) "VAMP_CORE" "centerLeft" "R0" "roman" 10)
dbCreateLabel(cv list("AP" "pin") list(152 650) "IBIAS_CORE" "centerLeft" "R0" "roman" 10)

dbSave(cv)
t
