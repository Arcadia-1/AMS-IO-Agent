pdb3ac_h_gMaster = dbOpenCellView("tphn28hpcpgv18" "PDB3AC_H_G" "symbol")
dbCreateInst(cv pdb3ac_h_gMaster "VINP_left0" '(0 24.8125) "R270")
schCreateWire(cv "route" "full" '((0.000 25.000) (-0.750 25.000)) 0 0 0 nil nil)
schCreateWireLabel(cv nil '(-0.250 25.000) "VINP" "lowerRight" "R0" "stick" 0.0625 nil)
schCreatePin(cv nil "VINP" "inputOutput" nil '(-0.750 25.000) "R0")
schCreateWire(cv "route" "full" '((0.875 25.062) (1.625 25.062)) 0 0 0 nil nil)
schCreateWireLabel(cv nil '(1.125 25.062) "AVSS" "lowerLeft" "R0" "stick" 0.0625 nil)
schCreateWire(cv "route" "full" '((0.875 24.688) (1.625 24.688)) 0 0 0 nil nil)
schCreateWireLabel(cv nil '(1.125 24.688) "GIOL" "lowerLeft" "R0" "stick" 0.0625 nil)
schCreateWire(cv "route" "full" '((0.875 25.438) (1.625 25.438)) 0 0 0 nil nil)
schCreateWireLabel(cv nil '(1.125 25.438) "AVDD" "lowerLeft" "R0" "stick" 0.0625 nil)
dbCreateInst(cv pdb3ac_h_gMaster "VINN_left1" '(0 22.8125) "R270")
schCreateWire(cv "route" "full" '((0.000 23.000) (-0.750 23.000)) 0 0 0 nil nil)
schCreateWireLabel(cv nil '(-0.250 23.000) "VINN" "lowerRight" "R0" "stick" 0.0625 nil)
schCreatePin(cv nil "VINN" "inputOutput" nil '(-0.750 23.000) "R0")
schCreateWire(cv "route" "full" '((0.875 23.062) (1.625 23.062)) 0 0 0 nil nil)
schCreateWireLabel(cv nil '(1.125 23.062) "AVSS" "lowerLeft" "R0" "stick" 0.0625 nil)
schCreateWire(cv "route" "full" '((0.875 22.688) (1.625 22.688)) 0 0 0 nil nil)
schCreateWireLabel(cv nil '(1.125 22.688) "GIOL" "lowerLeft" "R0" "stick" 0.0625 nil)
schCreateWire(cv "route" "full" '((0.875 23.438) (1.625 23.438)) 0 0 0 nil nil)
schCreateWireLabel(cv nil '(1.125 23.438) "AVDD" "lowerLeft" "R0" "stick" 0.0625 nil)
dbCreateInst(cv pdb3ac_h_gMaster "VIP_left2" '(0 20.8125) "R270")
schCreateWire(cv "route" "full" '((0.000 21.000) (-0.750 21.000)) 0 0 0 nil nil)
schCreateWireLabel(cv nil '(-0.250 21.000) "VIP" "lowerRight" "R0" "stick" 0.0625 nil)
schCreatePin(cv nil "VIP" "inputOutput" nil '(-0.750 21.000) "R0")
schCreateWire(cv "route" "full" '((0.875 21.062) (1.625 21.062)) 0 0 0 nil nil)
schCreateWireLabel(cv nil '(1.125 21.062) "AVSS" "lowerLeft" "R0" "stick" 0.0625 nil)
schCreateWire(cv "route" "full" '((0.875 20.688) (1.625 20.688)) 0 0 0 nil nil)
schCreateWireLabel(cv nil '(1.125 20.688) "GIOL" "lowerLeft" "R0" "stick" 0.0625 nil)
schCreateWire(cv "route" "full" '((0.875 21.438) (1.625 21.438)) 0 0 0 nil nil)
schCreateWireLabel(cv nil '(1.125 21.438) "AVDD" "lowerLeft" "R0" "stick" 0.0625 nil)
dbCreateInst(cv pdb3ac_h_gMaster "VIM_left3" '(0 18.8125) "R270")
schCreateWire(cv "route" "full" '((0.000 19.000) (-0.750 19.000)) 0 0 0 nil nil)
schCreateWireLabel(cv nil '(-0.250 19.000) "VIM" "lowerRight" "R0" "stick" 0.0625 nil)
schCreatePin(cv nil "VIM" "inputOutput" nil '(-0.750 19.000) "R0")
schCreateWire(cv "route" "full" '((0.875 19.062) (1.625 19.062)) 0 0 0 nil nil)
schCreateWireLabel(cv nil '(1.125 19.062) "AVSS" "lowerLeft" "R0" "stick" 0.0625 nil)
schCreateWire(cv "route" "full" '((0.875 18.688) (1.625 18.688)) 0 0 0 nil nil)
schCreateWireLabel(cv nil '(1.125 18.688) "GIOL" "lowerLeft" "R0" "stick" 0.0625 nil)
schCreateWire(cv "route" "full" '((0.875 19.438) (1.625 19.438)) 0 0 0 nil nil)
schCreateWireLabel(cv nil '(1.125 19.438) "AVDD" "lowerLeft" "R0" "stick" 0.0625 nil)
dbCreateInst(cv pdb3ac_h_gMaster "VCM_left4" '(0 16.8125) "R270")
schCreateWire(cv "route" "full" '((0.000 17.000) (-0.750 17.000)) 0 0 0 nil nil)
schCreateWireLabel(cv nil '(-0.250 17.000) "VCM" "lowerRight" "R0" "stick" 0.0625 nil)
schCreatePin(cv nil "VCM" "inputOutput" nil '(-0.750 17.000) "R0")
schCreateWire(cv "route" "full" '((0.875 17.062) (1.625 17.062)) 0 0 0 nil nil)
schCreateWireLabel(cv nil '(1.125 17.062) "AVSS" "lowerLeft" "R0" "stick" 0.0625 nil)
schCreateWire(cv "route" "full" '((0.875 16.688) (1.625 16.688)) 0 0 0 nil nil)
schCreateWireLabel(cv nil '(1.125 16.688) "GIOL" "lowerLeft" "R0" "stick" 0.0625 nil)
schCreateWire(cv "route" "full" '((0.875 17.438) (1.625 17.438)) 0 0 0 nil nil)
schCreateWireLabel(cv nil '(1.125 17.438) "AVDD" "lowerLeft" "R0" "stick" 0.0625 nil)
dbCreateInst(cv pdb3ac_h_gMaster "VREF_left5" '(0 14.8125) "R270")
schCreateWire(cv "route" "full" '((0.000 15.001) (-0.750 15.001)) 0 0 0 nil nil)
schCreateWireLabel(cv nil '(-0.250 15.001) "VREF" "lowerRight" "R0" "stick" 0.0625 nil)
schCreatePin(cv nil "VREF" "inputOutput" nil '(-0.750 15.001) "R0")
schCreateWire(cv "route" "full" '((0.875 15.062) (1.625 15.062)) 0 0 0 nil nil)
schCreateWireLabel(cv nil '(1.125 15.062) "AVSS" "lowerLeft" "R0" "stick" 0.0625 nil)
schCreateWire(cv "route" "full" '((0.875 14.688) (1.625 14.688)) 0 0 0 nil nil)
schCreateWireLabel(cv nil '(1.125 14.688) "GIOL" "lowerLeft" "R0" "stick" 0.0625 nil)
schCreateWire(cv "route" "full" '((0.875 15.438) (1.625 15.438)) 0 0 0 nil nil)
schCreateWireLabel(cv nil '(1.125 15.438) "AVDD" "lowerLeft" "R0" "stick" 0.0625 nil)
pvdd3ac_h_gMaster = dbOpenCellView("tphn28hpcpgv18" "PVDD3AC_H_G" "symbol")
dbCreateInst(cv pvdd3ac_h_gMaster "AVDD_left6" '(0 12.8125) "R270")
schCreateWire(cv "route" "full" '((0.875 13.438) (1.625 13.438)) 0 0 0 nil nil)
schCreateWireLabel(cv nil '(1.125 13.438) "AVDD_CORE" "lowerLeft" "R0" "stick" 0.0625 nil)
schCreatePin(cv nil "AVDD_CORE" "inputOutput" nil '(1.625 13.438) "R180")
schCreateWire(cv "route" "full" '((0.875 13.062) (1.625 13.062)) 0 0 0 nil nil)
schCreateWireLabel(cv nil '(1.125 13.062) "AVSS" "lowerLeft" "R0" "stick" 0.0625 nil)
schCreateWire(cv "route" "full" '((0.875 12.688) (1.625 12.688)) 0 0 0 nil nil)
schCreateWireLabel(cv nil '(1.125 12.688) "GIOL" "lowerLeft" "R0" "stick" 0.0625 nil)
schCreateWire(cv "route" "full" '((0.000 13.001) (-0.750 13.001)) 0 0 0 nil nil)
schCreateWireLabel(cv nil '(-0.250 13.001) "AVDD" "lowerRight" "R0" "stick" 0.0625 nil)
schCreatePin(cv nil "AVDD" "inputOutput" nil '(-0.750 13.001) "R0")
pvss3ac_h_gMaster = dbOpenCellView("tphn28hpcpgv18" "PVSS3AC_H_G" "symbol")
dbCreateInst(cv pvss3ac_h_gMaster "AVSS_left7" '(0 10.8125) "R270")
schCreateWire(cv "route" "full" '((0.000 11.001) (-0.750 11.001)) 0 0 0 nil nil)
schCreateWireLabel(cv nil '(-0.250 11.001) "AVSS" "lowerRight" "R0" "stick" 0.0625 nil)
schCreatePin(cv nil "AVSS" "inputOutput" nil '(-0.750 11.001) "R0")
schCreateWire(cv "route" "full" '((0.875 10.688) (1.625 10.688)) 0 0 0 nil nil)
schCreateWireLabel(cv nil '(1.125 10.688) "GIOL" "lowerLeft" "R0" "stick" 0.0625 nil)
schCreateWire(cv "route" "full" '((0.875 11.438) (1.625 11.438)) 0 0 0 nil nil)
schCreateWireLabel(cv nil '(1.125 11.438) "AVSS_CORE" "lowerLeft" "R0" "stick" 0.0625 nil)
schCreatePin(cv nil "AVSS_CORE" "inputOutput" nil '(1.625 11.438) "R180")
schCreateWire(cv "route" "full" '((0.875 11.062) (1.625 11.062)) 0 0 0 nil nil)
schCreateWireLabel(cv nil '(1.125 11.062) "AVDD" "lowerLeft" "R0" "stick" 0.0625 nil)
pddw16sdgz_h_gMaster = dbOpenCellView("tphn28hpcpgv18" "PDDW16SDGZ_H_G" "symbol")
dbCreateInst(cv pddw16sdgz_h_gMaster "D0_left8" '(0 9.6875) "R270")
schCreateWire(cv "route" "full" '((1.000 9.562) (1.750 9.562)) 0 0 0 nil nil)
schCreateWireLabel(cv nil '(1.250 9.562) "VIOL" "lowerLeft" "R0" "stick" 0.0625 nil)
noConnMaster = dbOpenCellView("basic" "noConn" "symbol")
schCreateWire(cv "route" "full" '((1.000 9.438) (1.750 9.438)) 0 0 0 nil nil)
dbCreateInst(cv noConnMaster "noConn_D0_left8_C" '(1.750 9.438) "R90")
schCreateWire(cv "route" "full" '((1.000 9.812) (1.750 9.812)) 0 0 0 nil nil)
schCreateWireLabel(cv nil '(1.250 9.812) "GIOL" "lowerLeft" "R0" "stick" 0.0625 nil)
schCreateWire(cv "route" "full" '((1.000 9.938) (1.750 9.938)) 0 0 0 nil nil)
schCreateWireLabel(cv nil '(1.250 9.938) "D0_CORE" "lowerLeft" "R0" "stick" 0.0625 nil)
schCreatePin(cv nil "D0_CORE" "inputOutput" nil '(1.750 9.938) "R180")
schCreateWire(cv "route" "full" '((0.000 8.999) (-0.750 8.999)) 0 0 0 nil nil)
schCreateWireLabel(cv nil '(-0.250 8.999) "D0" "lowerRight" "R0" "stick" 0.0625 nil)
schCreatePin(cv nil "D0" "inputOutput" nil '(-0.750 8.999) "R0")
schCreateWire(cv "route" "full" '((1.000 9.312) (1.750 9.312)) 0 0 0 nil nil)
schCreateWireLabel(cv nil '(1.250 9.312) "POC" "lowerLeft" "R0" "stick" 0.0625 nil)
schCreateWire(cv "route" "full" '((1.000 9.126) (1.750 9.126)) 0 0 0 nil nil)
schCreateWireLabel(cv nil '(1.250 9.126) "VIOL" "lowerLeft" "R0" "stick" 0.0625 nil)
schCreateWire(cv "route" "full" '((1.000 8.938) (1.750 8.938)) 0 0 0 nil nil)
schCreateWireLabel(cv nil '(1.250 8.938) "GIOL" "lowerLeft" "R0" "stick" 0.0625 nil)
schCreateWire(cv "route" "full" '((1.000 8.749) (1.750 8.749)) 0 0 0 nil nil)
schCreateWireLabel(cv nil '(1.250 8.749) "VIOH" "lowerLeft" "R0" "stick" 0.0625 nil)
schCreateWire(cv "route" "full" '((1.000 8.376) (1.750 8.376)) 0 0 0 nil nil)
schCreateWireLabel(cv nil '(1.250 8.376) "GIOH" "lowerLeft" "R0" "stick" 0.0625 nil)
dbCreateInst(cv pddw16sdgz_h_gMaster "D1_left9" '(0 7.6875) "R270")
schCreateWire(cv "route" "full" '((1.000 7.562) (1.750 7.562)) 0 0 0 nil nil)
schCreateWireLabel(cv nil '(1.250 7.562) "VIOL" "lowerLeft" "R0" "stick" 0.0625 nil)
schCreateWire(cv "route" "full" '((1.000 7.438) (1.750 7.438)) 0 0 0 nil nil)
dbCreateInst(cv noConnMaster "noConn_D1_left9_C" '(1.750 7.438) "R90")
schCreateWire(cv "route" "full" '((1.000 7.812) (1.750 7.812)) 0 0 0 nil nil)
schCreateWireLabel(cv nil '(1.250 7.812) "GIOL" "lowerLeft" "R0" "stick" 0.0625 nil)
schCreateWire(cv "route" "full" '((1.000 7.938) (1.750 7.938)) 0 0 0 nil nil)
schCreateWireLabel(cv nil '(1.250 7.938) "D1_CORE" "lowerLeft" "R0" "stick" 0.0625 nil)
schCreatePin(cv nil "D1_CORE" "inputOutput" nil '(1.750 7.938) "R180")
schCreateWire(cv "route" "full" '((0.000 7.000) (-0.750 7.000)) 0 0 0 nil nil)
schCreateWireLabel(cv nil '(-0.250 7.000) "D1" "lowerRight" "R0" "stick" 0.0625 nil)
schCreatePin(cv nil "D1" "inputOutput" nil '(-0.750 7.000) "R0")
schCreateWire(cv "route" "full" '((1.000 7.312) (1.750 7.312)) 0 0 0 nil nil)
schCreateWireLabel(cv nil '(1.250 7.312) "POC" "lowerLeft" "R0" "stick" 0.0625 nil)
schCreateWire(cv "route" "full" '((1.000 7.125) (1.750 7.125)) 0 0 0 nil nil)
schCreateWireLabel(cv nil '(1.250 7.125) "VIOL" "lowerLeft" "R0" "stick" 0.0625 nil)
schCreateWire(cv "route" "full" '((1.000 6.938) (1.750 6.938)) 0 0 0 nil nil)
schCreateWireLabel(cv nil '(1.250 6.938) "GIOL" "lowerLeft" "R0" "stick" 0.0625 nil)
schCreateWire(cv "route" "full" '((1.000 6.750) (1.750 6.750)) 0 0 0 nil nil)
schCreateWireLabel(cv nil '(1.250 6.750) "VIOH" "lowerLeft" "R0" "stick" 0.0625 nil)
schCreateWire(cv "route" "full" '((1.000 6.375) (1.750 6.375)) 0 0 0 nil nil)
schCreateWireLabel(cv nil '(1.250 6.375) "GIOH" "lowerLeft" "R0" "stick" 0.0625 nil)
dbCreateInst(cv pddw16sdgz_h_gMaster "D2_left10" '(0 5.6875) "R270")
schCreateWire(cv "route" "full" '((1.000 5.562) (1.750 5.562)) 0 0 0 nil nil)
schCreateWireLabel(cv nil '(1.250 5.562) "VIOL" "lowerLeft" "R0" "stick" 0.0625 nil)
schCreateWire(cv "route" "full" '((1.000 5.438) (1.750 5.438)) 0 0 0 nil nil)
dbCreateInst(cv noConnMaster "noConn_D2_left10_C" '(1.750 5.438) "R90")
schCreateWire(cv "route" "full" '((1.000 5.812) (1.750 5.812)) 0 0 0 nil nil)
schCreateWireLabel(cv nil '(1.250 5.812) "GIOL" "lowerLeft" "R0" "stick" 0.0625 nil)
schCreateWire(cv "route" "full" '((1.000 5.938) (1.750 5.938)) 0 0 0 nil nil)
schCreateWireLabel(cv nil '(1.250 5.938) "D2_CORE" "lowerLeft" "R0" "stick" 0.0625 nil)
schCreatePin(cv nil "D2_CORE" "inputOutput" nil '(1.750 5.938) "R180")
schCreateWire(cv "route" "full" '((0.000 5.000) (-0.750 5.000)) 0 0 0 nil nil)
schCreateWireLabel(cv nil '(-0.250 5.000) "D2" "lowerRight" "R0" "stick" 0.0625 nil)
schCreatePin(cv nil "D2" "inputOutput" nil '(-0.750 5.000) "R0")
schCreateWire(cv "route" "full" '((1.000 5.312) (1.750 5.312)) 0 0 0 nil nil)
schCreateWireLabel(cv nil '(1.250 5.312) "POC" "lowerLeft" "R0" "stick" 0.0625 nil)
schCreateWire(cv "route" "full" '((1.000 5.125) (1.750 5.125)) 0 0 0 nil nil)
schCreateWireLabel(cv nil '(1.250 5.125) "VIOL" "lowerLeft" "R0" "stick" 0.0625 nil)
schCreateWire(cv "route" "full" '((1.000 4.938) (1.750 4.938)) 0 0 0 nil nil)
schCreateWireLabel(cv nil '(1.250 4.938) "GIOL" "lowerLeft" "R0" "stick" 0.0625 nil)
schCreateWire(cv "route" "full" '((1.000 4.750) (1.750 4.750)) 0 0 0 nil nil)
schCreateWireLabel(cv nil '(1.250 4.750) "VIOH" "lowerLeft" "R0" "stick" 0.0625 nil)
schCreateWire(cv "route" "full" '((1.000 4.375) (1.750 4.375)) 0 0 0 nil nil)
schCreateWireLabel(cv nil '(1.250 4.375) "GIOH" "lowerLeft" "R0" "stick" 0.0625 nil)
dbCreateInst(cv pddw16sdgz_h_gMaster "D3_left11" '(0 3.6875) "R270")
schCreateWire(cv "route" "full" '((1.000 3.562) (1.750 3.562)) 0 0 0 nil nil)
schCreateWireLabel(cv nil '(1.250 3.562) "VIOL" "lowerLeft" "R0" "stick" 0.0625 nil)
schCreateWire(cv "route" "full" '((1.000 3.438) (1.750 3.438)) 0 0 0 nil nil)
dbCreateInst(cv noConnMaster "noConn_D3_left11_C" '(1.750 3.438) "R90")
schCreateWire(cv "route" "full" '((1.000 3.812) (1.750 3.812)) 0 0 0 nil nil)
schCreateWireLabel(cv nil '(1.250 3.812) "GIOL" "lowerLeft" "R0" "stick" 0.0625 nil)
schCreateWire(cv "route" "full" '((1.000 3.938) (1.750 3.938)) 0 0 0 nil nil)
schCreateWireLabel(cv nil '(1.250 3.938) "D3_CORE" "lowerLeft" "R0" "stick" 0.0625 nil)
schCreatePin(cv nil "D3_CORE" "inputOutput" nil '(1.750 3.938) "R180")
schCreateWire(cv "route" "full" '((0.000 3.000) (-0.750 3.000)) 0 0 0 nil nil)
schCreateWireLabel(cv nil '(-0.250 3.000) "D3" "lowerRight" "R0" "stick" 0.0625 nil)
schCreatePin(cv nil "D3" "inputOutput" nil '(-0.750 3.000) "R0")
schCreateWire(cv "route" "full" '((1.000 3.312) (1.750 3.312)) 0 0 0 nil nil)
schCreateWireLabel(cv nil '(1.250 3.312) "POC" "lowerLeft" "R0" "stick" 0.0625 nil)
schCreateWire(cv "route" "full" '((1.000 3.125) (1.750 3.125)) 0 0 0 nil nil)
schCreateWireLabel(cv nil '(1.250 3.125) "VIOL" "lowerLeft" "R0" "stick" 0.0625 nil)
schCreateWire(cv "route" "full" '((1.000 2.938) (1.750 2.938)) 0 0 0 nil nil)
schCreateWireLabel(cv nil '(1.250 2.938) "GIOL" "lowerLeft" "R0" "stick" 0.0625 nil)
schCreateWire(cv "route" "full" '((1.000 2.750) (1.750 2.750)) 0 0 0 nil nil)
schCreateWireLabel(cv nil '(1.250 2.750) "VIOH" "lowerLeft" "R0" "stick" 0.0625 nil)
schCreateWire(cv "route" "full" '((1.000 2.375) (1.750 2.375)) 0 0 0 nil nil)
schCreateWireLabel(cv nil '(1.250 2.375) "GIOH" "lowerLeft" "R0" "stick" 0.0625 nil)
pddw16sdgz_v_gMaster = dbOpenCellView("tphn28hpcpgv18" "PDDW16SDGZ_V_G" "symbol")
dbCreateInst(cv pddw16sdgz_v_gMaster "D4_bottom0" '(2.3125 0) "R0")
schCreateWire(cv "route" "full" '((2.438 1.000) (2.438 1.750)) 0 0 0 nil nil)
schCreateWireLabel(cv nil '(2.438 1.250) "VIOL" "lowerLeft" "R90" "stick" 0.0625 nil)
schCreateWire(cv "route" "full" '((2.562 1.000) (2.562 1.750)) 0 0 0 nil nil)
dbCreateInst(cv noConnMaster "noConn_D4_bottom0_C" '(2.562 1.750) "R180")
schCreateWire(cv "route" "full" '((2.188 1.000) (2.188 1.750)) 0 0 0 nil nil)
schCreateWireLabel(cv nil '(2.188 1.250) "GIOL" "lowerLeft" "R90" "stick" 0.0625 nil)
schCreateWire(cv "route" "full" '((2.062 1.000) (2.062 1.750)) 0 0 0 nil nil)
schCreateWireLabel(cv nil '(2.062 1.250) "D4_CORE" "lowerLeft" "R90" "stick" 0.0625 nil)
schCreatePin(cv nil "D4_CORE" "inputOutput" nil '(2.062 1.750) "R270")
schCreateWire(cv "route" "full" '((3.000 0.000) (3.000 -0.750)) 0 0 0 nil nil)
schCreateWireLabel(cv nil '(3.000 -0.250) "D4" "lowerRight" "R90" "stick" 0.0625 nil)
schCreatePin(cv nil "D4" "inputOutput" nil '(3.000 -0.750) "R90")
schCreateWire(cv "route" "full" '((2.688 1.000) (2.688 1.750)) 0 0 0 nil nil)
schCreateWireLabel(cv nil '(2.688 1.250) "POC" "lowerLeft" "R90" "stick" 0.0625 nil)
schCreateWire(cv "route" "full" '((2.875 1.000) (2.875 1.750)) 0 0 0 nil nil)
schCreateWireLabel(cv nil '(2.875 1.250) "VIOL" "lowerLeft" "R90" "stick" 0.0625 nil)
schCreateWire(cv "route" "full" '((3.062 1.000) (3.062 1.750)) 0 0 0 nil nil)
schCreateWireLabel(cv nil '(3.062 1.250) "GIOL" "lowerLeft" "R90" "stick" 0.0625 nil)
schCreateWire(cv "route" "full" '((3.250 1.000) (3.250 1.750)) 0 0 0 nil nil)
schCreateWireLabel(cv nil '(3.250 1.250) "VIOH" "lowerLeft" "R90" "stick" 0.0625 nil)
schCreateWire(cv "route" "full" '((3.625 1.000) (3.625 1.750)) 0 0 0 nil nil)
schCreateWireLabel(cv nil '(3.625 1.250) "GIOH" "lowerLeft" "R90" "stick" 0.0625 nil)
dbCreateInst(cv pddw16sdgz_v_gMaster "D5_bottom1" '(4.3125 0) "R0")
schCreateWire(cv "route" "full" '((4.438 1.000) (4.438 1.750)) 0 0 0 nil nil)
schCreateWireLabel(cv nil '(4.438 1.250) "VIOL" "lowerLeft" "R90" "stick" 0.0625 nil)
schCreateWire(cv "route" "full" '((4.562 1.000) (4.562 1.750)) 0 0 0 nil nil)
dbCreateInst(cv noConnMaster "noConn_D5_bottom1_C" '(4.562 1.750) "R180")
schCreateWire(cv "route" "full" '((4.188 1.000) (4.188 1.750)) 0 0 0 nil nil)
schCreateWireLabel(cv nil '(4.188 1.250) "GIOL" "lowerLeft" "R90" "stick" 0.0625 nil)
schCreateWire(cv "route" "full" '((4.062 1.000) (4.062 1.750)) 0 0 0 nil nil)
schCreateWireLabel(cv nil '(4.062 1.250) "D5_CORE" "lowerLeft" "R90" "stick" 0.0625 nil)
schCreatePin(cv nil "D5_CORE" "inputOutput" nil '(4.062 1.750) "R270")
schCreateWire(cv "route" "full" '((5.000 0.000) (5.000 -0.750)) 0 0 0 nil nil)
schCreateWireLabel(cv nil '(5.000 -0.250) "D5" "lowerRight" "R90" "stick" 0.0625 nil)
schCreatePin(cv nil "D5" "inputOutput" nil '(5.000 -0.750) "R90")
schCreateWire(cv "route" "full" '((4.688 1.000) (4.688 1.750)) 0 0 0 nil nil)
schCreateWireLabel(cv nil '(4.688 1.250) "POC" "lowerLeft" "R90" "stick" 0.0625 nil)
schCreateWire(cv "route" "full" '((4.875 1.000) (4.875 1.750)) 0 0 0 nil nil)
schCreateWireLabel(cv nil '(4.875 1.250) "VIOL" "lowerLeft" "R90" "stick" 0.0625 nil)
schCreateWire(cv "route" "full" '((5.062 1.000) (5.062 1.750)) 0 0 0 nil nil)
schCreateWireLabel(cv nil '(5.062 1.250) "GIOL" "lowerLeft" "R90" "stick" 0.0625 nil)
schCreateWire(cv "route" "full" '((5.250 1.000) (5.250 1.750)) 0 0 0 nil nil)
schCreateWireLabel(cv nil '(5.250 1.250) "VIOH" "lowerLeft" "R90" "stick" 0.0625 nil)
schCreateWire(cv "route" "full" '((5.625 1.000) (5.625 1.750)) 0 0 0 nil nil)
schCreateWireLabel(cv nil '(5.625 1.250) "GIOH" "lowerLeft" "R90" "stick" 0.0625 nil)
dbCreateInst(cv pddw16sdgz_v_gMaster "D6_bottom2" '(6.3125 0) "R0")
schCreateWire(cv "route" "full" '((6.438 1.000) (6.438 1.750)) 0 0 0 nil nil)
schCreateWireLabel(cv nil '(6.438 1.250) "VIOL" "lowerLeft" "R90" "stick" 0.0625 nil)
schCreateWire(cv "route" "full" '((6.562 1.000) (6.562 1.750)) 0 0 0 nil nil)
dbCreateInst(cv noConnMaster "noConn_D6_bottom2_C" '(6.562 1.750) "R180")
schCreateWire(cv "route" "full" '((6.188 1.000) (6.188 1.750)) 0 0 0 nil nil)
schCreateWireLabel(cv nil '(6.188 1.250) "GIOL" "lowerLeft" "R90" "stick" 0.0625 nil)
schCreateWire(cv "route" "full" '((6.062 1.000) (6.062 1.750)) 0 0 0 nil nil)
schCreateWireLabel(cv nil '(6.062 1.250) "D6_CORE" "lowerLeft" "R90" "stick" 0.0625 nil)
schCreatePin(cv nil "D6_CORE" "inputOutput" nil '(6.062 1.750) "R270")
schCreateWire(cv "route" "full" '((7.000 0.000) (7.000 -0.750)) 0 0 0 nil nil)
schCreateWireLabel(cv nil '(7.000 -0.250) "D6" "lowerRight" "R90" "stick" 0.0625 nil)
schCreatePin(cv nil "D6" "inputOutput" nil '(7.000 -0.750) "R90")
schCreateWire(cv "route" "full" '((6.688 1.000) (6.688 1.750)) 0 0 0 nil nil)
schCreateWireLabel(cv nil '(6.688 1.250) "POC" "lowerLeft" "R90" "stick" 0.0625 nil)
schCreateWire(cv "route" "full" '((6.875 1.000) (6.875 1.750)) 0 0 0 nil nil)
schCreateWireLabel(cv nil '(6.875 1.250) "VIOL" "lowerLeft" "R90" "stick" 0.0625 nil)
schCreateWire(cv "route" "full" '((7.062 1.000) (7.062 1.750)) 0 0 0 nil nil)
schCreateWireLabel(cv nil '(7.062 1.250) "GIOL" "lowerLeft" "R90" "stick" 0.0625 nil)
schCreateWire(cv "route" "full" '((7.250 1.000) (7.250 1.750)) 0 0 0 nil nil)
schCreateWireLabel(cv nil '(7.250 1.250) "VIOH" "lowerLeft" "R90" "stick" 0.0625 nil)
schCreateWire(cv "route" "full" '((7.625 1.000) (7.625 1.750)) 0 0 0 nil nil)
schCreateWireLabel(cv nil '(7.625 1.250) "GIOH" "lowerLeft" "R90" "stick" 0.0625 nil)
dbCreateInst(cv pddw16sdgz_v_gMaster "D7_bottom3" '(8.3125 0) "R0")
schCreateWire(cv "route" "full" '((8.438 1.000) (8.438 1.750)) 0 0 0 nil nil)
schCreateWireLabel(cv nil '(8.438 1.250) "VIOL" "lowerLeft" "R90" "stick" 0.0625 nil)
schCreateWire(cv "route" "full" '((8.562 1.000) (8.562 1.750)) 0 0 0 nil nil)
dbCreateInst(cv noConnMaster "noConn_D7_bottom3_C" '(8.562 1.750) "R180")
schCreateWire(cv "route" "full" '((8.188 1.000) (8.188 1.750)) 0 0 0 nil nil)
schCreateWireLabel(cv nil '(8.188 1.250) "GIOL" "lowerLeft" "R90" "stick" 0.0625 nil)
schCreateWire(cv "route" "full" '((8.062 1.000) (8.062 1.750)) 0 0 0 nil nil)
schCreateWireLabel(cv nil '(8.062 1.250) "D7_CORE" "lowerLeft" "R90" "stick" 0.0625 nil)
schCreatePin(cv nil "D7_CORE" "inputOutput" nil '(8.062 1.750) "R270")
schCreateWire(cv "route" "full" '((9.001 0.000) (9.001 -0.750)) 0 0 0 nil nil)
schCreateWireLabel(cv nil '(9.001 -0.250) "D7" "lowerRight" "R90" "stick" 0.0625 nil)
schCreatePin(cv nil "D7" "inputOutput" nil '(9.001 -0.750) "R90")
schCreateWire(cv "route" "full" '((8.688 1.000) (8.688 1.750)) 0 0 0 nil nil)
schCreateWireLabel(cv nil '(8.688 1.250) "POC" "lowerLeft" "R90" "stick" 0.0625 nil)
schCreateWire(cv "route" "full" '((8.874 1.000) (8.874 1.750)) 0 0 0 nil nil)
schCreateWireLabel(cv nil '(8.874 1.250) "VIOL" "lowerLeft" "R90" "stick" 0.0625 nil)
schCreateWire(cv "route" "full" '((9.062 1.000) (9.062 1.750)) 0 0 0 nil nil)
schCreateWireLabel(cv nil '(9.062 1.250) "GIOL" "lowerLeft" "R90" "stick" 0.0625 nil)
schCreateWire(cv "route" "full" '((9.251 1.000) (9.251 1.750)) 0 0 0 nil nil)
schCreateWireLabel(cv nil '(9.251 1.250) "VIOH" "lowerLeft" "R90" "stick" 0.0625 nil)
schCreateWire(cv "route" "full" '((9.624 1.000) (9.624 1.750)) 0 0 0 nil nil)
schCreateWireLabel(cv nil '(9.624 1.250) "GIOH" "lowerLeft" "R90" "stick" 0.0625 nil)
dbCreateInst(cv pddw16sdgz_v_gMaster "D8_bottom4" '(10.3125 0) "R0")
schCreateWire(cv "route" "full" '((10.438 1.000) (10.438 1.750)) 0 0 0 nil nil)
schCreateWireLabel(cv nil '(10.438 1.250) "VIOL" "lowerLeft" "R90" "stick" 0.0625 nil)
schCreateWire(cv "route" "full" '((10.562 1.000) (10.562 1.750)) 0 0 0 nil nil)
dbCreateInst(cv noConnMaster "noConn_D8_bottom4_C" '(10.562 1.750) "R180")
schCreateWire(cv "route" "full" '((10.188 1.000) (10.188 1.750)) 0 0 0 nil nil)
schCreateWireLabel(cv nil '(10.188 1.250) "GIOL" "lowerLeft" "R90" "stick" 0.0625 nil)
schCreateWire(cv "route" "full" '((10.062 1.000) (10.062 1.750)) 0 0 0 nil nil)
schCreateWireLabel(cv nil '(10.062 1.250) "D8_CORE" "lowerLeft" "R90" "stick" 0.0625 nil)
schCreatePin(cv nil "D8_CORE" "inputOutput" nil '(10.062 1.750) "R270")
schCreateWire(cv "route" "full" '((11.001 0.000) (11.001 -0.750)) 0 0 0 nil nil)
schCreateWireLabel(cv nil '(11.001 -0.250) "D8" "lowerRight" "R90" "stick" 0.0625 nil)
schCreatePin(cv nil "D8" "inputOutput" nil '(11.001 -0.750) "R90")
schCreateWire(cv "route" "full" '((10.688 1.000) (10.688 1.750)) 0 0 0 nil nil)
schCreateWireLabel(cv nil '(10.688 1.250) "POC" "lowerLeft" "R90" "stick" 0.0625 nil)
schCreateWire(cv "route" "full" '((10.874 1.000) (10.874 1.750)) 0 0 0 nil nil)
schCreateWireLabel(cv nil '(10.874 1.250) "VIOL" "lowerLeft" "R90" "stick" 0.0625 nil)
schCreateWire(cv "route" "full" '((11.062 1.000) (11.062 1.750)) 0 0 0 nil nil)
schCreateWireLabel(cv nil '(11.062 1.250) "GIOL" "lowerLeft" "R90" "stick" 0.0625 nil)
schCreateWire(cv "route" "full" '((11.251 1.000) (11.251 1.750)) 0 0 0 nil nil)
schCreateWireLabel(cv nil '(11.251 1.250) "VIOH" "lowerLeft" "R90" "stick" 0.0625 nil)
schCreateWire(cv "route" "full" '((11.624 1.000) (11.624 1.750)) 0 0 0 nil nil)
schCreateWireLabel(cv nil '(11.624 1.250) "GIOH" "lowerLeft" "R90" "stick" 0.0625 nil)
dbCreateInst(cv pddw16sdgz_v_gMaster "D9_bottom5" '(12.3125 0) "R0")
schCreateWire(cv "route" "full" '((12.438 1.000) (12.438 1.750)) 0 0 0 nil nil)
schCreateWireLabel(cv nil '(12.438 1.250) "VIOL" "lowerLeft" "R90" "stick" 0.0625 nil)
schCreateWire(cv "route" "full" '((12.562 1.000) (12.562 1.750)) 0 0 0 nil nil)
dbCreateInst(cv noConnMaster "noConn_D9_bottom5_C" '(12.562 1.750) "R180")
schCreateWire(cv "route" "full" '((12.188 1.000) (12.188 1.750)) 0 0 0 nil nil)
schCreateWireLabel(cv nil '(12.188 1.250) "GIOL" "lowerLeft" "R90" "stick" 0.0625 nil)
schCreateWire(cv "route" "full" '((12.062 1.000) (12.062 1.750)) 0 0 0 nil nil)
schCreateWireLabel(cv nil '(12.062 1.250) "D9_CORE" "lowerLeft" "R90" "stick" 0.0625 nil)
schCreatePin(cv nil "D9_CORE" "inputOutput" nil '(12.062 1.750) "R270")
schCreateWire(cv "route" "full" '((13.001 0.000) (13.001 -0.750)) 0 0 0 nil nil)
schCreateWireLabel(cv nil '(13.001 -0.250) "D9" "lowerRight" "R90" "stick" 0.0625 nil)
schCreatePin(cv nil "D9" "inputOutput" nil '(13.001 -0.750) "R90")
schCreateWire(cv "route" "full" '((12.688 1.000) (12.688 1.750)) 0 0 0 nil nil)
schCreateWireLabel(cv nil '(12.688 1.250) "POC" "lowerLeft" "R90" "stick" 0.0625 nil)
schCreateWire(cv "route" "full" '((12.874 1.000) (12.874 1.750)) 0 0 0 nil nil)
schCreateWireLabel(cv nil '(12.874 1.250) "VIOL" "lowerLeft" "R90" "stick" 0.0625 nil)
schCreateWire(cv "route" "full" '((13.062 1.000) (13.062 1.750)) 0 0 0 nil nil)
schCreateWireLabel(cv nil '(13.062 1.250) "GIOL" "lowerLeft" "R90" "stick" 0.0625 nil)
schCreateWire(cv "route" "full" '((13.251 1.000) (13.251 1.750)) 0 0 0 nil nil)
schCreateWireLabel(cv nil '(13.251 1.250) "VIOH" "lowerLeft" "R90" "stick" 0.0625 nil)
schCreateWire(cv "route" "full" '((13.624 1.000) (13.624 1.750)) 0 0 0 nil nil)
schCreateWireLabel(cv nil '(13.624 1.250) "GIOH" "lowerLeft" "R90" "stick" 0.0625 nil)
dbCreateInst(cv pddw16sdgz_v_gMaster "D10_bottom6" '(14.3125 0) "R0")
schCreateWire(cv "route" "full" '((14.438 1.000) (14.438 1.750)) 0 0 0 nil nil)
schCreateWireLabel(cv nil '(14.438 1.250) "VIOL" "lowerLeft" "R90" "stick" 0.0625 nil)
schCreateWire(cv "route" "full" '((14.562 1.000) (14.562 1.750)) 0 0 0 nil nil)
dbCreateInst(cv noConnMaster "noConn_D10_bottom6_C" '(14.562 1.750) "R180")
schCreateWire(cv "route" "full" '((14.188 1.000) (14.188 1.750)) 0 0 0 nil nil)
schCreateWireLabel(cv nil '(14.188 1.250) "GIOL" "lowerLeft" "R90" "stick" 0.0625 nil)
schCreateWire(cv "route" "full" '((14.062 1.000) (14.062 1.750)) 0 0 0 nil nil)
schCreateWireLabel(cv nil '(14.062 1.250) "D10_CORE" "lowerLeft" "R90" "stick" 0.0625 nil)
schCreatePin(cv nil "D10_CORE" "inputOutput" nil '(14.062 1.750) "R270")
schCreateWire(cv "route" "full" '((15.001 0.000) (15.001 -0.750)) 0 0 0 nil nil)
schCreateWireLabel(cv nil '(15.001 -0.250) "D10" "lowerRight" "R90" "stick" 0.0625 nil)
schCreatePin(cv nil "D10" "inputOutput" nil '(15.001 -0.750) "R90")
schCreateWire(cv "route" "full" '((14.688 1.000) (14.688 1.750)) 0 0 0 nil nil)
schCreateWireLabel(cv nil '(14.688 1.250) "POC" "lowerLeft" "R90" "stick" 0.0625 nil)
schCreateWire(cv "route" "full" '((14.874 1.000) (14.874 1.750)) 0 0 0 nil nil)
schCreateWireLabel(cv nil '(14.874 1.250) "VIOL" "lowerLeft" "R90" "stick" 0.0625 nil)
schCreateWire(cv "route" "full" '((15.062 1.000) (15.062 1.750)) 0 0 0 nil nil)
schCreateWireLabel(cv nil '(15.062 1.250) "GIOL" "lowerLeft" "R90" "stick" 0.0625 nil)
schCreateWire(cv "route" "full" '((15.251 1.000) (15.251 1.750)) 0 0 0 nil nil)
schCreateWireLabel(cv nil '(15.251 1.250) "VIOH" "lowerLeft" "R90" "stick" 0.0625 nil)
schCreateWire(cv "route" "full" '((15.624 1.000) (15.624 1.750)) 0 0 0 nil nil)
schCreateWireLabel(cv nil '(15.624 1.250) "GIOH" "lowerLeft" "R90" "stick" 0.0625 nil)
dbCreateInst(cv pddw16sdgz_v_gMaster "D11_bottom7" '(16.3125 0) "R0")
schCreateWire(cv "route" "full" '((16.438 1.000) (16.438 1.750)) 0 0 0 nil nil)
schCreateWireLabel(cv nil '(16.438 1.250) "VIOL" "lowerLeft" "R90" "stick" 0.0625 nil)
schCreateWire(cv "route" "full" '((16.562 1.000) (16.562 1.750)) 0 0 0 nil nil)
dbCreateInst(cv noConnMaster "noConn_D11_bottom7_C" '(16.562 1.750) "R180")
schCreateWire(cv "route" "full" '((16.188 1.000) (16.188 1.750)) 0 0 0 nil nil)
schCreateWireLabel(cv nil '(16.188 1.250) "GIOL" "lowerLeft" "R90" "stick" 0.0625 nil)
schCreateWire(cv "route" "full" '((16.062 1.000) (16.062 1.750)) 0 0 0 nil nil)
schCreateWireLabel(cv nil '(16.062 1.250) "D11_CORE" "lowerLeft" "R90" "stick" 0.0625 nil)
schCreatePin(cv nil "D11_CORE" "inputOutput" nil '(16.062 1.750) "R270")
schCreateWire(cv "route" "full" '((17.000 0.000) (17.000 -0.750)) 0 0 0 nil nil)
schCreateWireLabel(cv nil '(17.000 -0.250) "D11" "lowerRight" "R90" "stick" 0.0625 nil)
schCreatePin(cv nil "D11" "inputOutput" nil '(17.000 -0.750) "R90")
schCreateWire(cv "route" "full" '((16.688 1.000) (16.688 1.750)) 0 0 0 nil nil)
schCreateWireLabel(cv nil '(16.688 1.250) "POC" "lowerLeft" "R90" "stick" 0.0625 nil)
schCreateWire(cv "route" "full" '((16.875 1.000) (16.875 1.750)) 0 0 0 nil nil)
schCreateWireLabel(cv nil '(16.875 1.250) "VIOL" "lowerLeft" "R90" "stick" 0.0625 nil)
schCreateWire(cv "route" "full" '((17.062 1.000) (17.062 1.750)) 0 0 0 nil nil)
schCreateWireLabel(cv nil '(17.062 1.250) "GIOL" "lowerLeft" "R90" "stick" 0.0625 nil)
schCreateWire(cv "route" "full" '((17.250 1.000) (17.250 1.750)) 0 0 0 nil nil)
schCreateWireLabel(cv nil '(17.250 1.250) "VIOH" "lowerLeft" "R90" "stick" 0.0625 nil)
schCreateWire(cv "route" "full" '((17.625 1.000) (17.625 1.750)) 0 0 0 nil nil)
schCreateWireLabel(cv nil '(17.625 1.250) "GIOH" "lowerLeft" "R90" "stick" 0.0625 nil)
dbCreateInst(cv pddw16sdgz_v_gMaster "D12_bottom8" '(18.3125 0) "R0")
schCreateWire(cv "route" "full" '((18.438 1.000) (18.438 1.750)) 0 0 0 nil nil)
schCreateWireLabel(cv nil '(18.438 1.250) "VIOL" "lowerLeft" "R90" "stick" 0.0625 nil)
schCreateWire(cv "route" "full" '((18.562 1.000) (18.562 1.750)) 0 0 0 nil nil)
dbCreateInst(cv noConnMaster "noConn_D12_bottom8_C" '(18.562 1.750) "R180")
schCreateWire(cv "route" "full" '((18.188 1.000) (18.188 1.750)) 0 0 0 nil nil)
schCreateWireLabel(cv nil '(18.188 1.250) "GIOL" "lowerLeft" "R90" "stick" 0.0625 nil)
schCreateWire(cv "route" "full" '((18.062 1.000) (18.062 1.750)) 0 0 0 nil nil)
schCreateWireLabel(cv nil '(18.062 1.250) "D12_CORE" "lowerLeft" "R90" "stick" 0.0625 nil)
schCreatePin(cv nil "D12_CORE" "inputOutput" nil '(18.062 1.750) "R270")
schCreateWire(cv "route" "full" '((19.000 0.000) (19.000 -0.750)) 0 0 0 nil nil)
schCreateWireLabel(cv nil '(19.000 -0.250) "D12" "lowerRight" "R90" "stick" 0.0625 nil)
schCreatePin(cv nil "D12" "inputOutput" nil '(19.000 -0.750) "R90")
schCreateWire(cv "route" "full" '((18.688 1.000) (18.688 1.750)) 0 0 0 nil nil)
schCreateWireLabel(cv nil '(18.688 1.250) "POC" "lowerLeft" "R90" "stick" 0.0625 nil)
schCreateWire(cv "route" "full" '((18.875 1.000) (18.875 1.750)) 0 0 0 nil nil)
schCreateWireLabel(cv nil '(18.875 1.250) "VIOL" "lowerLeft" "R90" "stick" 0.0625 nil)
schCreateWire(cv "route" "full" '((19.062 1.000) (19.062 1.750)) 0 0 0 nil nil)
schCreateWireLabel(cv nil '(19.062 1.250) "GIOL" "lowerLeft" "R90" "stick" 0.0625 nil)
schCreateWire(cv "route" "full" '((19.250 1.000) (19.250 1.750)) 0 0 0 nil nil)
schCreateWireLabel(cv nil '(19.250 1.250) "VIOH" "lowerLeft" "R90" "stick" 0.0625 nil)
schCreateWire(cv "route" "full" '((19.625 1.000) (19.625 1.750)) 0 0 0 nil nil)
schCreateWireLabel(cv nil '(19.625 1.250) "GIOH" "lowerLeft" "R90" "stick" 0.0625 nil)
dbCreateInst(cv pddw16sdgz_v_gMaster "D13_bottom9" '(20.3125 0) "R0")
schCreateWire(cv "route" "full" '((20.438 1.000) (20.438 1.750)) 0 0 0 nil nil)
schCreateWireLabel(cv nil '(20.438 1.250) "VIOL" "lowerLeft" "R90" "stick" 0.0625 nil)
schCreateWire(cv "route" "full" '((20.562 1.000) (20.562 1.750)) 0 0 0 nil nil)
dbCreateInst(cv noConnMaster "noConn_D13_bottom9_C" '(20.562 1.750) "R180")
schCreateWire(cv "route" "full" '((20.188 1.000) (20.188 1.750)) 0 0 0 nil nil)
schCreateWireLabel(cv nil '(20.188 1.250) "GIOL" "lowerLeft" "R90" "stick" 0.0625 nil)
schCreateWire(cv "route" "full" '((20.062 1.000) (20.062 1.750)) 0 0 0 nil nil)
schCreateWireLabel(cv nil '(20.062 1.250) "D13_CORE" "lowerLeft" "R90" "stick" 0.0625 nil)
schCreatePin(cv nil "D13_CORE" "inputOutput" nil '(20.062 1.750) "R270")
schCreateWire(cv "route" "full" '((21.000 0.000) (21.000 -0.750)) 0 0 0 nil nil)
schCreateWireLabel(cv nil '(21.000 -0.250) "D13" "lowerRight" "R90" "stick" 0.0625 nil)
schCreatePin(cv nil "D13" "inputOutput" nil '(21.000 -0.750) "R90")
schCreateWire(cv "route" "full" '((20.688 1.000) (20.688 1.750)) 0 0 0 nil nil)
schCreateWireLabel(cv nil '(20.688 1.250) "POC" "lowerLeft" "R90" "stick" 0.0625 nil)
schCreateWire(cv "route" "full" '((20.875 1.000) (20.875 1.750)) 0 0 0 nil nil)
schCreateWireLabel(cv nil '(20.875 1.250) "VIOL" "lowerLeft" "R90" "stick" 0.0625 nil)
schCreateWire(cv "route" "full" '((21.062 1.000) (21.062 1.750)) 0 0 0 nil nil)
schCreateWireLabel(cv nil '(21.062 1.250) "GIOL" "lowerLeft" "R90" "stick" 0.0625 nil)
schCreateWire(cv "route" "full" '((21.250 1.000) (21.250 1.750)) 0 0 0 nil nil)
schCreateWireLabel(cv nil '(21.250 1.250) "VIOH" "lowerLeft" "R90" "stick" 0.0625 nil)
schCreateWire(cv "route" "full" '((21.625 1.000) (21.625 1.750)) 0 0 0 nil nil)
schCreateWireLabel(cv nil '(21.625 1.250) "GIOH" "lowerLeft" "R90" "stick" 0.0625 nil)
dbCreateInst(cv pddw16sdgz_v_gMaster "D14_bottom10" '(22.3125 0) "R0")
schCreateWire(cv "route" "full" '((22.438 1.000) (22.438 1.750)) 0 0 0 nil nil)
schCreateWireLabel(cv nil '(22.438 1.250) "VIOL" "lowerLeft" "R90" "stick" 0.0625 nil)
schCreateWire(cv "route" "full" '((22.562 1.000) (22.562 1.750)) 0 0 0 nil nil)
dbCreateInst(cv noConnMaster "noConn_D14_bottom10_C" '(22.562 1.750) "R180")
schCreateWire(cv "route" "full" '((22.188 1.000) (22.188 1.750)) 0 0 0 nil nil)
schCreateWireLabel(cv nil '(22.188 1.250) "GIOL" "lowerLeft" "R90" "stick" 0.0625 nil)
schCreateWire(cv "route" "full" '((22.062 1.000) (22.062 1.750)) 0 0 0 nil nil)
schCreateWireLabel(cv nil '(22.062 1.250) "D14_CORE" "lowerLeft" "R90" "stick" 0.0625 nil)
schCreatePin(cv nil "D14_CORE" "inputOutput" nil '(22.062 1.750) "R270")
schCreateWire(cv "route" "full" '((23.000 0.000) (23.000 -0.750)) 0 0 0 nil nil)
schCreateWireLabel(cv nil '(23.000 -0.250) "D14" "lowerRight" "R90" "stick" 0.0625 nil)
schCreatePin(cv nil "D14" "inputOutput" nil '(23.000 -0.750) "R90")
schCreateWire(cv "route" "full" '((22.688 1.000) (22.688 1.750)) 0 0 0 nil nil)
schCreateWireLabel(cv nil '(22.688 1.250) "POC" "lowerLeft" "R90" "stick" 0.0625 nil)
schCreateWire(cv "route" "full" '((22.875 1.000) (22.875 1.750)) 0 0 0 nil nil)
schCreateWireLabel(cv nil '(22.875 1.250) "VIOL" "lowerLeft" "R90" "stick" 0.0625 nil)
schCreateWire(cv "route" "full" '((23.062 1.000) (23.062 1.750)) 0 0 0 nil nil)
schCreateWireLabel(cv nil '(23.062 1.250) "GIOL" "lowerLeft" "R90" "stick" 0.0625 nil)
schCreateWire(cv "route" "full" '((23.250 1.000) (23.250 1.750)) 0 0 0 nil nil)
schCreateWireLabel(cv nil '(23.250 1.250) "VIOH" "lowerLeft" "R90" "stick" 0.0625 nil)
schCreateWire(cv "route" "full" '((23.625 1.000) (23.625 1.750)) 0 0 0 nil nil)
schCreateWireLabel(cv nil '(23.625 1.250) "GIOH" "lowerLeft" "R90" "stick" 0.0625 nil)
dbCreateInst(cv pddw16sdgz_v_gMaster "D15_bottom11" '(24.3125 0) "R0")
schCreateWire(cv "route" "full" '((24.438 1.000) (24.438 1.750)) 0 0 0 nil nil)
schCreateWireLabel(cv nil '(24.438 1.250) "VIOL" "lowerLeft" "R90" "stick" 0.0625 nil)
schCreateWire(cv "route" "full" '((24.562 1.000) (24.562 1.750)) 0 0 0 nil nil)
dbCreateInst(cv noConnMaster "noConn_D15_bottom11_C" '(24.562 1.750) "R180")
schCreateWire(cv "route" "full" '((24.188 1.000) (24.188 1.750)) 0 0 0 nil nil)
schCreateWireLabel(cv nil '(24.188 1.250) "GIOL" "lowerLeft" "R90" "stick" 0.0625 nil)
schCreateWire(cv "route" "full" '((24.062 1.000) (24.062 1.750)) 0 0 0 nil nil)
schCreateWireLabel(cv nil '(24.062 1.250) "D15_CORE" "lowerLeft" "R90" "stick" 0.0625 nil)
schCreatePin(cv nil "D15_CORE" "inputOutput" nil '(24.062 1.750) "R270")
schCreateWire(cv "route" "full" '((25.000 0.000) (25.000 -0.750)) 0 0 0 nil nil)
schCreateWireLabel(cv nil '(25.000 -0.250) "D15" "lowerRight" "R90" "stick" 0.0625 nil)
schCreatePin(cv nil "D15" "inputOutput" nil '(25.000 -0.750) "R90")
schCreateWire(cv "route" "full" '((24.688 1.000) (24.688 1.750)) 0 0 0 nil nil)
schCreateWireLabel(cv nil '(24.688 1.250) "POC" "lowerLeft" "R90" "stick" 0.0625 nil)
schCreateWire(cv "route" "full" '((24.875 1.000) (24.875 1.750)) 0 0 0 nil nil)
schCreateWireLabel(cv nil '(24.875 1.250) "VIOL" "lowerLeft" "R90" "stick" 0.0625 nil)
schCreateWire(cv "route" "full" '((25.062 1.000) (25.062 1.750)) 0 0 0 nil nil)
schCreateWireLabel(cv nil '(25.062 1.250) "GIOL" "lowerLeft" "R90" "stick" 0.0625 nil)
schCreateWire(cv "route" "full" '((25.250 1.000) (25.250 1.750)) 0 0 0 nil nil)
schCreateWireLabel(cv nil '(25.250 1.250) "VIOH" "lowerLeft" "R90" "stick" 0.0625 nil)
schCreateWire(cv "route" "full" '((25.625 1.000) (25.625 1.750)) 0 0 0 nil nil)
schCreateWireLabel(cv nil '(25.625 1.250) "GIOH" "lowerLeft" "R90" "stick" 0.0625 nil)
dbCreateInst(cv pddw16sdgz_h_gMaster "D16_right0" '(28.0 2.3125) "R90")
schCreateWire(cv "route" "full" '((27.000 2.438) (26.250 2.438)) 0 0 0 nil nil)
schCreateWireLabel(cv nil '(26.750 2.438) "VIOL" "lowerRight" "R0" "stick" 0.0625 nil)
schCreateWire(cv "route" "full" '((27.000 2.562) (26.250 2.562)) 0 0 0 nil nil)
dbCreateInst(cv noConnMaster "noConn_D16_right0_C" '(26.250 2.562) "R270")
schCreateWire(cv "route" "full" '((27.000 2.188) (26.250 2.188)) 0 0 0 nil nil)
schCreateWireLabel(cv nil '(26.750 2.188) "GIOL" "lowerRight" "R0" "stick" 0.0625 nil)
schCreateWire(cv "route" "full" '((27.000 2.062) (26.250 2.062)) 0 0 0 nil nil)
schCreateWireLabel(cv nil '(26.750 2.062) "D16_CORE" "lowerRight" "R0" "stick" 0.0625 nil)
schCreatePin(cv nil "D16_CORE" "inputOutput" nil '(26.250 2.062) "R0")
schCreateWire(cv "route" "full" '((28.000 3.000) (28.750 3.000)) 0 0 0 nil nil)
schCreateWireLabel(cv nil '(28.250 3.000) "D16" "lowerLeft" "R0" "stick" 0.0625 nil)
schCreatePin(cv nil "D16" "inputOutput" nil '(28.750 3.000) "R180")
schCreateWire(cv "route" "full" '((27.000 2.688) (26.250 2.688)) 0 0 0 nil nil)
schCreateWireLabel(cv nil '(26.750 2.688) "POC" "lowerRight" "R0" "stick" 0.0625 nil)
schCreateWire(cv "route" "full" '((27.000 2.875) (26.250 2.875)) 0 0 0 nil nil)
schCreateWireLabel(cv nil '(26.750 2.875) "VIOL" "lowerRight" "R0" "stick" 0.0625 nil)
schCreateWire(cv "route" "full" '((27.000 3.062) (26.250 3.062)) 0 0 0 nil nil)
schCreateWireLabel(cv nil '(26.750 3.062) "GIOL" "lowerRight" "R0" "stick" 0.0625 nil)
schCreateWire(cv "route" "full" '((27.000 3.250) (26.250 3.250)) 0 0 0 nil nil)
schCreateWireLabel(cv nil '(26.750 3.250) "VIOH" "lowerRight" "R0" "stick" 0.0625 nil)
schCreateWire(cv "route" "full" '((27.000 3.625) (26.250 3.625)) 0 0 0 nil nil)
schCreateWireLabel(cv nil '(26.750 3.625) "GIOH" "lowerRight" "R0" "stick" 0.0625 nil)
dbCreateInst(cv pddw16sdgz_h_gMaster "D17_right1" '(28.0 4.3125) "R90")
schCreateWire(cv "route" "full" '((27.000 4.438) (26.250 4.438)) 0 0 0 nil nil)
schCreateWireLabel(cv nil '(26.750 4.438) "VIOL" "lowerRight" "R0" "stick" 0.0625 nil)
schCreateWire(cv "route" "full" '((27.000 4.562) (26.250 4.562)) 0 0 0 nil nil)
dbCreateInst(cv noConnMaster "noConn_D17_right1_C" '(26.250 4.562) "R270")
schCreateWire(cv "route" "full" '((27.000 4.188) (26.250 4.188)) 0 0 0 nil nil)
schCreateWireLabel(cv nil '(26.750 4.188) "GIOL" "lowerRight" "R0" "stick" 0.0625 nil)
schCreateWire(cv "route" "full" '((27.000 4.062) (26.250 4.062)) 0 0 0 nil nil)
schCreateWireLabel(cv nil '(26.750 4.062) "D17_CORE" "lowerRight" "R0" "stick" 0.0625 nil)
schCreatePin(cv nil "D17_CORE" "inputOutput" nil '(26.250 4.062) "R0")
schCreateWire(cv "route" "full" '((28.000 5.000) (28.750 5.000)) 0 0 0 nil nil)
schCreateWireLabel(cv nil '(28.250 5.000) "D17" "lowerLeft" "R0" "stick" 0.0625 nil)
schCreatePin(cv nil "D17" "inputOutput" nil '(28.750 5.000) "R180")
schCreateWire(cv "route" "full" '((27.000 4.688) (26.250 4.688)) 0 0 0 nil nil)
schCreateWireLabel(cv nil '(26.750 4.688) "POC" "lowerRight" "R0" "stick" 0.0625 nil)
schCreateWire(cv "route" "full" '((27.000 4.875) (26.250 4.875)) 0 0 0 nil nil)
schCreateWireLabel(cv nil '(26.750 4.875) "VIOL" "lowerRight" "R0" "stick" 0.0625 nil)
schCreateWire(cv "route" "full" '((27.000 5.062) (26.250 5.062)) 0 0 0 nil nil)
schCreateWireLabel(cv nil '(26.750 5.062) "GIOL" "lowerRight" "R0" "stick" 0.0625 nil)
schCreateWire(cv "route" "full" '((27.000 5.250) (26.250 5.250)) 0 0 0 nil nil)
schCreateWireLabel(cv nil '(26.750 5.250) "VIOH" "lowerRight" "R0" "stick" 0.0625 nil)
schCreateWire(cv "route" "full" '((27.000 5.625) (26.250 5.625)) 0 0 0 nil nil)
schCreateWireLabel(cv nil '(26.750 5.625) "GIOH" "lowerRight" "R0" "stick" 0.0625 nil)
dbCreateInst(cv pddw16sdgz_h_gMaster "D18_right2" '(28.0 6.3125) "R90")
schCreateWire(cv "route" "full" '((27.000 6.438) (26.250 6.438)) 0 0 0 nil nil)
schCreateWireLabel(cv nil '(26.750 6.438) "VIOL" "lowerRight" "R0" "stick" 0.0625 nil)
schCreateWire(cv "route" "full" '((27.000 6.562) (26.250 6.562)) 0 0 0 nil nil)
dbCreateInst(cv noConnMaster "noConn_D18_right2_C" '(26.250 6.562) "R270")
schCreateWire(cv "route" "full" '((27.000 6.188) (26.250 6.188)) 0 0 0 nil nil)
schCreateWireLabel(cv nil '(26.750 6.188) "GIOL" "lowerRight" "R0" "stick" 0.0625 nil)
schCreateWire(cv "route" "full" '((27.000 6.062) (26.250 6.062)) 0 0 0 nil nil)
schCreateWireLabel(cv nil '(26.750 6.062) "D18_CORE" "lowerRight" "R0" "stick" 0.0625 nil)
schCreatePin(cv nil "D18_CORE" "inputOutput" nil '(26.250 6.062) "R0")
schCreateWire(cv "route" "full" '((28.000 7.000) (28.750 7.000)) 0 0 0 nil nil)
schCreateWireLabel(cv nil '(28.250 7.000) "D18" "lowerLeft" "R0" "stick" 0.0625 nil)
schCreatePin(cv nil "D18" "inputOutput" nil '(28.750 7.000) "R180")
schCreateWire(cv "route" "full" '((27.000 6.688) (26.250 6.688)) 0 0 0 nil nil)
schCreateWireLabel(cv nil '(26.750 6.688) "POC" "lowerRight" "R0" "stick" 0.0625 nil)
schCreateWire(cv "route" "full" '((27.000 6.875) (26.250 6.875)) 0 0 0 nil nil)
schCreateWireLabel(cv nil '(26.750 6.875) "VIOL" "lowerRight" "R0" "stick" 0.0625 nil)
schCreateWire(cv "route" "full" '((27.000 7.062) (26.250 7.062)) 0 0 0 nil nil)
schCreateWireLabel(cv nil '(26.750 7.062) "GIOL" "lowerRight" "R0" "stick" 0.0625 nil)
schCreateWire(cv "route" "full" '((27.000 7.250) (26.250 7.250)) 0 0 0 nil nil)
schCreateWireLabel(cv nil '(26.750 7.250) "VIOH" "lowerRight" "R0" "stick" 0.0625 nil)
schCreateWire(cv "route" "full" '((27.000 7.625) (26.250 7.625)) 0 0 0 nil nil)
schCreateWireLabel(cv nil '(26.750 7.625) "GIOH" "lowerRight" "R0" "stick" 0.0625 nil)
dbCreateInst(cv pddw16sdgz_h_gMaster "D19_right3" '(28.0 8.3125) "R90")
schCreateWire(cv "route" "full" '((27.000 8.438) (26.250 8.438)) 0 0 0 nil nil)
schCreateWireLabel(cv nil '(26.750 8.438) "VIOL" "lowerRight" "R0" "stick" 0.0625 nil)
schCreateWire(cv "route" "full" '((27.000 8.562) (26.250 8.562)) 0 0 0 nil nil)
dbCreateInst(cv noConnMaster "noConn_D19_right3_C" '(26.250 8.562) "R270")
schCreateWire(cv "route" "full" '((27.000 8.188) (26.250 8.188)) 0 0 0 nil nil)
schCreateWireLabel(cv nil '(26.750 8.188) "GIOL" "lowerRight" "R0" "stick" 0.0625 nil)
schCreateWire(cv "route" "full" '((27.000 8.062) (26.250 8.062)) 0 0 0 nil nil)
schCreateWireLabel(cv nil '(26.750 8.062) "D19_CORE" "lowerRight" "R0" "stick" 0.0625 nil)
schCreatePin(cv nil "D19_CORE" "inputOutput" nil '(26.250 8.062) "R0")
schCreateWire(cv "route" "full" '((28.000 9.001) (28.750 9.001)) 0 0 0 nil nil)
schCreateWireLabel(cv nil '(28.250 9.001) "D19" "lowerLeft" "R0" "stick" 0.0625 nil)
schCreatePin(cv nil "D19" "inputOutput" nil '(28.750 9.001) "R180")
schCreateWire(cv "route" "full" '((27.000 8.688) (26.250 8.688)) 0 0 0 nil nil)
schCreateWireLabel(cv nil '(26.750 8.688) "POC" "lowerRight" "R0" "stick" 0.0625 nil)
schCreateWire(cv "route" "full" '((27.000 8.874) (26.250 8.874)) 0 0 0 nil nil)
schCreateWireLabel(cv nil '(26.750 8.874) "VIOL" "lowerRight" "R0" "stick" 0.0625 nil)
schCreateWire(cv "route" "full" '((27.000 9.062) (26.250 9.062)) 0 0 0 nil nil)
schCreateWireLabel(cv nil '(26.750 9.062) "GIOL" "lowerRight" "R0" "stick" 0.0625 nil)
schCreateWire(cv "route" "full" '((27.000 9.251) (26.250 9.251)) 0 0 0 nil nil)
schCreateWireLabel(cv nil '(26.750 9.251) "VIOH" "lowerRight" "R0" "stick" 0.0625 nil)
schCreateWire(cv "route" "full" '((27.000 9.624) (26.250 9.624)) 0 0 0 nil nil)
schCreateWireLabel(cv nil '(26.750 9.624) "GIOH" "lowerRight" "R0" "stick" 0.0625 nil)
dbCreateInst(cv pddw16sdgz_h_gMaster "D20_right4" '(28.0 10.3125) "R90")
schCreateWire(cv "route" "full" '((27.000 10.438) (26.250 10.438)) 0 0 0 nil nil)
schCreateWireLabel(cv nil '(26.750 10.438) "VIOL" "lowerRight" "R0" "stick" 0.0625 nil)
schCreateWire(cv "route" "full" '((27.000 10.562) (26.250 10.562)) 0 0 0 nil nil)
dbCreateInst(cv noConnMaster "noConn_D20_right4_C" '(26.250 10.562) "R270")
schCreateWire(cv "route" "full" '((27.000 10.188) (26.250 10.188)) 0 0 0 nil nil)
schCreateWireLabel(cv nil '(26.750 10.188) "GIOL" "lowerRight" "R0" "stick" 0.0625 nil)
schCreateWire(cv "route" "full" '((27.000 10.062) (26.250 10.062)) 0 0 0 nil nil)
schCreateWireLabel(cv nil '(26.750 10.062) "D20_CORE" "lowerRight" "R0" "stick" 0.0625 nil)
schCreatePin(cv nil "D20_CORE" "inputOutput" nil '(26.250 10.062) "R0")
schCreateWire(cv "route" "full" '((28.000 11.001) (28.750 11.001)) 0 0 0 nil nil)
schCreateWireLabel(cv nil '(28.250 11.001) "D20" "lowerLeft" "R0" "stick" 0.0625 nil)
schCreatePin(cv nil "D20" "inputOutput" nil '(28.750 11.001) "R180")
schCreateWire(cv "route" "full" '((27.000 10.688) (26.250 10.688)) 0 0 0 nil nil)
schCreateWireLabel(cv nil '(26.750 10.688) "POC" "lowerRight" "R0" "stick" 0.0625 nil)
schCreateWire(cv "route" "full" '((27.000 10.874) (26.250 10.874)) 0 0 0 nil nil)
schCreateWireLabel(cv nil '(26.750 10.874) "VIOL" "lowerRight" "R0" "stick" 0.0625 nil)
schCreateWire(cv "route" "full" '((27.000 11.062) (26.250 11.062)) 0 0 0 nil nil)
schCreateWireLabel(cv nil '(26.750 11.062) "GIOL" "lowerRight" "R0" "stick" 0.0625 nil)
schCreateWire(cv "route" "full" '((27.000 11.251) (26.250 11.251)) 0 0 0 nil nil)
schCreateWireLabel(cv nil '(26.750 11.251) "VIOH" "lowerRight" "R0" "stick" 0.0625 nil)
schCreateWire(cv "route" "full" '((27.000 11.624) (26.250 11.624)) 0 0 0 nil nil)
schCreateWireLabel(cv nil '(26.750 11.624) "GIOH" "lowerRight" "R0" "stick" 0.0625 nil)
dbCreateInst(cv pddw16sdgz_h_gMaster "D21_right5" '(28.0 12.3125) "R90")
schCreateWire(cv "route" "full" '((27.000 12.438) (26.250 12.438)) 0 0 0 nil nil)
schCreateWireLabel(cv nil '(26.750 12.438) "VIOL" "lowerRight" "R0" "stick" 0.0625 nil)
schCreateWire(cv "route" "full" '((27.000 12.562) (26.250 12.562)) 0 0 0 nil nil)
dbCreateInst(cv noConnMaster "noConn_D21_right5_C" '(26.250 12.562) "R270")
schCreateWire(cv "route" "full" '((27.000 12.188) (26.250 12.188)) 0 0 0 nil nil)
schCreateWireLabel(cv nil '(26.750 12.188) "GIOL" "lowerRight" "R0" "stick" 0.0625 nil)
schCreateWire(cv "route" "full" '((27.000 12.062) (26.250 12.062)) 0 0 0 nil nil)
schCreateWireLabel(cv nil '(26.750 12.062) "D21_CORE" "lowerRight" "R0" "stick" 0.0625 nil)
schCreatePin(cv nil "D21_CORE" "inputOutput" nil '(26.250 12.062) "R0")
schCreateWire(cv "route" "full" '((28.000 13.001) (28.750 13.001)) 0 0 0 nil nil)
schCreateWireLabel(cv nil '(28.250 13.001) "D21" "lowerLeft" "R0" "stick" 0.0625 nil)
schCreatePin(cv nil "D21" "inputOutput" nil '(28.750 13.001) "R180")
schCreateWire(cv "route" "full" '((27.000 12.688) (26.250 12.688)) 0 0 0 nil nil)
schCreateWireLabel(cv nil '(26.750 12.688) "POC" "lowerRight" "R0" "stick" 0.0625 nil)
schCreateWire(cv "route" "full" '((27.000 12.874) (26.250 12.874)) 0 0 0 nil nil)
schCreateWireLabel(cv nil '(26.750 12.874) "VIOL" "lowerRight" "R0" "stick" 0.0625 nil)
schCreateWire(cv "route" "full" '((27.000 13.062) (26.250 13.062)) 0 0 0 nil nil)
schCreateWireLabel(cv nil '(26.750 13.062) "GIOL" "lowerRight" "R0" "stick" 0.0625 nil)
schCreateWire(cv "route" "full" '((27.000 13.251) (26.250 13.251)) 0 0 0 nil nil)
schCreateWireLabel(cv nil '(26.750 13.251) "VIOH" "lowerRight" "R0" "stick" 0.0625 nil)
schCreateWire(cv "route" "full" '((27.000 13.624) (26.250 13.624)) 0 0 0 nil nil)
schCreateWireLabel(cv nil '(26.750 13.624) "GIOH" "lowerRight" "R0" "stick" 0.0625 nil)
dbCreateInst(cv pddw16sdgz_h_gMaster "D22_right6" '(28.0 14.3125) "R90")
schCreateWire(cv "route" "full" '((27.000 14.438) (26.250 14.438)) 0 0 0 nil nil)
schCreateWireLabel(cv nil '(26.750 14.438) "VIOL" "lowerRight" "R0" "stick" 0.0625 nil)
schCreateWire(cv "route" "full" '((27.000 14.562) (26.250 14.562)) 0 0 0 nil nil)
dbCreateInst(cv noConnMaster "noConn_D22_right6_C" '(26.250 14.562) "R270")
schCreateWire(cv "route" "full" '((27.000 14.188) (26.250 14.188)) 0 0 0 nil nil)
schCreateWireLabel(cv nil '(26.750 14.188) "GIOL" "lowerRight" "R0" "stick" 0.0625 nil)
schCreateWire(cv "route" "full" '((27.000 14.062) (26.250 14.062)) 0 0 0 nil nil)
schCreateWireLabel(cv nil '(26.750 14.062) "D22_CORE" "lowerRight" "R0" "stick" 0.0625 nil)
schCreatePin(cv nil "D22_CORE" "inputOutput" nil '(26.250 14.062) "R0")
schCreateWire(cv "route" "full" '((28.000 15.001) (28.750 15.001)) 0 0 0 nil nil)
schCreateWireLabel(cv nil '(28.250 15.001) "D22" "lowerLeft" "R0" "stick" 0.0625 nil)
schCreatePin(cv nil "D22" "inputOutput" nil '(28.750 15.001) "R180")
schCreateWire(cv "route" "full" '((27.000 14.688) (26.250 14.688)) 0 0 0 nil nil)
schCreateWireLabel(cv nil '(26.750 14.688) "POC" "lowerRight" "R0" "stick" 0.0625 nil)
schCreateWire(cv "route" "full" '((27.000 14.874) (26.250 14.874)) 0 0 0 nil nil)
schCreateWireLabel(cv nil '(26.750 14.874) "VIOL" "lowerRight" "R0" "stick" 0.0625 nil)
schCreateWire(cv "route" "full" '((27.000 15.062) (26.250 15.062)) 0 0 0 nil nil)
schCreateWireLabel(cv nil '(26.750 15.062) "GIOL" "lowerRight" "R0" "stick" 0.0625 nil)
schCreateWire(cv "route" "full" '((27.000 15.251) (26.250 15.251)) 0 0 0 nil nil)
schCreateWireLabel(cv nil '(26.750 15.251) "VIOH" "lowerRight" "R0" "stick" 0.0625 nil)
schCreateWire(cv "route" "full" '((27.000 15.624) (26.250 15.624)) 0 0 0 nil nil)
schCreateWireLabel(cv nil '(26.750 15.624) "GIOH" "lowerRight" "R0" "stick" 0.0625 nil)
dbCreateInst(cv pddw16sdgz_h_gMaster "D23_right7" '(28.0 16.3125) "R90")
schCreateWire(cv "route" "full" '((27.000 16.438) (26.250 16.438)) 0 0 0 nil nil)
schCreateWireLabel(cv nil '(26.750 16.438) "VIOL" "lowerRight" "R0" "stick" 0.0625 nil)
schCreateWire(cv "route" "full" '((27.000 16.562) (26.250 16.562)) 0 0 0 nil nil)
dbCreateInst(cv noConnMaster "noConn_D23_right7_C" '(26.250 16.562) "R270")
schCreateWire(cv "route" "full" '((27.000 16.188) (26.250 16.188)) 0 0 0 nil nil)
schCreateWireLabel(cv nil '(26.750 16.188) "GIOL" "lowerRight" "R0" "stick" 0.0625 nil)
schCreateWire(cv "route" "full" '((27.000 16.062) (26.250 16.062)) 0 0 0 nil nil)
schCreateWireLabel(cv nil '(26.750 16.062) "D23_CORE" "lowerRight" "R0" "stick" 0.0625 nil)
schCreatePin(cv nil "D23_CORE" "inputOutput" nil '(26.250 16.062) "R0")
schCreateWire(cv "route" "full" '((28.000 17.000) (28.750 17.000)) 0 0 0 nil nil)
schCreateWireLabel(cv nil '(28.250 17.000) "D23" "lowerLeft" "R0" "stick" 0.0625 nil)
schCreatePin(cv nil "D23" "inputOutput" nil '(28.750 17.000) "R180")
schCreateWire(cv "route" "full" '((27.000 16.688) (26.250 16.688)) 0 0 0 nil nil)
schCreateWireLabel(cv nil '(26.750 16.688) "POC" "lowerRight" "R0" "stick" 0.0625 nil)
schCreateWire(cv "route" "full" '((27.000 16.875) (26.250 16.875)) 0 0 0 nil nil)
schCreateWireLabel(cv nil '(26.750 16.875) "VIOL" "lowerRight" "R0" "stick" 0.0625 nil)
schCreateWire(cv "route" "full" '((27.000 17.062) (26.250 17.062)) 0 0 0 nil nil)
schCreateWireLabel(cv nil '(26.750 17.062) "GIOL" "lowerRight" "R0" "stick" 0.0625 nil)
schCreateWire(cv "route" "full" '((27.000 17.250) (26.250 17.250)) 0 0 0 nil nil)
schCreateWireLabel(cv nil '(26.750 17.250) "VIOH" "lowerRight" "R0" "stick" 0.0625 nil)
schCreateWire(cv "route" "full" '((27.000 17.625) (26.250 17.625)) 0 0 0 nil nil)
schCreateWireLabel(cv nil '(26.750 17.625) "GIOH" "lowerRight" "R0" "stick" 0.0625 nil)
dbCreateInst(cv pddw16sdgz_h_gMaster "D24_right8" '(28.0 18.3125) "R90")
schCreateWire(cv "route" "full" '((27.000 18.438) (26.250 18.438)) 0 0 0 nil nil)
schCreateWireLabel(cv nil '(26.750 18.438) "VIOL" "lowerRight" "R0" "stick" 0.0625 nil)
schCreateWire(cv "route" "full" '((27.000 18.562) (26.250 18.562)) 0 0 0 nil nil)
dbCreateInst(cv noConnMaster "noConn_D24_right8_C" '(26.250 18.562) "R270")
schCreateWire(cv "route" "full" '((27.000 18.188) (26.250 18.188)) 0 0 0 nil nil)
schCreateWireLabel(cv nil '(26.750 18.188) "GIOL" "lowerRight" "R0" "stick" 0.0625 nil)
schCreateWire(cv "route" "full" '((27.000 18.062) (26.250 18.062)) 0 0 0 nil nil)
schCreateWireLabel(cv nil '(26.750 18.062) "D24_CORE" "lowerRight" "R0" "stick" 0.0625 nil)
schCreatePin(cv nil "D24_CORE" "inputOutput" nil '(26.250 18.062) "R0")
schCreateWire(cv "route" "full" '((28.000 19.000) (28.750 19.000)) 0 0 0 nil nil)
schCreateWireLabel(cv nil '(28.250 19.000) "D24" "lowerLeft" "R0" "stick" 0.0625 nil)
schCreatePin(cv nil "D24" "inputOutput" nil '(28.750 19.000) "R180")
schCreateWire(cv "route" "full" '((27.000 18.688) (26.250 18.688)) 0 0 0 nil nil)
schCreateWireLabel(cv nil '(26.750 18.688) "POC" "lowerRight" "R0" "stick" 0.0625 nil)
schCreateWire(cv "route" "full" '((27.000 18.875) (26.250 18.875)) 0 0 0 nil nil)
schCreateWireLabel(cv nil '(26.750 18.875) "VIOL" "lowerRight" "R0" "stick" 0.0625 nil)
schCreateWire(cv "route" "full" '((27.000 19.062) (26.250 19.062)) 0 0 0 nil nil)
schCreateWireLabel(cv nil '(26.750 19.062) "GIOL" "lowerRight" "R0" "stick" 0.0625 nil)
schCreateWire(cv "route" "full" '((27.000 19.250) (26.250 19.250)) 0 0 0 nil nil)
schCreateWireLabel(cv nil '(26.750 19.250) "VIOH" "lowerRight" "R0" "stick" 0.0625 nil)
schCreateWire(cv "route" "full" '((27.000 19.625) (26.250 19.625)) 0 0 0 nil nil)
schCreateWireLabel(cv nil '(26.750 19.625) "GIOH" "lowerRight" "R0" "stick" 0.0625 nil)
dbCreateInst(cv pddw16sdgz_h_gMaster "D25_right9" '(28.0 20.3125) "R90")
schCreateWire(cv "route" "full" '((27.000 20.438) (26.250 20.438)) 0 0 0 nil nil)
schCreateWireLabel(cv nil '(26.750 20.438) "VIOL" "lowerRight" "R0" "stick" 0.0625 nil)
schCreateWire(cv "route" "full" '((27.000 20.562) (26.250 20.562)) 0 0 0 nil nil)
dbCreateInst(cv noConnMaster "noConn_D25_right9_C" '(26.250 20.562) "R270")
schCreateWire(cv "route" "full" '((27.000 20.188) (26.250 20.188)) 0 0 0 nil nil)
schCreateWireLabel(cv nil '(26.750 20.188) "GIOL" "lowerRight" "R0" "stick" 0.0625 nil)
schCreateWire(cv "route" "full" '((27.000 20.062) (26.250 20.062)) 0 0 0 nil nil)
schCreateWireLabel(cv nil '(26.750 20.062) "D25_CORE" "lowerRight" "R0" "stick" 0.0625 nil)
schCreatePin(cv nil "D25_CORE" "inputOutput" nil '(26.250 20.062) "R0")
schCreateWire(cv "route" "full" '((28.000 21.000) (28.750 21.000)) 0 0 0 nil nil)
schCreateWireLabel(cv nil '(28.250 21.000) "D25" "lowerLeft" "R0" "stick" 0.0625 nil)
schCreatePin(cv nil "D25" "inputOutput" nil '(28.750 21.000) "R180")
schCreateWire(cv "route" "full" '((27.000 20.688) (26.250 20.688)) 0 0 0 nil nil)
schCreateWireLabel(cv nil '(26.750 20.688) "POC" "lowerRight" "R0" "stick" 0.0625 nil)
schCreateWire(cv "route" "full" '((27.000 20.875) (26.250 20.875)) 0 0 0 nil nil)
schCreateWireLabel(cv nil '(26.750 20.875) "VIOL" "lowerRight" "R0" "stick" 0.0625 nil)
schCreateWire(cv "route" "full" '((27.000 21.062) (26.250 21.062)) 0 0 0 nil nil)
schCreateWireLabel(cv nil '(26.750 21.062) "GIOL" "lowerRight" "R0" "stick" 0.0625 nil)
schCreateWire(cv "route" "full" '((27.000 21.250) (26.250 21.250)) 0 0 0 nil nil)
schCreateWireLabel(cv nil '(26.750 21.250) "VIOH" "lowerRight" "R0" "stick" 0.0625 nil)
schCreateWire(cv "route" "full" '((27.000 21.625) (26.250 21.625)) 0 0 0 nil nil)
schCreateWireLabel(cv nil '(26.750 21.625) "GIOH" "lowerRight" "R0" "stick" 0.0625 nil)
dbCreateInst(cv pddw16sdgz_h_gMaster "D26_right10" '(28.0 22.3125) "R90")
schCreateWire(cv "route" "full" '((27.000 22.438) (26.250 22.438)) 0 0 0 nil nil)
schCreateWireLabel(cv nil '(26.750 22.438) "VIOL" "lowerRight" "R0" "stick" 0.0625 nil)
schCreateWire(cv "route" "full" '((27.000 22.562) (26.250 22.562)) 0 0 0 nil nil)
dbCreateInst(cv noConnMaster "noConn_D26_right10_C" '(26.250 22.562) "R270")
schCreateWire(cv "route" "full" '((27.000 22.188) (26.250 22.188)) 0 0 0 nil nil)
schCreateWireLabel(cv nil '(26.750 22.188) "GIOL" "lowerRight" "R0" "stick" 0.0625 nil)
schCreateWire(cv "route" "full" '((27.000 22.062) (26.250 22.062)) 0 0 0 nil nil)
schCreateWireLabel(cv nil '(26.750 22.062) "D26_CORE" "lowerRight" "R0" "stick" 0.0625 nil)
schCreatePin(cv nil "D26_CORE" "inputOutput" nil '(26.250 22.062) "R0")
schCreateWire(cv "route" "full" '((28.000 23.000) (28.750 23.000)) 0 0 0 nil nil)
schCreateWireLabel(cv nil '(28.250 23.000) "D26" "lowerLeft" "R0" "stick" 0.0625 nil)
schCreatePin(cv nil "D26" "inputOutput" nil '(28.750 23.000) "R180")
schCreateWire(cv "route" "full" '((27.000 22.688) (26.250 22.688)) 0 0 0 nil nil)
schCreateWireLabel(cv nil '(26.750 22.688) "POC" "lowerRight" "R0" "stick" 0.0625 nil)
schCreateWire(cv "route" "full" '((27.000 22.875) (26.250 22.875)) 0 0 0 nil nil)
schCreateWireLabel(cv nil '(26.750 22.875) "VIOL" "lowerRight" "R0" "stick" 0.0625 nil)
schCreateWire(cv "route" "full" '((27.000 23.062) (26.250 23.062)) 0 0 0 nil nil)
schCreateWireLabel(cv nil '(26.750 23.062) "GIOL" "lowerRight" "R0" "stick" 0.0625 nil)
schCreateWire(cv "route" "full" '((27.000 23.250) (26.250 23.250)) 0 0 0 nil nil)
schCreateWireLabel(cv nil '(26.750 23.250) "VIOH" "lowerRight" "R0" "stick" 0.0625 nil)
schCreateWire(cv "route" "full" '((27.000 23.625) (26.250 23.625)) 0 0 0 nil nil)
schCreateWireLabel(cv nil '(26.750 23.625) "GIOH" "lowerRight" "R0" "stick" 0.0625 nil)
dbCreateInst(cv pddw16sdgz_h_gMaster "D27_right11" '(28.0 24.3125) "R90")
schCreateWire(cv "route" "full" '((27.000 24.438) (26.250 24.438)) 0 0 0 nil nil)
schCreateWireLabel(cv nil '(26.750 24.438) "VIOL" "lowerRight" "R0" "stick" 0.0625 nil)
schCreateWire(cv "route" "full" '((27.000 24.562) (26.250 24.562)) 0 0 0 nil nil)
dbCreateInst(cv noConnMaster "noConn_D27_right11_C" '(26.250 24.562) "R270")
schCreateWire(cv "route" "full" '((27.000 24.188) (26.250 24.188)) 0 0 0 nil nil)
schCreateWireLabel(cv nil '(26.750 24.188) "GIOL" "lowerRight" "R0" "stick" 0.0625 nil)
schCreateWire(cv "route" "full" '((27.000 24.062) (26.250 24.062)) 0 0 0 nil nil)
schCreateWireLabel(cv nil '(26.750 24.062) "D27_CORE" "lowerRight" "R0" "stick" 0.0625 nil)
schCreatePin(cv nil "D27_CORE" "inputOutput" nil '(26.250 24.062) "R0")
schCreateWire(cv "route" "full" '((28.000 25.000) (28.750 25.000)) 0 0 0 nil nil)
schCreateWireLabel(cv nil '(28.250 25.000) "D27" "lowerLeft" "R0" "stick" 0.0625 nil)
schCreatePin(cv nil "D27" "inputOutput" nil '(28.750 25.000) "R180")
schCreateWire(cv "route" "full" '((27.000 24.688) (26.250 24.688)) 0 0 0 nil nil)
schCreateWireLabel(cv nil '(26.750 24.688) "POC" "lowerRight" "R0" "stick" 0.0625 nil)
schCreateWire(cv "route" "full" '((27.000 24.875) (26.250 24.875)) 0 0 0 nil nil)
schCreateWireLabel(cv nil '(26.750 24.875) "VIOL" "lowerRight" "R0" "stick" 0.0625 nil)
schCreateWire(cv "route" "full" '((27.000 25.062) (26.250 25.062)) 0 0 0 nil nil)
schCreateWireLabel(cv nil '(26.750 25.062) "GIOL" "lowerRight" "R0" "stick" 0.0625 nil)
schCreateWire(cv "route" "full" '((27.000 25.250) (26.250 25.250)) 0 0 0 nil nil)
schCreateWireLabel(cv nil '(26.750 25.250) "VIOH" "lowerRight" "R0" "stick" 0.0625 nil)
schCreateWire(cv "route" "full" '((27.000 25.625) (26.250 25.625)) 0 0 0 nil nil)
schCreateWireLabel(cv nil '(26.750 25.625) "GIOH" "lowerRight" "R0" "stick" 0.0625 nil)
dbCreateInst(cv pddw16sdgz_v_gMaster "D28_top0" '(25.6875 28.0) "R180")
schCreateWire(cv "route" "full" '((25.562 27.000) (25.562 26.250)) 0 0 0 nil nil)
schCreateWireLabel(cv nil '(25.562 26.750) "VIOL" "lowerRight" "R90" "stick" 0.0625 nil)
schCreateWire(cv "route" "full" '((25.438 27.000) (25.438 26.250)) 0 0 0 nil nil)
dbCreateInst(cv noConnMaster "noConn_D28_top0_C" '(25.438 26.250) "R0")
schCreateWire(cv "route" "full" '((25.812 27.000) (25.812 26.250)) 0 0 0 nil nil)
schCreateWireLabel(cv nil '(25.812 26.750) "GIOL" "lowerRight" "R90" "stick" 0.0625 nil)
schCreateWire(cv "route" "full" '((25.938 27.000) (25.938 26.250)) 0 0 0 nil nil)
schCreateWireLabel(cv nil '(25.938 26.750) "D28_CORE" "lowerRight" "R90" "stick" 0.0625 nil)
schCreatePin(cv nil "D28_CORE" "inputOutput" nil '(25.938 26.250) "R90")
schCreateWire(cv "route" "full" '((25.000 28.000) (25.000 28.750)) 0 0 0 nil nil)
schCreateWireLabel(cv nil '(25.000 28.250) "D28" "lowerLeft" "R90" "stick" 0.0625 nil)
schCreatePin(cv nil "D28" "inputOutput" nil '(25.000 28.750) "R270")
schCreateWire(cv "route" "full" '((25.312 27.000) (25.312 26.250)) 0 0 0 nil nil)
schCreateWireLabel(cv nil '(25.312 26.750) "POC" "lowerRight" "R90" "stick" 0.0625 nil)
schCreateWire(cv "route" "full" '((25.125 27.000) (25.125 26.250)) 0 0 0 nil nil)
schCreateWireLabel(cv nil '(25.125 26.750) "VIOL" "lowerRight" "R90" "stick" 0.0625 nil)
schCreateWire(cv "route" "full" '((24.938 27.000) (24.938 26.250)) 0 0 0 nil nil)
schCreateWireLabel(cv nil '(24.938 26.750) "GIOL" "lowerRight" "R90" "stick" 0.0625 nil)
schCreateWire(cv "route" "full" '((24.750 27.000) (24.750 26.250)) 0 0 0 nil nil)
schCreateWireLabel(cv nil '(24.750 26.750) "VIOH" "lowerRight" "R90" "stick" 0.0625 nil)
schCreateWire(cv "route" "full" '((24.375 27.000) (24.375 26.250)) 0 0 0 nil nil)
schCreateWireLabel(cv nil '(24.375 26.750) "GIOH" "lowerRight" "R90" "stick" 0.0625 nil)
dbCreateInst(cv pddw16sdgz_v_gMaster "D29_top1" '(23.6875 28.0) "R180")
schCreateWire(cv "route" "full" '((23.562 27.000) (23.562 26.250)) 0 0 0 nil nil)
schCreateWireLabel(cv nil '(23.562 26.750) "VIOL" "lowerRight" "R90" "stick" 0.0625 nil)
schCreateWire(cv "route" "full" '((23.438 27.000) (23.438 26.250)) 0 0 0 nil nil)
dbCreateInst(cv noConnMaster "noConn_D29_top1_C" '(23.438 26.250) "R0")
schCreateWire(cv "route" "full" '((23.812 27.000) (23.812 26.250)) 0 0 0 nil nil)
schCreateWireLabel(cv nil '(23.812 26.750) "GIOL" "lowerRight" "R90" "stick" 0.0625 nil)
schCreateWire(cv "route" "full" '((23.938 27.000) (23.938 26.250)) 0 0 0 nil nil)
schCreateWireLabel(cv nil '(23.938 26.750) "D29_CORE" "lowerRight" "R90" "stick" 0.0625 nil)
schCreatePin(cv nil "D29_CORE" "inputOutput" nil '(23.938 26.250) "R90")
schCreateWire(cv "route" "full" '((23.000 28.000) (23.000 28.750)) 0 0 0 nil nil)
schCreateWireLabel(cv nil '(23.000 28.250) "D29" "lowerLeft" "R90" "stick" 0.0625 nil)
schCreatePin(cv nil "D29" "inputOutput" nil '(23.000 28.750) "R270")
schCreateWire(cv "route" "full" '((23.312 27.000) (23.312 26.250)) 0 0 0 nil nil)
schCreateWireLabel(cv nil '(23.312 26.750) "POC" "lowerRight" "R90" "stick" 0.0625 nil)
schCreateWire(cv "route" "full" '((23.125 27.000) (23.125 26.250)) 0 0 0 nil nil)
schCreateWireLabel(cv nil '(23.125 26.750) "VIOL" "lowerRight" "R90" "stick" 0.0625 nil)
schCreateWire(cv "route" "full" '((22.938 27.000) (22.938 26.250)) 0 0 0 nil nil)
schCreateWireLabel(cv nil '(22.938 26.750) "GIOL" "lowerRight" "R90" "stick" 0.0625 nil)
schCreateWire(cv "route" "full" '((22.750 27.000) (22.750 26.250)) 0 0 0 nil nil)
schCreateWireLabel(cv nil '(22.750 26.750) "VIOH" "lowerRight" "R90" "stick" 0.0625 nil)
schCreateWire(cv "route" "full" '((22.375 27.000) (22.375 26.250)) 0 0 0 nil nil)
schCreateWireLabel(cv nil '(22.375 26.750) "GIOH" "lowerRight" "R90" "stick" 0.0625 nil)
dbCreateInst(cv pddw16sdgz_v_gMaster "D30_top2" '(21.6875 28.0) "R180")
schCreateWire(cv "route" "full" '((21.562 27.000) (21.562 26.250)) 0 0 0 nil nil)
schCreateWireLabel(cv nil '(21.562 26.750) "VIOL" "lowerRight" "R90" "stick" 0.0625 nil)
schCreateWire(cv "route" "full" '((21.438 27.000) (21.438 26.250)) 0 0 0 nil nil)
dbCreateInst(cv noConnMaster "noConn_D30_top2_C" '(21.438 26.250) "R0")
schCreateWire(cv "route" "full" '((21.812 27.000) (21.812 26.250)) 0 0 0 nil nil)
schCreateWireLabel(cv nil '(21.812 26.750) "GIOL" "lowerRight" "R90" "stick" 0.0625 nil)
schCreateWire(cv "route" "full" '((21.938 27.000) (21.938 26.250)) 0 0 0 nil nil)
schCreateWireLabel(cv nil '(21.938 26.750) "D30_CORE" "lowerRight" "R90" "stick" 0.0625 nil)
schCreatePin(cv nil "D30_CORE" "inputOutput" nil '(21.938 26.250) "R90")
schCreateWire(cv "route" "full" '((21.000 28.000) (21.000 28.750)) 0 0 0 nil nil)
schCreateWireLabel(cv nil '(21.000 28.250) "D30" "lowerLeft" "R90" "stick" 0.0625 nil)
schCreatePin(cv nil "D30" "inputOutput" nil '(21.000 28.750) "R270")
schCreateWire(cv "route" "full" '((21.312 27.000) (21.312 26.250)) 0 0 0 nil nil)
schCreateWireLabel(cv nil '(21.312 26.750) "POC" "lowerRight" "R90" "stick" 0.0625 nil)
schCreateWire(cv "route" "full" '((21.125 27.000) (21.125 26.250)) 0 0 0 nil nil)
schCreateWireLabel(cv nil '(21.125 26.750) "VIOL" "lowerRight" "R90" "stick" 0.0625 nil)
schCreateWire(cv "route" "full" '((20.938 27.000) (20.938 26.250)) 0 0 0 nil nil)
schCreateWireLabel(cv nil '(20.938 26.750) "GIOL" "lowerRight" "R90" "stick" 0.0625 nil)
schCreateWire(cv "route" "full" '((20.750 27.000) (20.750 26.250)) 0 0 0 nil nil)
schCreateWireLabel(cv nil '(20.750 26.750) "VIOH" "lowerRight" "R90" "stick" 0.0625 nil)
schCreateWire(cv "route" "full" '((20.375 27.000) (20.375 26.250)) 0 0 0 nil nil)
schCreateWireLabel(cv nil '(20.375 26.750) "GIOH" "lowerRight" "R90" "stick" 0.0625 nil)
dbCreateInst(cv pddw16sdgz_v_gMaster "D31_top3" '(19.6875 28.0) "R180")
schCreateWire(cv "route" "full" '((19.562 27.000) (19.562 26.250)) 0 0 0 nil nil)
schCreateWireLabel(cv nil '(19.562 26.750) "VIOL" "lowerRight" "R90" "stick" 0.0625 nil)
schCreateWire(cv "route" "full" '((19.438 27.000) (19.438 26.250)) 0 0 0 nil nil)
dbCreateInst(cv noConnMaster "noConn_D31_top3_C" '(19.438 26.250) "R0")
schCreateWire(cv "route" "full" '((19.812 27.000) (19.812 26.250)) 0 0 0 nil nil)
schCreateWireLabel(cv nil '(19.812 26.750) "GIOL" "lowerRight" "R90" "stick" 0.0625 nil)
schCreateWire(cv "route" "full" '((19.938 27.000) (19.938 26.250)) 0 0 0 nil nil)
schCreateWireLabel(cv nil '(19.938 26.750) "D31_CORE" "lowerRight" "R90" "stick" 0.0625 nil)
schCreatePin(cv nil "D31_CORE" "inputOutput" nil '(19.938 26.250) "R90")
schCreateWire(cv "route" "full" '((19.000 28.000) (19.000 28.750)) 0 0 0 nil nil)
schCreateWireLabel(cv nil '(19.000 28.250) "D31" "lowerLeft" "R90" "stick" 0.0625 nil)
schCreatePin(cv nil "D31" "inputOutput" nil '(19.000 28.750) "R270")
schCreateWire(cv "route" "full" '((19.312 27.000) (19.312 26.250)) 0 0 0 nil nil)
schCreateWireLabel(cv nil '(19.312 26.750) "POC" "lowerRight" "R90" "stick" 0.0625 nil)
schCreateWire(cv "route" "full" '((19.125 27.000) (19.125 26.250)) 0 0 0 nil nil)
schCreateWireLabel(cv nil '(19.125 26.750) "VIOL" "lowerRight" "R90" "stick" 0.0625 nil)
schCreateWire(cv "route" "full" '((18.938 27.000) (18.938 26.250)) 0 0 0 nil nil)
schCreateWireLabel(cv nil '(18.938 26.750) "GIOL" "lowerRight" "R90" "stick" 0.0625 nil)
schCreateWire(cv "route" "full" '((18.750 27.000) (18.750 26.250)) 0 0 0 nil nil)
schCreateWireLabel(cv nil '(18.750 26.750) "VIOH" "lowerRight" "R90" "stick" 0.0625 nil)
schCreateWire(cv "route" "full" '((18.375 27.000) (18.375 26.250)) 0 0 0 nil nil)
schCreateWireLabel(cv nil '(18.375 26.750) "GIOH" "lowerRight" "R90" "stick" 0.0625 nil)
dbCreateInst(cv pddw16sdgz_v_gMaster "D32_top4" '(17.6875 28.0) "R180")
schCreateWire(cv "route" "full" '((17.562 27.000) (17.562 26.250)) 0 0 0 nil nil)
schCreateWireLabel(cv nil '(17.562 26.750) "VIOL" "lowerRight" "R90" "stick" 0.0625 nil)
schCreateWire(cv "route" "full" '((17.438 27.000) (17.438 26.250)) 0 0 0 nil nil)
dbCreateInst(cv noConnMaster "noConn_D32_top4_C" '(17.438 26.250) "R0")
schCreateWire(cv "route" "full" '((17.812 27.000) (17.812 26.250)) 0 0 0 nil nil)
schCreateWireLabel(cv nil '(17.812 26.750) "GIOL" "lowerRight" "R90" "stick" 0.0625 nil)
schCreateWire(cv "route" "full" '((17.938 27.000) (17.938 26.250)) 0 0 0 nil nil)
schCreateWireLabel(cv nil '(17.938 26.750) "D32_CORE" "lowerRight" "R90" "stick" 0.0625 nil)
schCreatePin(cv nil "D32_CORE" "inputOutput" nil '(17.938 26.250) "R90")
schCreateWire(cv "route" "full" '((17.000 28.000) (17.000 28.750)) 0 0 0 nil nil)
schCreateWireLabel(cv nil '(17.000 28.250) "D32" "lowerLeft" "R90" "stick" 0.0625 nil)
schCreatePin(cv nil "D32" "inputOutput" nil '(17.000 28.750) "R270")
schCreateWire(cv "route" "full" '((17.312 27.000) (17.312 26.250)) 0 0 0 nil nil)
schCreateWireLabel(cv nil '(17.312 26.750) "POC" "lowerRight" "R90" "stick" 0.0625 nil)
schCreateWire(cv "route" "full" '((17.125 27.000) (17.125 26.250)) 0 0 0 nil nil)
schCreateWireLabel(cv nil '(17.125 26.750) "VIOL" "lowerRight" "R90" "stick" 0.0625 nil)
schCreateWire(cv "route" "full" '((16.938 27.000) (16.938 26.250)) 0 0 0 nil nil)
schCreateWireLabel(cv nil '(16.938 26.750) "GIOL" "lowerRight" "R90" "stick" 0.0625 nil)
schCreateWire(cv "route" "full" '((16.750 27.000) (16.750 26.250)) 0 0 0 nil nil)
schCreateWireLabel(cv nil '(16.750 26.750) "VIOH" "lowerRight" "R90" "stick" 0.0625 nil)
schCreateWire(cv "route" "full" '((16.375 27.000) (16.375 26.250)) 0 0 0 nil nil)
schCreateWireLabel(cv nil '(16.375 26.750) "GIOH" "lowerRight" "R90" "stick" 0.0625 nil)
dbCreateInst(cv pddw16sdgz_v_gMaster "D33_top5" '(15.6875 28.0) "R180")
schCreateWire(cv "route" "full" '((15.562 27.000) (15.562 26.250)) 0 0 0 nil nil)
schCreateWireLabel(cv nil '(15.562 26.750) "VIOL" "lowerRight" "R90" "stick" 0.0625 nil)
schCreateWire(cv "route" "full" '((15.438 27.000) (15.438 26.250)) 0 0 0 nil nil)
dbCreateInst(cv noConnMaster "noConn_D33_top5_C" '(15.438 26.250) "R0")
schCreateWire(cv "route" "full" '((15.812 27.000) (15.812 26.250)) 0 0 0 nil nil)
schCreateWireLabel(cv nil '(15.812 26.750) "GIOL" "lowerRight" "R90" "stick" 0.0625 nil)
schCreateWire(cv "route" "full" '((15.938 27.000) (15.938 26.250)) 0 0 0 nil nil)
schCreateWireLabel(cv nil '(15.938 26.750) "D33_CORE" "lowerRight" "R90" "stick" 0.0625 nil)
schCreatePin(cv nil "D33_CORE" "inputOutput" nil '(15.938 26.250) "R90")
schCreateWire(cv "route" "full" '((14.999 28.000) (14.999 28.750)) 0 0 0 nil nil)
schCreateWireLabel(cv nil '(14.999 28.250) "D33" "lowerLeft" "R90" "stick" 0.0625 nil)
schCreatePin(cv nil "D33" "inputOutput" nil '(14.999 28.750) "R270")
schCreateWire(cv "route" "full" '((15.312 27.000) (15.312 26.250)) 0 0 0 nil nil)
schCreateWireLabel(cv nil '(15.312 26.750) "POC" "lowerRight" "R90" "stick" 0.0625 nil)
schCreateWire(cv "route" "full" '((15.126 27.000) (15.126 26.250)) 0 0 0 nil nil)
schCreateWireLabel(cv nil '(15.126 26.750) "VIOL" "lowerRight" "R90" "stick" 0.0625 nil)
schCreateWire(cv "route" "full" '((14.938 27.000) (14.938 26.250)) 0 0 0 nil nil)
schCreateWireLabel(cv nil '(14.938 26.750) "GIOL" "lowerRight" "R90" "stick" 0.0625 nil)
schCreateWire(cv "route" "full" '((14.749 27.000) (14.749 26.250)) 0 0 0 nil nil)
schCreateWireLabel(cv nil '(14.749 26.750) "VIOH" "lowerRight" "R90" "stick" 0.0625 nil)
schCreateWire(cv "route" "full" '((14.376 27.000) (14.376 26.250)) 0 0 0 nil nil)
schCreateWireLabel(cv nil '(14.376 26.750) "GIOH" "lowerRight" "R90" "stick" 0.0625 nil)
dbCreateInst(cv pddw16sdgz_v_gMaster "D34_top6" '(13.6875 28.0) "R180")
schCreateWire(cv "route" "full" '((13.562 27.000) (13.562 26.250)) 0 0 0 nil nil)
schCreateWireLabel(cv nil '(13.562 26.750) "VIOL" "lowerRight" "R90" "stick" 0.0625 nil)
schCreateWire(cv "route" "full" '((13.438 27.000) (13.438 26.250)) 0 0 0 nil nil)
dbCreateInst(cv noConnMaster "noConn_D34_top6_C" '(13.438 26.250) "R0")
schCreateWire(cv "route" "full" '((13.812 27.000) (13.812 26.250)) 0 0 0 nil nil)
schCreateWireLabel(cv nil '(13.812 26.750) "GIOL" "lowerRight" "R90" "stick" 0.0625 nil)
schCreateWire(cv "route" "full" '((13.938 27.000) (13.938 26.250)) 0 0 0 nil nil)
schCreateWireLabel(cv nil '(13.938 26.750) "D34_CORE" "lowerRight" "R90" "stick" 0.0625 nil)
schCreatePin(cv nil "D34_CORE" "inputOutput" nil '(13.938 26.250) "R90")
schCreateWire(cv "route" "full" '((12.999 28.000) (12.999 28.750)) 0 0 0 nil nil)
schCreateWireLabel(cv nil '(12.999 28.250) "D34" "lowerLeft" "R90" "stick" 0.0625 nil)
schCreatePin(cv nil "D34" "inputOutput" nil '(12.999 28.750) "R270")
schCreateWire(cv "route" "full" '((13.312 27.000) (13.312 26.250)) 0 0 0 nil nil)
schCreateWireLabel(cv nil '(13.312 26.750) "POC" "lowerRight" "R90" "stick" 0.0625 nil)
schCreateWire(cv "route" "full" '((13.126 27.000) (13.126 26.250)) 0 0 0 nil nil)
schCreateWireLabel(cv nil '(13.126 26.750) "VIOL" "lowerRight" "R90" "stick" 0.0625 nil)
schCreateWire(cv "route" "full" '((12.938 27.000) (12.938 26.250)) 0 0 0 nil nil)
schCreateWireLabel(cv nil '(12.938 26.750) "GIOL" "lowerRight" "R90" "stick" 0.0625 nil)
schCreateWire(cv "route" "full" '((12.749 27.000) (12.749 26.250)) 0 0 0 nil nil)
schCreateWireLabel(cv nil '(12.749 26.750) "VIOH" "lowerRight" "R90" "stick" 0.0625 nil)
schCreateWire(cv "route" "full" '((12.376 27.000) (12.376 26.250)) 0 0 0 nil nil)
schCreateWireLabel(cv nil '(12.376 26.750) "GIOH" "lowerRight" "R90" "stick" 0.0625 nil)
dbCreateInst(cv pddw16sdgz_v_gMaster "D35_top7" '(11.6875 28.0) "R180")
schCreateWire(cv "route" "full" '((11.562 27.000) (11.562 26.250)) 0 0 0 nil nil)
schCreateWireLabel(cv nil '(11.562 26.750) "VIOL" "lowerRight" "R90" "stick" 0.0625 nil)
schCreateWire(cv "route" "full" '((11.438 27.000) (11.438 26.250)) 0 0 0 nil nil)
dbCreateInst(cv noConnMaster "noConn_D35_top7_C" '(11.438 26.250) "R0")
schCreateWire(cv "route" "full" '((11.812 27.000) (11.812 26.250)) 0 0 0 nil nil)
schCreateWireLabel(cv nil '(11.812 26.750) "GIOL" "lowerRight" "R90" "stick" 0.0625 nil)
schCreateWire(cv "route" "full" '((11.938 27.000) (11.938 26.250)) 0 0 0 nil nil)
schCreateWireLabel(cv nil '(11.938 26.750) "D35_CORE" "lowerRight" "R90" "stick" 0.0625 nil)
schCreatePin(cv nil "D35_CORE" "inputOutput" nil '(11.938 26.250) "R90")
schCreateWire(cv "route" "full" '((10.999 28.000) (10.999 28.750)) 0 0 0 nil nil)
schCreateWireLabel(cv nil '(10.999 28.250) "D35" "lowerLeft" "R90" "stick" 0.0625 nil)
schCreatePin(cv nil "D35" "inputOutput" nil '(10.999 28.750) "R270")
schCreateWire(cv "route" "full" '((11.312 27.000) (11.312 26.250)) 0 0 0 nil nil)
schCreateWireLabel(cv nil '(11.312 26.750) "POC" "lowerRight" "R90" "stick" 0.0625 nil)
schCreateWire(cv "route" "full" '((11.126 27.000) (11.126 26.250)) 0 0 0 nil nil)
schCreateWireLabel(cv nil '(11.126 26.750) "VIOL" "lowerRight" "R90" "stick" 0.0625 nil)
schCreateWire(cv "route" "full" '((10.938 27.000) (10.938 26.250)) 0 0 0 nil nil)
schCreateWireLabel(cv nil '(10.938 26.750) "GIOL" "lowerRight" "R90" "stick" 0.0625 nil)
schCreateWire(cv "route" "full" '((10.749 27.000) (10.749 26.250)) 0 0 0 nil nil)
schCreateWireLabel(cv nil '(10.749 26.750) "VIOH" "lowerRight" "R90" "stick" 0.0625 nil)
schCreateWire(cv "route" "full" '((10.376 27.000) (10.376 26.250)) 0 0 0 nil nil)
schCreateWireLabel(cv nil '(10.376 26.750) "GIOH" "lowerRight" "R90" "stick" 0.0625 nil)
pvdd1dgz_v_gMaster = dbOpenCellView("tphn28hpcpgv18" "PVDD1DGZ_V_G" "symbol")
dbCreateInst(cv pvdd1dgz_v_gMaster "VIOL_top8" '(10.0 28.0) "R180")
schCreateWire(cv "route" "full" '((9.625 27.000) (9.625 26.250)) 0 0 0 nil nil)
schCreateWireLabel(cv nil '(9.625 26.750) "POC" "lowerRight" "R90" "stick" 0.0625 nil)
schCreateWire(cv "route" "full" '((9.000 28.000) (9.000 28.750)) 0 0 0 nil nil)
schCreateWireLabel(cv nil '(9.000 28.250) "VIOL" "lowerLeft" "R90" "stick" 0.0625 nil)
schCreatePin(cv nil "VIOL" "inputOutput" nil '(9.000 28.750) "R270")
schCreateWire(cv "route" "full" '((9.250 27.000) (9.250 26.250)) 0 0 0 nil nil)
schCreateWireLabel(cv nil '(9.250 26.750) "GIOL" "lowerRight" "R90" "stick" 0.0625 nil)
schCreateWire(cv "route" "full" '((9.062 27.000) (9.062 26.250)) 0 0 0 nil nil)
schCreateWireLabel(cv nil '(9.062 26.750) "VIOH" "lowerRight" "R90" "stick" 0.0625 nil)
schCreateWire(cv "route" "full" '((8.688 27.000) (8.688 26.250)) 0 0 0 nil nil)
schCreateWireLabel(cv nil '(8.688 26.750) "GIOH" "lowerRight" "R90" "stick" 0.0625 nil)
pvss1dgz_v_gMaster = dbOpenCellView("tphn28hpcpgv18" "PVSS1DGZ_V_G" "symbol")
dbCreateInst(cv pvss1dgz_v_gMaster "GIOL_top9" '(8.0 28.0) "R180")
schCreateWire(cv "route" "full" '((7.625 27.000) (7.625 26.250)) 0 0 0 nil nil)
schCreateWireLabel(cv nil '(7.625 26.750) "POC" "lowerRight" "R90" "stick" 0.0625 nil)
schCreateWire(cv "route" "full" '((7.438 27.000) (7.438 26.250)) 0 0 0 nil nil)
schCreateWireLabel(cv nil '(7.438 26.750) "VIOL" "lowerRight" "R90" "stick" 0.0625 nil)
schCreateWire(cv "route" "full" '((7.000 28.000) (7.000 28.750)) 0 0 0 nil nil)
schCreateWireLabel(cv nil '(7.000 28.250) "GIOL" "lowerLeft" "R90" "stick" 0.0625 nil)
schCreatePin(cv nil "GIOL" "inputOutput" nil '(7.000 28.750) "R270")
schCreateWire(cv "route" "full" '((7.062 27.000) (7.062 26.250)) 0 0 0 nil nil)
schCreateWireLabel(cv nil '(7.062 26.750) "VIOH" "lowerRight" "R90" "stick" 0.0625 nil)
schCreateWire(cv "route" "full" '((6.688 27.000) (6.688 26.250)) 0 0 0 nil nil)
schCreateWireLabel(cv nil '(6.688 26.750) "GIOH" "lowerRight" "R90" "stick" 0.0625 nil)
pvdd2poc_v_gMaster = dbOpenCellView("tphn28hpcpgv18" "PVDD2POC_V_G" "symbol")
dbCreateInst(cv pvdd2poc_v_gMaster "VIOH_top10" '(6.0 28.0) "R180")
schCreateWire(cv "route" "full" '((5.625 27.000) (5.625 26.250)) 0 0 0 nil nil)
schCreateWireLabel(cv nil '(5.625 26.750) "POC" "lowerRight" "R90" "stick" 0.0625 nil)
schCreateWire(cv "route" "full" '((5.438 27.000) (5.438 26.250)) 0 0 0 nil nil)
schCreateWireLabel(cv nil '(5.438 26.750) "VIOL" "lowerRight" "R90" "stick" 0.0625 nil)
schCreateWire(cv "route" "full" '((5.250 27.000) (5.250 26.250)) 0 0 0 nil nil)
schCreateWireLabel(cv nil '(5.250 26.750) "GIOL" "lowerRight" "R90" "stick" 0.0625 nil)
schCreateWire(cv "route" "full" '((5.000 28.000) (5.000 28.750)) 0 0 0 nil nil)
schCreateWireLabel(cv nil '(5.000 28.250) "VIOH" "lowerLeft" "R90" "stick" 0.0625 nil)
schCreatePin(cv nil "VIOH" "inputOutput" nil '(5.000 28.750) "R270")
schCreateWire(cv "route" "full" '((4.688 27.000) (4.688 26.250)) 0 0 0 nil nil)
schCreateWireLabel(cv nil '(4.688 26.750) "GIOH" "lowerRight" "R90" "stick" 0.0625 nil)
pvss2dgz_v_gMaster = dbOpenCellView("tphn28hpcpgv18" "PVSS2DGZ_V_G" "symbol")
dbCreateInst(cv pvss2dgz_v_gMaster "GIOH_top11" '(4.0 28.0) "R180")
schCreateWire(cv "route" "full" '((3.625 27.000) (3.625 26.250)) 0 0 0 nil nil)
schCreateWireLabel(cv nil '(3.625 26.750) "POC" "lowerRight" "R90" "stick" 0.0625 nil)
schCreateWire(cv "route" "full" '((3.438 27.000) (3.438 26.250)) 0 0 0 nil nil)
schCreateWireLabel(cv nil '(3.438 26.750) "VIOL" "lowerRight" "R90" "stick" 0.0625 nil)
schCreateWire(cv "route" "full" '((3.250 27.000) (3.250 26.250)) 0 0 0 nil nil)
schCreateWireLabel(cv nil '(3.250 26.750) "GIOL" "lowerRight" "R90" "stick" 0.0625 nil)
schCreateWire(cv "route" "full" '((3.062 27.000) (3.062 26.250)) 0 0 0 nil nil)
schCreateWireLabel(cv nil '(3.062 26.750) "VIOH" "lowerRight" "R90" "stick" 0.0625 nil)
schCreateWire(cv "route" "full" '((3.000 28.000) (3.000 28.750)) 0 0 0 nil nil)
schCreateWireLabel(cv nil '(3.000 28.250) "GIOH" "lowerLeft" "R90" "stick" 0.0625 nil)
schCreatePin(cv nil "GIOH" "inputOutput" nil '(3.000 28.750) "R270")
dbCreateInst(cv pdb3ac_h_gMaster "VREF_CORE_left45" '(4.0 15.625) "R270")
schCreateWire(cv "route" "full" '((4.000 15.813) (3.250 15.813)) 0 0 0 nil nil)
schCreateWireLabel(cv nil '(3.750 15.813) "VREF_CORE" "lowerRight" "R0" "stick" 0.0625 nil)
schCreatePin(cv nil "VREF_CORE" "inputOutput" nil '(3.250 15.813) "R0")
schCreateWire(cv "route" "full" '((4.875 15.875) (5.625 15.875)) 0 0 0 nil nil)
schCreateWireLabel(cv nil '(5.125 15.875) "AVSS" "lowerLeft" "R0" "stick" 0.0625 nil)
schCreateWire(cv "route" "full" '((4.875 15.500) (5.625 15.500)) 0 0 0 nil nil)
schCreateWireLabel(cv nil '(5.125 15.500) "GIOL" "lowerLeft" "R0" "stick" 0.0625 nil)
schCreateWire(cv "route" "full" '((4.875 16.250) (5.625 16.250)) 0 0 0 nil nil)
schCreateWireLabel(cv nil '(5.125 16.250) "AVDD" "lowerLeft" "R0" "stick" 0.0625 nil)
dbCreateInst(cv pdb3ac_h_gMaster "VAMP_CORE_left01" '(4.0 23.625) "R270")
schCreateWire(cv "route" "full" '((4.000 23.813) (3.250 23.813)) 0 0 0 nil nil)
schCreateWireLabel(cv nil '(3.750 23.813) "VAMP_CORE" "lowerRight" "R0" "stick" 0.0625 nil)
schCreatePin(cv nil "VAMP_CORE" "inputOutput" nil '(3.250 23.813) "R0")
schCreateWire(cv "route" "full" '((4.875 23.875) (5.625 23.875)) 0 0 0 nil nil)
schCreateWireLabel(cv nil '(5.125 23.875) "AVSS" "lowerLeft" "R0" "stick" 0.0625 nil)
schCreateWire(cv "route" "full" '((4.875 23.500) (5.625 23.500)) 0 0 0 nil nil)
schCreateWireLabel(cv nil '(5.125 23.500) "GIOL" "lowerLeft" "R0" "stick" 0.0625 nil)
schCreateWire(cv "route" "full" '((4.875 24.250) (5.625 24.250)) 0 0 0 nil nil)
schCreateWireLabel(cv nil '(5.125 24.250) "AVDD" "lowerLeft" "R0" "stick" 0.0625 nil)
dbCreateInst(cv pdb3ac_h_gMaster "IBIAS_CORE_left23" '(4.0 19.625) "R270")
schCreateWire(cv "route" "full" '((4.000 19.813) (3.250 19.813)) 0 0 0 nil nil)
schCreateWireLabel(cv nil '(3.750 19.813) "IBIAS_CORE" "lowerRight" "R0" "stick" 0.0625 nil)
schCreatePin(cv nil "IBIAS_CORE" "inputOutput" nil '(3.250 19.813) "R0")
schCreateWire(cv "route" "full" '((4.875 19.875) (5.625 19.875)) 0 0 0 nil nil)
schCreateWireLabel(cv nil '(5.125 19.875) "AVSS" "lowerLeft" "R0" "stick" 0.0625 nil)
schCreateWire(cv "route" "full" '((4.875 19.500) (5.625 19.500)) 0 0 0 nil nil)
schCreateWireLabel(cv nil '(5.125 19.500) "GIOL" "lowerLeft" "R0" "stick" 0.0625 nil)
schCreateWire(cv "route" "full" '((4.875 20.250) (5.625 20.250)) 0 0 0 nil nil)
schCreateWireLabel(cv nil '(5.125 20.250) "AVDD" "lowerLeft" "R0" "stick" 0.0625 nil)
schCheck(cv)
dbSave(cv)
t
