pdb3ac_h_gMaster = dbOpenCellView("tphn28hpcpgv18" "PDB3AC_H_G" "symbol")
dbCreateInst(cv pdb3ac_h_gMaster "VINP_left0" '(0 16.8125) "R270")
schCreateWire(cv "route" "full" '((0.000 17.000) (-0.750 17.000)) 0 0 0 nil nil)
schCreateWireLabel(cv nil '(-0.250 17.000) "VINP" "lowerRight" "R0" "stick" 0.0625 nil)
schCreatePin(cv nil "VINP" "inputOutput" nil '(-0.750 17.000) "R0")
schCreateWire(cv "route" "full" '((0.875 17.062) (1.625 17.062)) 0 0 0 nil nil)
schCreateWireLabel(cv nil '(1.125 17.062) "VSSIB" "lowerLeft" "R0" "stick" 0.0625 nil)
schCreateWire(cv "route" "full" '((0.875 16.688) (1.625 16.688)) 0 0 0 nil nil)
schCreateWireLabel(cv nil '(1.125 16.688) "GIOL" "lowerLeft" "R0" "stick" 0.0625 nil)
schCreateWire(cv "route" "full" '((0.875 17.438) (1.625 17.438)) 0 0 0 nil nil)
schCreateWireLabel(cv nil '(1.125 17.438) "VDDIB" "lowerLeft" "R0" "stick" 0.0625 nil)
dbCreateInst(cv pdb3ac_h_gMaster "VINN_left1" '(0 14.8125) "R270")
schCreateWire(cv "route" "full" '((0.000 15.001) (-0.750 15.001)) 0 0 0 nil nil)
schCreateWireLabel(cv nil '(-0.250 15.001) "VINN" "lowerRight" "R0" "stick" 0.0625 nil)
schCreatePin(cv nil "VINN" "inputOutput" nil '(-0.750 15.001) "R0")
schCreateWire(cv "route" "full" '((0.875 15.062) (1.625 15.062)) 0 0 0 nil nil)
schCreateWireLabel(cv nil '(1.125 15.062) "VSSIB" "lowerLeft" "R0" "stick" 0.0625 nil)
schCreateWire(cv "route" "full" '((0.875 14.688) (1.625 14.688)) 0 0 0 nil nil)
schCreateWireLabel(cv nil '(1.125 14.688) "GIOL" "lowerLeft" "R0" "stick" 0.0625 nil)
schCreateWire(cv "route" "full" '((0.875 15.438) (1.625 15.438)) 0 0 0 nil nil)
schCreateWireLabel(cv nil '(1.125 15.438) "VDDIB" "lowerLeft" "R0" "stick" 0.0625 nil)
dbCreateInst(cv pdb3ac_h_gMaster "VIP_left2" '(0 12.8125) "R270")
schCreateWire(cv "route" "full" '((0.000 13.001) (-0.750 13.001)) 0 0 0 nil nil)
schCreateWireLabel(cv nil '(-0.250 13.001) "VIP" "lowerRight" "R0" "stick" 0.0625 nil)
schCreatePin(cv nil "VIP" "inputOutput" nil '(-0.750 13.001) "R0")
schCreateWire(cv "route" "full" '((0.875 13.062) (1.625 13.062)) 0 0 0 nil nil)
schCreateWireLabel(cv nil '(1.125 13.062) "VSSIB" "lowerLeft" "R0" "stick" 0.0625 nil)
schCreateWire(cv "route" "full" '((0.875 12.688) (1.625 12.688)) 0 0 0 nil nil)
schCreateWireLabel(cv nil '(1.125 12.688) "GIOL" "lowerLeft" "R0" "stick" 0.0625 nil)
schCreateWire(cv "route" "full" '((0.875 13.438) (1.625 13.438)) 0 0 0 nil nil)
schCreateWireLabel(cv nil '(1.125 13.438) "VDDIB" "lowerLeft" "R0" "stick" 0.0625 nil)
dbCreateInst(cv pdb3ac_h_gMaster "VIM_left3" '(0 10.8125) "R270")
schCreateWire(cv "route" "full" '((0.000 11.001) (-0.750 11.001)) 0 0 0 nil nil)
schCreateWireLabel(cv nil '(-0.250 11.001) "VIM" "lowerRight" "R0" "stick" 0.0625 nil)
schCreatePin(cv nil "VIM" "inputOutput" nil '(-0.750 11.001) "R0")
schCreateWire(cv "route" "full" '((0.875 11.062) (1.625 11.062)) 0 0 0 nil nil)
schCreateWireLabel(cv nil '(1.125 11.062) "VSSIB" "lowerLeft" "R0" "stick" 0.0625 nil)
schCreateWire(cv "route" "full" '((0.875 10.688) (1.625 10.688)) 0 0 0 nil nil)
schCreateWireLabel(cv nil '(1.125 10.688) "GIOL" "lowerLeft" "R0" "stick" 0.0625 nil)
schCreateWire(cv "route" "full" '((0.875 11.438) (1.625 11.438)) 0 0 0 nil nil)
schCreateWireLabel(cv nil '(1.125 11.438) "VDDIB" "lowerLeft" "R0" "stick" 0.0625 nil)
dbCreateInst(cv pdb3ac_h_gMaster "VCM_left4" '(0 8.8125) "R270")
schCreateWire(cv "route" "full" '((0.000 9.001) (-0.750 9.001)) 0 0 0 nil nil)
schCreateWireLabel(cv nil '(-0.250 9.001) "VCM" "lowerRight" "R0" "stick" 0.0625 nil)
schCreatePin(cv nil "VCM" "inputOutput" nil '(-0.750 9.001) "R0")
schCreateWire(cv "route" "full" '((0.875 9.062) (1.625 9.062)) 0 0 0 nil nil)
schCreateWireLabel(cv nil '(1.125 9.062) "VSSIB" "lowerLeft" "R0" "stick" 0.0625 nil)
schCreateWire(cv "route" "full" '((0.875 8.688) (1.625 8.688)) 0 0 0 nil nil)
schCreateWireLabel(cv nil '(1.125 8.688) "GIOL" "lowerLeft" "R0" "stick" 0.0625 nil)
schCreateWire(cv "route" "full" '((0.875 9.438) (1.625 9.438)) 0 0 0 nil nil)
schCreateWireLabel(cv nil '(1.125 9.438) "VDDIB" "lowerLeft" "R0" "stick" 0.0625 nil)
dbCreateInst(cv pdb3ac_h_gMaster "VREF_left5" '(0 6.8125) "R270")
schCreateWire(cv "route" "full" '((0.000 7.000) (-0.750 7.000)) 0 0 0 nil nil)
schCreateWireLabel(cv nil '(-0.250 7.000) "VREF" "lowerRight" "R0" "stick" 0.0625 nil)
schCreatePin(cv nil "VREF" "inputOutput" nil '(-0.750 7.000) "R0")
schCreateWire(cv "route" "full" '((0.875 7.062) (1.625 7.062)) 0 0 0 nil nil)
schCreateWireLabel(cv nil '(1.125 7.062) "VSSIB" "lowerLeft" "R0" "stick" 0.0625 nil)
schCreateWire(cv "route" "full" '((0.875 6.688) (1.625 6.688)) 0 0 0 nil nil)
schCreateWireLabel(cv nil '(1.125 6.688) "GIOL" "lowerLeft" "R0" "stick" 0.0625 nil)
schCreateWire(cv "route" "full" '((0.875 7.438) (1.625 7.438)) 0 0 0 nil nil)
schCreateWireLabel(cv nil '(1.125 7.438) "VDDIB" "lowerLeft" "R0" "stick" 0.0625 nil)
dbCreateInst(cv pdb3ac_h_gMaster "IBVREF_left6" '(0 4.8125) "R270")
schCreateWire(cv "route" "full" '((0.000 5.000) (-0.750 5.000)) 0 0 0 nil nil)
schCreateWireLabel(cv nil '(-0.250 5.000) "IBVREF" "lowerRight" "R0" "stick" 0.0625 nil)
schCreatePin(cv nil "IBVREF" "inputOutput" nil '(-0.750 5.000) "R0")
schCreateWire(cv "route" "full" '((0.875 5.062) (1.625 5.062)) 0 0 0 nil nil)
schCreateWireLabel(cv nil '(1.125 5.062) "VSSIB" "lowerLeft" "R0" "stick" 0.0625 nil)
schCreateWire(cv "route" "full" '((0.875 4.688) (1.625 4.688)) 0 0 0 nil nil)
schCreateWireLabel(cv nil '(1.125 4.688) "GIOL" "lowerLeft" "R0" "stick" 0.0625 nil)
schCreateWire(cv "route" "full" '((0.875 5.438) (1.625 5.438)) 0 0 0 nil nil)
schCreateWireLabel(cv nil '(1.125 5.438) "VDDIB" "lowerLeft" "R0" "stick" 0.0625 nil)
pvdd3ac_h_gMaster = dbOpenCellView("tphn28hpcpgv18" "PVDD3AC_H_G" "symbol")
dbCreateInst(cv pvdd3ac_h_gMaster "VDDIB_left7" '(0 2.8125) "R270")
schCreateWire(cv "route" "full" '((0.875 3.438) (1.625 3.438)) 0 0 0 nil nil)
schCreateWireLabel(cv nil '(1.125 3.438) "VDDIB_CORE" "lowerLeft" "R0" "stick" 0.0625 nil)
schCreatePin(cv nil "VDDIB_CORE" "inputOutput" nil '(1.625 3.438) "R180")
schCreateWire(cv "route" "full" '((0.875 3.062) (1.625 3.062)) 0 0 0 nil nil)
schCreateWireLabel(cv nil '(1.125 3.062) "VSSIB" "lowerLeft" "R0" "stick" 0.0625 nil)
schCreateWire(cv "route" "full" '((0.875 2.688) (1.625 2.688)) 0 0 0 nil nil)
schCreateWireLabel(cv nil '(1.125 2.688) "GIOL" "lowerLeft" "R0" "stick" 0.0625 nil)
schCreateWire(cv "route" "full" '((0.000 3.001) (-0.750 3.001)) 0 0 0 nil nil)
schCreateWireLabel(cv nil '(-0.250 3.001) "VDDIB" "lowerRight" "R0" "stick" 0.0625 nil)
schCreatePin(cv nil "VDDIB" "inputOutput" nil '(-0.750 3.001) "R0")
pvss3ac_v_gMaster = dbOpenCellView("tphn28hpcpgv18" "PVSS3AC_V_G" "symbol")
dbCreateInst(cv pvss3ac_v_gMaster "VSSIB_bottom0" '(3.1875 0) "R0")
schCreateWire(cv "route" "full" '((2.999 0.000) (2.999 -0.750)) 0 0 0 nil nil)
schCreateWireLabel(cv nil '(2.999 -0.250) "VSSIB" "lowerRight" "R90" "stick" 0.0625 nil)
schCreatePin(cv nil "VSSIB" "inputOutput" nil '(2.999 -0.750) "R90")
schCreateWire(cv "route" "full" '((3.312 0.875) (3.312 1.625)) 0 0 0 nil nil)
schCreateWireLabel(cv nil '(3.312 1.125) "GIOL" "lowerLeft" "R90" "stick" 0.0625 nil)
schCreateWire(cv "route" "full" '((2.562 0.875) (2.562 1.625)) 0 0 0 nil nil)
schCreateWireLabel(cv nil '(2.562 1.125) "VSSIB_CORE" "lowerLeft" "R90" "stick" 0.0625 nil)
schCreatePin(cv nil "VSSIB_CORE" "inputOutput" nil '(2.562 1.625) "R270")
schCreateWire(cv "route" "full" '((2.938 0.875) (2.938 1.625)) 0 0 0 nil nil)
schCreateWireLabel(cv nil '(2.938 1.125) "VDDIB" "lowerLeft" "R90" "stick" 0.0625 nil)
pvdd3ac_v_gMaster = dbOpenCellView("tphn28hpcpgv18" "PVDD3AC_V_G" "symbol")
dbCreateInst(cv pvdd3ac_v_gMaster "VDD_CKB_bottom1" '(5.1875 0) "R0")
schCreateWire(cv "route" "full" '((4.562 0.875) (4.562 1.625)) 0 0 0 nil nil)
schCreateWireLabel(cv nil '(4.562 1.125) "VDD_CKB_CORE" "lowerLeft" "R90" "stick" 0.0625 nil)
schCreatePin(cv nil "VDD_CKB_CORE" "inputOutput" nil '(4.562 1.625) "R270")
schCreateWire(cv "route" "full" '((4.938 0.875) (4.938 1.625)) 0 0 0 nil nil)
schCreateWireLabel(cv nil '(4.938 1.125) "VSS_CKB" "lowerLeft" "R90" "stick" 0.0625 nil)
schCreateWire(cv "route" "full" '((5.312 0.875) (5.312 1.625)) 0 0 0 nil nil)
schCreateWireLabel(cv nil '(5.312 1.125) "GIOL" "lowerLeft" "R90" "stick" 0.0625 nil)
schCreateWire(cv "route" "full" '((5.000 0.000) (5.000 -0.750)) 0 0 0 nil nil)
schCreateWireLabel(cv nil '(5.000 -0.250) "VDD_CKB" "lowerRight" "R90" "stick" 0.0625 nil)
schCreatePin(cv nil "VDD_CKB" "inputOutput" nil '(5.000 -0.750) "R90")
pdb3ac_v_gMaster = dbOpenCellView("tphn28hpcpgv18" "PDB3AC_V_G" "symbol")
dbCreateInst(cv pdb3ac_v_gMaster "CLKN_bottom2" '(7.1875 0) "R0")
schCreateWire(cv "route" "full" '((7.000 0.000) (7.000 -0.750)) 0 0 0 nil nil)
schCreateWireLabel(cv nil '(7.000 -0.250) "CLKN" "lowerRight" "R90" "stick" 0.0625 nil)
schCreatePin(cv nil "CLKN" "inputOutput" nil '(7.000 -0.750) "R90")
schCreateWire(cv "route" "full" '((6.938 0.875) (6.938 1.625)) 0 0 0 nil nil)
schCreateWireLabel(cv nil '(6.938 1.125) "VSS_CKB" "lowerLeft" "R90" "stick" 0.0625 nil)
schCreateWire(cv "route" "full" '((7.312 0.875) (7.312 1.625)) 0 0 0 nil nil)
schCreateWireLabel(cv nil '(7.312 1.125) "GIOL" "lowerLeft" "R90" "stick" 0.0625 nil)
schCreateWire(cv "route" "full" '((6.562 0.875) (6.562 1.625)) 0 0 0 nil nil)
schCreateWireLabel(cv nil '(6.562 1.125) "VDD_CKB" "lowerLeft" "R90" "stick" 0.0625 nil)
dbCreateInst(cv pdb3ac_v_gMaster "CLKP_bottom3" '(9.1875 0) "R0")
schCreateWire(cv "route" "full" '((8.999 0.000) (8.999 -0.750)) 0 0 0 nil nil)
schCreateWireLabel(cv nil '(8.999 -0.250) "CLKP" "lowerRight" "R90" "stick" 0.0625 nil)
schCreatePin(cv nil "CLKP" "inputOutput" nil '(8.999 -0.750) "R90")
schCreateWire(cv "route" "full" '((8.938 0.875) (8.938 1.625)) 0 0 0 nil nil)
schCreateWireLabel(cv nil '(8.938 1.125) "VSS_CKB" "lowerLeft" "R90" "stick" 0.0625 nil)
schCreateWire(cv "route" "full" '((9.312 0.875) (9.312 1.625)) 0 0 0 nil nil)
schCreateWireLabel(cv nil '(9.312 1.125) "GIOL" "lowerLeft" "R90" "stick" 0.0625 nil)
schCreateWire(cv "route" "full" '((8.562 0.875) (8.562 1.625)) 0 0 0 nil nil)
schCreateWireLabel(cv nil '(8.562 1.125) "VDD_CKB" "lowerLeft" "R90" "stick" 0.0625 nil)
dbCreateInst(cv pvss3ac_v_gMaster "VSS_CKB_bottom4" '(11.1875 0) "R0")
schCreateWire(cv "route" "full" '((10.999 0.000) (10.999 -0.750)) 0 0 0 nil nil)
schCreateWireLabel(cv nil '(10.999 -0.250) "VSS_CKB" "lowerRight" "R90" "stick" 0.0625 nil)
schCreatePin(cv nil "VSS_CKB" "inputOutput" nil '(10.999 -0.750) "R90")
schCreateWire(cv "route" "full" '((11.312 0.875) (11.312 1.625)) 0 0 0 nil nil)
schCreateWireLabel(cv nil '(11.312 1.125) "GIOL" "lowerLeft" "R90" "stick" 0.0625 nil)
schCreateWire(cv "route" "full" '((10.562 0.875) (10.562 1.625)) 0 0 0 nil nil)
schCreateWireLabel(cv nil '(10.562 1.125) "VSS_CKB_CORE" "lowerLeft" "R90" "stick" 0.0625 nil)
schCreatePin(cv nil "VSS_CKB_CORE" "inputOutput" nil '(10.562 1.625) "R270")
schCreateWire(cv "route" "full" '((10.938 0.875) (10.938 1.625)) 0 0 0 nil nil)
schCreateWireLabel(cv nil '(10.938 1.125) "VDD_CKB" "lowerLeft" "R90" "stick" 0.0625 nil)
pddw16sdgz_v_gMaster = dbOpenCellView("tphn28hpcpgv18" "PDDW16SDGZ_V_G" "symbol")
dbCreateInst(cv pddw16sdgz_v_gMaster "D0_bottom5" '(12.3125 0) "R0")
schCreateWire(cv "route" "full" '((12.438 1.000) (12.438 1.750)) 0 0 0 nil nil)
schCreateWireLabel(cv nil '(12.438 1.250) "VIOL" "lowerLeft" "R90" "stick" 0.0625 nil)
noConnMaster = dbOpenCellView("basic" "noConn" "symbol")
schCreateWire(cv "route" "full" '((12.562 1.000) (12.562 1.750)) 0 0 0 nil nil)
dbCreateInst(cv noConnMaster "noConn_D0_bottom5_C" '(12.562 1.750) "R180")
schCreateWire(cv "route" "full" '((12.188 1.000) (12.188 1.750)) 0 0 0 nil nil)
schCreateWireLabel(cv nil '(12.188 1.250) "GIOL" "lowerLeft" "R90" "stick" 0.0625 nil)
schCreateWire(cv "route" "full" '((12.062 1.000) (12.062 1.750)) 0 0 0 nil nil)
schCreateWireLabel(cv nil '(12.062 1.250) "D0_CORE" "lowerLeft" "R90" "stick" 0.0625 nil)
schCreatePin(cv nil "D0_CORE" "inputOutput" nil '(12.062 1.750) "R270")
schCreateWire(cv "route" "full" '((13.001 0.000) (13.001 -0.750)) 0 0 0 nil nil)
schCreateWireLabel(cv nil '(13.001 -0.250) "D0" "lowerRight" "R90" "stick" 0.0625 nil)
schCreatePin(cv nil "D0" "inputOutput" nil '(13.001 -0.750) "R90")
schCreateWire(cv "route" "full" '((12.688 1.000) (12.688 1.750)) 0 0 0 nil nil)
schCreateWireLabel(cv nil '(12.688 1.250) "POC" "lowerLeft" "R90" "stick" 0.0625 nil)
schCreateWire(cv "route" "full" '((12.874 1.000) (12.874 1.750)) 0 0 0 nil nil)
schCreateWireLabel(cv nil '(12.874 1.250) "VIOL" "lowerLeft" "R90" "stick" 0.0625 nil)
schCreateWire(cv "route" "full" '((13.062 1.000) (13.062 1.750)) 0 0 0 nil nil)
schCreateWireLabel(cv nil '(13.062 1.250) "GIOL" "lowerLeft" "R90" "stick" 0.0625 nil)
schCreateWire(cv "route" "full" '((13.251 1.000) (13.251 1.750)) 0 0 0 nil nil)
schCreateWireLabel(cv nil '(13.251 1.250) "VIOH" "lowerLeft" "R90" "stick" 0.0625 nil)
schCreateWire(cv "route" "full" '((13.624 1.000) (13.624 1.750)) 0 0 0 nil nil)
schCreateWireLabel(cv nil '(13.624 1.250) "GIOH" "lowerLeft" "R90" "stick" 0.0625 nil)
dbCreateInst(cv pddw16sdgz_v_gMaster "D1_bottom6" '(14.3125 0) "R0")
schCreateWire(cv "route" "full" '((14.438 1.000) (14.438 1.750)) 0 0 0 nil nil)
schCreateWireLabel(cv nil '(14.438 1.250) "VIOL" "lowerLeft" "R90" "stick" 0.0625 nil)
schCreateWire(cv "route" "full" '((14.562 1.000) (14.562 1.750)) 0 0 0 nil nil)
dbCreateInst(cv noConnMaster "noConn_D1_bottom6_C" '(14.562 1.750) "R180")
schCreateWire(cv "route" "full" '((14.188 1.000) (14.188 1.750)) 0 0 0 nil nil)
schCreateWireLabel(cv nil '(14.188 1.250) "GIOL" "lowerLeft" "R90" "stick" 0.0625 nil)
schCreateWire(cv "route" "full" '((14.062 1.000) (14.062 1.750)) 0 0 0 nil nil)
schCreateWireLabel(cv nil '(14.062 1.250) "D1_CORE" "lowerLeft" "R90" "stick" 0.0625 nil)
schCreatePin(cv nil "D1_CORE" "inputOutput" nil '(14.062 1.750) "R270")
schCreateWire(cv "route" "full" '((15.001 0.000) (15.001 -0.750)) 0 0 0 nil nil)
schCreateWireLabel(cv nil '(15.001 -0.250) "D1" "lowerRight" "R90" "stick" 0.0625 nil)
schCreatePin(cv nil "D1" "inputOutput" nil '(15.001 -0.750) "R90")
schCreateWire(cv "route" "full" '((14.688 1.000) (14.688 1.750)) 0 0 0 nil nil)
schCreateWireLabel(cv nil '(14.688 1.250) "POC" "lowerLeft" "R90" "stick" 0.0625 nil)
schCreateWire(cv "route" "full" '((14.874 1.000) (14.874 1.750)) 0 0 0 nil nil)
schCreateWireLabel(cv nil '(14.874 1.250) "VIOL" "lowerLeft" "R90" "stick" 0.0625 nil)
schCreateWire(cv "route" "full" '((15.062 1.000) (15.062 1.750)) 0 0 0 nil nil)
schCreateWireLabel(cv nil '(15.062 1.250) "GIOL" "lowerLeft" "R90" "stick" 0.0625 nil)
schCreateWire(cv "route" "full" '((15.251 1.000) (15.251 1.750)) 0 0 0 nil nil)
schCreateWireLabel(cv nil '(15.251 1.250) "VIOH" "lowerLeft" "R90" "stick" 0.0625 nil)
schCreateWire(cv "route" "full" '((15.624 1.000) (15.624 1.750)) 0 0 0 nil nil)
schCreateWireLabel(cv nil '(15.624 1.250) "GIOH" "lowerLeft" "R90" "stick" 0.0625 nil)
dbCreateInst(cv pddw16sdgz_v_gMaster "D2_bottom7" '(16.3125 0) "R0")
schCreateWire(cv "route" "full" '((16.438 1.000) (16.438 1.750)) 0 0 0 nil nil)
schCreateWireLabel(cv nil '(16.438 1.250) "VIOL" "lowerLeft" "R90" "stick" 0.0625 nil)
schCreateWire(cv "route" "full" '((16.562 1.000) (16.562 1.750)) 0 0 0 nil nil)
dbCreateInst(cv noConnMaster "noConn_D2_bottom7_C" '(16.562 1.750) "R180")
schCreateWire(cv "route" "full" '((16.188 1.000) (16.188 1.750)) 0 0 0 nil nil)
schCreateWireLabel(cv nil '(16.188 1.250) "GIOL" "lowerLeft" "R90" "stick" 0.0625 nil)
schCreateWire(cv "route" "full" '((16.062 1.000) (16.062 1.750)) 0 0 0 nil nil)
schCreateWireLabel(cv nil '(16.062 1.250) "D2_CORE" "lowerLeft" "R90" "stick" 0.0625 nil)
schCreatePin(cv nil "D2_CORE" "inputOutput" nil '(16.062 1.750) "R270")
schCreateWire(cv "route" "full" '((17.000 0.000) (17.000 -0.750)) 0 0 0 nil nil)
schCreateWireLabel(cv nil '(17.000 -0.250) "D2" "lowerRight" "R90" "stick" 0.0625 nil)
schCreatePin(cv nil "D2" "inputOutput" nil '(17.000 -0.750) "R90")
schCreateWire(cv "route" "full" '((16.688 1.000) (16.688 1.750)) 0 0 0 nil nil)
schCreateWireLabel(cv nil '(16.688 1.250) "POC" "lowerLeft" "R90" "stick" 0.0625 nil)
schCreateWire(cv "route" "full" '((16.875 1.000) (16.875 1.750)) 0 0 0 nil nil)
schCreateWireLabel(cv nil '(16.875 1.250) "VIOL" "lowerLeft" "R90" "stick" 0.0625 nil)
schCreateWire(cv "route" "full" '((17.062 1.000) (17.062 1.750)) 0 0 0 nil nil)
schCreateWireLabel(cv nil '(17.062 1.250) "GIOL" "lowerLeft" "R90" "stick" 0.0625 nil)
schCreateWire(cv "route" "full" '((17.250 1.000) (17.250 1.750)) 0 0 0 nil nil)
schCreateWireLabel(cv nil '(17.250 1.250) "VIOH" "lowerLeft" "R90" "stick" 0.0625 nil)
schCreateWire(cv "route" "full" '((17.625 1.000) (17.625 1.750)) 0 0 0 nil nil)
schCreateWireLabel(cv nil '(17.625 1.250) "GIOH" "lowerLeft" "R90" "stick" 0.0625 nil)
pddw16sdgz_h_gMaster = dbOpenCellView("tphn28hpcpgv18" "PDDW16SDGZ_H_G" "symbol")
dbCreateInst(cv pddw16sdgz_h_gMaster "D3_right0" '(20.0 2.3125) "R90")
schCreateWire(cv "route" "full" '((19.000 2.438) (18.250 2.438)) 0 0 0 nil nil)
schCreateWireLabel(cv nil '(18.750 2.438) "VIOL" "lowerRight" "R0" "stick" 0.0625 nil)
schCreateWire(cv "route" "full" '((19.000 2.562) (18.250 2.562)) 0 0 0 nil nil)
dbCreateInst(cv noConnMaster "noConn_D3_right0_C" '(18.250 2.562) "R270")
schCreateWire(cv "route" "full" '((19.000 2.188) (18.250 2.188)) 0 0 0 nil nil)
schCreateWireLabel(cv nil '(18.750 2.188) "GIOL" "lowerRight" "R0" "stick" 0.0625 nil)
schCreateWire(cv "route" "full" '((19.000 2.062) (18.250 2.062)) 0 0 0 nil nil)
schCreateWireLabel(cv nil '(18.750 2.062) "D3_CORE" "lowerRight" "R0" "stick" 0.0625 nil)
schCreatePin(cv nil "D3_CORE" "inputOutput" nil '(18.250 2.062) "R0")
schCreateWire(cv "route" "full" '((20.000 3.000) (20.750 3.000)) 0 0 0 nil nil)
schCreateWireLabel(cv nil '(20.250 3.000) "D3" "lowerLeft" "R0" "stick" 0.0625 nil)
schCreatePin(cv nil "D3" "inputOutput" nil '(20.750 3.000) "R180")
schCreateWire(cv "route" "full" '((19.000 2.688) (18.250 2.688)) 0 0 0 nil nil)
schCreateWireLabel(cv nil '(18.750 2.688) "POC" "lowerRight" "R0" "stick" 0.0625 nil)
schCreateWire(cv "route" "full" '((19.000 2.875) (18.250 2.875)) 0 0 0 nil nil)
schCreateWireLabel(cv nil '(18.750 2.875) "VIOL" "lowerRight" "R0" "stick" 0.0625 nil)
schCreateWire(cv "route" "full" '((19.000 3.062) (18.250 3.062)) 0 0 0 nil nil)
schCreateWireLabel(cv nil '(18.750 3.062) "GIOL" "lowerRight" "R0" "stick" 0.0625 nil)
schCreateWire(cv "route" "full" '((19.000 3.250) (18.250 3.250)) 0 0 0 nil nil)
schCreateWireLabel(cv nil '(18.750 3.250) "VIOH" "lowerRight" "R0" "stick" 0.0625 nil)
schCreateWire(cv "route" "full" '((19.000 3.625) (18.250 3.625)) 0 0 0 nil nil)
schCreateWireLabel(cv nil '(18.750 3.625) "GIOH" "lowerRight" "R0" "stick" 0.0625 nil)
dbCreateInst(cv pddw16sdgz_h_gMaster "D4_right1" '(20.0 4.3125) "R90")
schCreateWire(cv "route" "full" '((19.000 4.438) (18.250 4.438)) 0 0 0 nil nil)
schCreateWireLabel(cv nil '(18.750 4.438) "VIOL" "lowerRight" "R0" "stick" 0.0625 nil)
schCreateWire(cv "route" "full" '((19.000 4.562) (18.250 4.562)) 0 0 0 nil nil)
dbCreateInst(cv noConnMaster "noConn_D4_right1_C" '(18.250 4.562) "R270")
schCreateWire(cv "route" "full" '((19.000 4.188) (18.250 4.188)) 0 0 0 nil nil)
schCreateWireLabel(cv nil '(18.750 4.188) "GIOL" "lowerRight" "R0" "stick" 0.0625 nil)
schCreateWire(cv "route" "full" '((19.000 4.062) (18.250 4.062)) 0 0 0 nil nil)
schCreateWireLabel(cv nil '(18.750 4.062) "D4_CORE" "lowerRight" "R0" "stick" 0.0625 nil)
schCreatePin(cv nil "D4_CORE" "inputOutput" nil '(18.250 4.062) "R0")
schCreateWire(cv "route" "full" '((20.000 5.000) (20.750 5.000)) 0 0 0 nil nil)
schCreateWireLabel(cv nil '(20.250 5.000) "D4" "lowerLeft" "R0" "stick" 0.0625 nil)
schCreatePin(cv nil "D4" "inputOutput" nil '(20.750 5.000) "R180")
schCreateWire(cv "route" "full" '((19.000 4.688) (18.250 4.688)) 0 0 0 nil nil)
schCreateWireLabel(cv nil '(18.750 4.688) "POC" "lowerRight" "R0" "stick" 0.0625 nil)
schCreateWire(cv "route" "full" '((19.000 4.875) (18.250 4.875)) 0 0 0 nil nil)
schCreateWireLabel(cv nil '(18.750 4.875) "VIOL" "lowerRight" "R0" "stick" 0.0625 nil)
schCreateWire(cv "route" "full" '((19.000 5.062) (18.250 5.062)) 0 0 0 nil nil)
schCreateWireLabel(cv nil '(18.750 5.062) "GIOL" "lowerRight" "R0" "stick" 0.0625 nil)
schCreateWire(cv "route" "full" '((19.000 5.250) (18.250 5.250)) 0 0 0 nil nil)
schCreateWireLabel(cv nil '(18.750 5.250) "VIOH" "lowerRight" "R0" "stick" 0.0625 nil)
schCreateWire(cv "route" "full" '((19.000 5.625) (18.250 5.625)) 0 0 0 nil nil)
schCreateWireLabel(cv nil '(18.750 5.625) "GIOH" "lowerRight" "R0" "stick" 0.0625 nil)
dbCreateInst(cv pddw16sdgz_h_gMaster "D5_right2" '(20.0 6.3125) "R90")
schCreateWire(cv "route" "full" '((19.000 6.438) (18.250 6.438)) 0 0 0 nil nil)
schCreateWireLabel(cv nil '(18.750 6.438) "VIOL" "lowerRight" "R0" "stick" 0.0625 nil)
schCreateWire(cv "route" "full" '((19.000 6.562) (18.250 6.562)) 0 0 0 nil nil)
dbCreateInst(cv noConnMaster "noConn_D5_right2_C" '(18.250 6.562) "R270")
schCreateWire(cv "route" "full" '((19.000 6.188) (18.250 6.188)) 0 0 0 nil nil)
schCreateWireLabel(cv nil '(18.750 6.188) "GIOL" "lowerRight" "R0" "stick" 0.0625 nil)
schCreateWire(cv "route" "full" '((19.000 6.062) (18.250 6.062)) 0 0 0 nil nil)
schCreateWireLabel(cv nil '(18.750 6.062) "D5_CORE" "lowerRight" "R0" "stick" 0.0625 nil)
schCreatePin(cv nil "D5_CORE" "inputOutput" nil '(18.250 6.062) "R0")
schCreateWire(cv "route" "full" '((20.000 7.000) (20.750 7.000)) 0 0 0 nil nil)
schCreateWireLabel(cv nil '(20.250 7.000) "D5" "lowerLeft" "R0" "stick" 0.0625 nil)
schCreatePin(cv nil "D5" "inputOutput" nil '(20.750 7.000) "R180")
schCreateWire(cv "route" "full" '((19.000 6.688) (18.250 6.688)) 0 0 0 nil nil)
schCreateWireLabel(cv nil '(18.750 6.688) "POC" "lowerRight" "R0" "stick" 0.0625 nil)
schCreateWire(cv "route" "full" '((19.000 6.875) (18.250 6.875)) 0 0 0 nil nil)
schCreateWireLabel(cv nil '(18.750 6.875) "VIOL" "lowerRight" "R0" "stick" 0.0625 nil)
schCreateWire(cv "route" "full" '((19.000 7.062) (18.250 7.062)) 0 0 0 nil nil)
schCreateWireLabel(cv nil '(18.750 7.062) "GIOL" "lowerRight" "R0" "stick" 0.0625 nil)
schCreateWire(cv "route" "full" '((19.000 7.250) (18.250 7.250)) 0 0 0 nil nil)
schCreateWireLabel(cv nil '(18.750 7.250) "VIOH" "lowerRight" "R0" "stick" 0.0625 nil)
schCreateWire(cv "route" "full" '((19.000 7.625) (18.250 7.625)) 0 0 0 nil nil)
schCreateWireLabel(cv nil '(18.750 7.625) "GIOH" "lowerRight" "R0" "stick" 0.0625 nil)
dbCreateInst(cv pddw16sdgz_h_gMaster "D6_right3" '(20.0 8.3125) "R90")
schCreateWire(cv "route" "full" '((19.000 8.438) (18.250 8.438)) 0 0 0 nil nil)
schCreateWireLabel(cv nil '(18.750 8.438) "VIOL" "lowerRight" "R0" "stick" 0.0625 nil)
schCreateWire(cv "route" "full" '((19.000 8.562) (18.250 8.562)) 0 0 0 nil nil)
dbCreateInst(cv noConnMaster "noConn_D6_right3_C" '(18.250 8.562) "R270")
schCreateWire(cv "route" "full" '((19.000 8.188) (18.250 8.188)) 0 0 0 nil nil)
schCreateWireLabel(cv nil '(18.750 8.188) "GIOL" "lowerRight" "R0" "stick" 0.0625 nil)
schCreateWire(cv "route" "full" '((19.000 8.062) (18.250 8.062)) 0 0 0 nil nil)
schCreateWireLabel(cv nil '(18.750 8.062) "D6_CORE" "lowerRight" "R0" "stick" 0.0625 nil)
schCreatePin(cv nil "D6_CORE" "inputOutput" nil '(18.250 8.062) "R0")
schCreateWire(cv "route" "full" '((20.000 9.001) (20.750 9.001)) 0 0 0 nil nil)
schCreateWireLabel(cv nil '(20.250 9.001) "D6" "lowerLeft" "R0" "stick" 0.0625 nil)
schCreatePin(cv nil "D6" "inputOutput" nil '(20.750 9.001) "R180")
schCreateWire(cv "route" "full" '((19.000 8.688) (18.250 8.688)) 0 0 0 nil nil)
schCreateWireLabel(cv nil '(18.750 8.688) "POC" "lowerRight" "R0" "stick" 0.0625 nil)
schCreateWire(cv "route" "full" '((19.000 8.874) (18.250 8.874)) 0 0 0 nil nil)
schCreateWireLabel(cv nil '(18.750 8.874) "VIOL" "lowerRight" "R0" "stick" 0.0625 nil)
schCreateWire(cv "route" "full" '((19.000 9.062) (18.250 9.062)) 0 0 0 nil nil)
schCreateWireLabel(cv nil '(18.750 9.062) "GIOL" "lowerRight" "R0" "stick" 0.0625 nil)
schCreateWire(cv "route" "full" '((19.000 9.251) (18.250 9.251)) 0 0 0 nil nil)
schCreateWireLabel(cv nil '(18.750 9.251) "VIOH" "lowerRight" "R0" "stick" 0.0625 nil)
schCreateWire(cv "route" "full" '((19.000 9.624) (18.250 9.624)) 0 0 0 nil nil)
schCreateWireLabel(cv nil '(18.750 9.624) "GIOH" "lowerRight" "R0" "stick" 0.0625 nil)
dbCreateInst(cv pddw16sdgz_h_gMaster "D7_right4" '(20.0 10.3125) "R90")
schCreateWire(cv "route" "full" '((19.000 10.438) (18.250 10.438)) 0 0 0 nil nil)
schCreateWireLabel(cv nil '(18.750 10.438) "VIOL" "lowerRight" "R0" "stick" 0.0625 nil)
schCreateWire(cv "route" "full" '((19.000 10.562) (18.250 10.562)) 0 0 0 nil nil)
dbCreateInst(cv noConnMaster "noConn_D7_right4_C" '(18.250 10.562) "R270")
schCreateWire(cv "route" "full" '((19.000 10.188) (18.250 10.188)) 0 0 0 nil nil)
schCreateWireLabel(cv nil '(18.750 10.188) "GIOL" "lowerRight" "R0" "stick" 0.0625 nil)
schCreateWire(cv "route" "full" '((19.000 10.062) (18.250 10.062)) 0 0 0 nil nil)
schCreateWireLabel(cv nil '(18.750 10.062) "D7_CORE" "lowerRight" "R0" "stick" 0.0625 nil)
schCreatePin(cv nil "D7_CORE" "inputOutput" nil '(18.250 10.062) "R0")
schCreateWire(cv "route" "full" '((20.000 11.001) (20.750 11.001)) 0 0 0 nil nil)
schCreateWireLabel(cv nil '(20.250 11.001) "D7" "lowerLeft" "R0" "stick" 0.0625 nil)
schCreatePin(cv nil "D7" "inputOutput" nil '(20.750 11.001) "R180")
schCreateWire(cv "route" "full" '((19.000 10.688) (18.250 10.688)) 0 0 0 nil nil)
schCreateWireLabel(cv nil '(18.750 10.688) "POC" "lowerRight" "R0" "stick" 0.0625 nil)
schCreateWire(cv "route" "full" '((19.000 10.874) (18.250 10.874)) 0 0 0 nil nil)
schCreateWireLabel(cv nil '(18.750 10.874) "VIOL" "lowerRight" "R0" "stick" 0.0625 nil)
schCreateWire(cv "route" "full" '((19.000 11.062) (18.250 11.062)) 0 0 0 nil nil)
schCreateWireLabel(cv nil '(18.750 11.062) "GIOL" "lowerRight" "R0" "stick" 0.0625 nil)
schCreateWire(cv "route" "full" '((19.000 11.251) (18.250 11.251)) 0 0 0 nil nil)
schCreateWireLabel(cv nil '(18.750 11.251) "VIOH" "lowerRight" "R0" "stick" 0.0625 nil)
schCreateWire(cv "route" "full" '((19.000 11.624) (18.250 11.624)) 0 0 0 nil nil)
schCreateWireLabel(cv nil '(18.750 11.624) "GIOH" "lowerRight" "R0" "stick" 0.0625 nil)
dbCreateInst(cv pddw16sdgz_h_gMaster "D8_right5" '(20.0 12.3125) "R90")
schCreateWire(cv "route" "full" '((19.000 12.438) (18.250 12.438)) 0 0 0 nil nil)
schCreateWireLabel(cv nil '(18.750 12.438) "VIOL" "lowerRight" "R0" "stick" 0.0625 nil)
schCreateWire(cv "route" "full" '((19.000 12.562) (18.250 12.562)) 0 0 0 nil nil)
dbCreateInst(cv noConnMaster "noConn_D8_right5_C" '(18.250 12.562) "R270")
schCreateWire(cv "route" "full" '((19.000 12.188) (18.250 12.188)) 0 0 0 nil nil)
schCreateWireLabel(cv nil '(18.750 12.188) "GIOL" "lowerRight" "R0" "stick" 0.0625 nil)
schCreateWire(cv "route" "full" '((19.000 12.062) (18.250 12.062)) 0 0 0 nil nil)
schCreateWireLabel(cv nil '(18.750 12.062) "D8_CORE" "lowerRight" "R0" "stick" 0.0625 nil)
schCreatePin(cv nil "D8_CORE" "inputOutput" nil '(18.250 12.062) "R0")
schCreateWire(cv "route" "full" '((20.000 13.001) (20.750 13.001)) 0 0 0 nil nil)
schCreateWireLabel(cv nil '(20.250 13.001) "D8" "lowerLeft" "R0" "stick" 0.0625 nil)
schCreatePin(cv nil "D8" "inputOutput" nil '(20.750 13.001) "R180")
schCreateWire(cv "route" "full" '((19.000 12.688) (18.250 12.688)) 0 0 0 nil nil)
schCreateWireLabel(cv nil '(18.750 12.688) "POC" "lowerRight" "R0" "stick" 0.0625 nil)
schCreateWire(cv "route" "full" '((19.000 12.874) (18.250 12.874)) 0 0 0 nil nil)
schCreateWireLabel(cv nil '(18.750 12.874) "VIOL" "lowerRight" "R0" "stick" 0.0625 nil)
schCreateWire(cv "route" "full" '((19.000 13.062) (18.250 13.062)) 0 0 0 nil nil)
schCreateWireLabel(cv nil '(18.750 13.062) "GIOL" "lowerRight" "R0" "stick" 0.0625 nil)
schCreateWire(cv "route" "full" '((19.000 13.251) (18.250 13.251)) 0 0 0 nil nil)
schCreateWireLabel(cv nil '(18.750 13.251) "VIOH" "lowerRight" "R0" "stick" 0.0625 nil)
schCreateWire(cv "route" "full" '((19.000 13.624) (18.250 13.624)) 0 0 0 nil nil)
schCreateWireLabel(cv nil '(18.750 13.624) "GIOH" "lowerRight" "R0" "stick" 0.0625 nil)
dbCreateInst(cv pddw16sdgz_h_gMaster "D9_right6" '(20.0 14.3125) "R90")
schCreateWire(cv "route" "full" '((19.000 14.438) (18.250 14.438)) 0 0 0 nil nil)
schCreateWireLabel(cv nil '(18.750 14.438) "VIOL" "lowerRight" "R0" "stick" 0.0625 nil)
schCreateWire(cv "route" "full" '((19.000 14.562) (18.250 14.562)) 0 0 0 nil nil)
dbCreateInst(cv noConnMaster "noConn_D9_right6_C" '(18.250 14.562) "R270")
schCreateWire(cv "route" "full" '((19.000 14.188) (18.250 14.188)) 0 0 0 nil nil)
schCreateWireLabel(cv nil '(18.750 14.188) "GIOL" "lowerRight" "R0" "stick" 0.0625 nil)
schCreateWire(cv "route" "full" '((19.000 14.062) (18.250 14.062)) 0 0 0 nil nil)
schCreateWireLabel(cv nil '(18.750 14.062) "D9_CORE" "lowerRight" "R0" "stick" 0.0625 nil)
schCreatePin(cv nil "D9_CORE" "inputOutput" nil '(18.250 14.062) "R0")
schCreateWire(cv "route" "full" '((20.000 15.001) (20.750 15.001)) 0 0 0 nil nil)
schCreateWireLabel(cv nil '(20.250 15.001) "D9" "lowerLeft" "R0" "stick" 0.0625 nil)
schCreatePin(cv nil "D9" "inputOutput" nil '(20.750 15.001) "R180")
schCreateWire(cv "route" "full" '((19.000 14.688) (18.250 14.688)) 0 0 0 nil nil)
schCreateWireLabel(cv nil '(18.750 14.688) "POC" "lowerRight" "R0" "stick" 0.0625 nil)
schCreateWire(cv "route" "full" '((19.000 14.874) (18.250 14.874)) 0 0 0 nil nil)
schCreateWireLabel(cv nil '(18.750 14.874) "VIOL" "lowerRight" "R0" "stick" 0.0625 nil)
schCreateWire(cv "route" "full" '((19.000 15.062) (18.250 15.062)) 0 0 0 nil nil)
schCreateWireLabel(cv nil '(18.750 15.062) "GIOL" "lowerRight" "R0" "stick" 0.0625 nil)
schCreateWire(cv "route" "full" '((19.000 15.251) (18.250 15.251)) 0 0 0 nil nil)
schCreateWireLabel(cv nil '(18.750 15.251) "VIOH" "lowerRight" "R0" "stick" 0.0625 nil)
schCreateWire(cv "route" "full" '((19.000 15.624) (18.250 15.624)) 0 0 0 nil nil)
schCreateWireLabel(cv nil '(18.750 15.624) "GIOH" "lowerRight" "R0" "stick" 0.0625 nil)
dbCreateInst(cv pddw16sdgz_h_gMaster "D10_right7" '(20.0 16.3125) "R90")
schCreateWire(cv "route" "full" '((19.000 16.438) (18.250 16.438)) 0 0 0 nil nil)
schCreateWireLabel(cv nil '(18.750 16.438) "VIOL" "lowerRight" "R0" "stick" 0.0625 nil)
schCreateWire(cv "route" "full" '((19.000 16.562) (18.250 16.562)) 0 0 0 nil nil)
dbCreateInst(cv noConnMaster "noConn_D10_right7_C" '(18.250 16.562) "R270")
schCreateWire(cv "route" "full" '((19.000 16.188) (18.250 16.188)) 0 0 0 nil nil)
schCreateWireLabel(cv nil '(18.750 16.188) "GIOL" "lowerRight" "R0" "stick" 0.0625 nil)
schCreateWire(cv "route" "full" '((19.000 16.062) (18.250 16.062)) 0 0 0 nil nil)
schCreateWireLabel(cv nil '(18.750 16.062) "D10_CORE" "lowerRight" "R0" "stick" 0.0625 nil)
schCreatePin(cv nil "D10_CORE" "inputOutput" nil '(18.250 16.062) "R0")
schCreateWire(cv "route" "full" '((20.000 17.000) (20.750 17.000)) 0 0 0 nil nil)
schCreateWireLabel(cv nil '(20.250 17.000) "D10" "lowerLeft" "R0" "stick" 0.0625 nil)
schCreatePin(cv nil "D10" "inputOutput" nil '(20.750 17.000) "R180")
schCreateWire(cv "route" "full" '((19.000 16.688) (18.250 16.688)) 0 0 0 nil nil)
schCreateWireLabel(cv nil '(18.750 16.688) "POC" "lowerRight" "R0" "stick" 0.0625 nil)
schCreateWire(cv "route" "full" '((19.000 16.875) (18.250 16.875)) 0 0 0 nil nil)
schCreateWireLabel(cv nil '(18.750 16.875) "VIOL" "lowerRight" "R0" "stick" 0.0625 nil)
schCreateWire(cv "route" "full" '((19.000 17.062) (18.250 17.062)) 0 0 0 nil nil)
schCreateWireLabel(cv nil '(18.750 17.062) "GIOL" "lowerRight" "R0" "stick" 0.0625 nil)
schCreateWire(cv "route" "full" '((19.000 17.250) (18.250 17.250)) 0 0 0 nil nil)
schCreateWireLabel(cv nil '(18.750 17.250) "VIOH" "lowerRight" "R0" "stick" 0.0625 nil)
schCreateWire(cv "route" "full" '((19.000 17.625) (18.250 17.625)) 0 0 0 nil nil)
schCreateWireLabel(cv nil '(18.750 17.625) "GIOH" "lowerRight" "R0" "stick" 0.0625 nil)
dbCreateInst(cv pddw16sdgz_v_gMaster "D11_top0" '(17.6875 20.0) "R180")
schCreateWire(cv "route" "full" '((17.562 19.000) (17.562 18.250)) 0 0 0 nil nil)
schCreateWireLabel(cv nil '(17.562 18.750) "VIOL" "lowerRight" "R90" "stick" 0.0625 nil)
schCreateWire(cv "route" "full" '((17.438 19.000) (17.438 18.250)) 0 0 0 nil nil)
dbCreateInst(cv noConnMaster "noConn_D11_top0_C" '(17.438 18.250) "R0")
schCreateWire(cv "route" "full" '((17.812 19.000) (17.812 18.250)) 0 0 0 nil nil)
schCreateWireLabel(cv nil '(17.812 18.750) "GIOL" "lowerRight" "R90" "stick" 0.0625 nil)
schCreateWire(cv "route" "full" '((17.938 19.000) (17.938 18.250)) 0 0 0 nil nil)
schCreateWireLabel(cv nil '(17.938 18.750) "D11_CORE" "lowerRight" "R90" "stick" 0.0625 nil)
schCreatePin(cv nil "D11_CORE" "inputOutput" nil '(17.938 18.250) "R90")
schCreateWire(cv "route" "full" '((17.000 20.000) (17.000 20.750)) 0 0 0 nil nil)
schCreateWireLabel(cv nil '(17.000 20.250) "D11" "lowerLeft" "R90" "stick" 0.0625 nil)
schCreatePin(cv nil "D11" "inputOutput" nil '(17.000 20.750) "R270")
schCreateWire(cv "route" "full" '((17.312 19.000) (17.312 18.250)) 0 0 0 nil nil)
schCreateWireLabel(cv nil '(17.312 18.750) "POC" "lowerRight" "R90" "stick" 0.0625 nil)
schCreateWire(cv "route" "full" '((17.125 19.000) (17.125 18.250)) 0 0 0 nil nil)
schCreateWireLabel(cv nil '(17.125 18.750) "VIOL" "lowerRight" "R90" "stick" 0.0625 nil)
schCreateWire(cv "route" "full" '((16.938 19.000) (16.938 18.250)) 0 0 0 nil nil)
schCreateWireLabel(cv nil '(16.938 18.750) "GIOL" "lowerRight" "R90" "stick" 0.0625 nil)
schCreateWire(cv "route" "full" '((16.750 19.000) (16.750 18.250)) 0 0 0 nil nil)
schCreateWireLabel(cv nil '(16.750 18.750) "VIOH" "lowerRight" "R90" "stick" 0.0625 nil)
schCreateWire(cv "route" "full" '((16.375 19.000) (16.375 18.250)) 0 0 0 nil nil)
schCreateWireLabel(cv nil '(16.375 18.750) "GIOH" "lowerRight" "R90" "stick" 0.0625 nil)
dbCreateInst(cv pddw16sdgz_v_gMaster "D12_top1" '(15.6875 20.0) "R180")
schCreateWire(cv "route" "full" '((15.562 19.000) (15.562 18.250)) 0 0 0 nil nil)
schCreateWireLabel(cv nil '(15.562 18.750) "VIOL" "lowerRight" "R90" "stick" 0.0625 nil)
schCreateWire(cv "route" "full" '((15.438 19.000) (15.438 18.250)) 0 0 0 nil nil)
dbCreateInst(cv noConnMaster "noConn_D12_top1_C" '(15.438 18.250) "R0")
schCreateWire(cv "route" "full" '((15.812 19.000) (15.812 18.250)) 0 0 0 nil nil)
schCreateWireLabel(cv nil '(15.812 18.750) "GIOL" "lowerRight" "R90" "stick" 0.0625 nil)
schCreateWire(cv "route" "full" '((15.938 19.000) (15.938 18.250)) 0 0 0 nil nil)
schCreateWireLabel(cv nil '(15.938 18.750) "D12_CORE" "lowerRight" "R90" "stick" 0.0625 nil)
schCreatePin(cv nil "D12_CORE" "inputOutput" nil '(15.938 18.250) "R90")
schCreateWire(cv "route" "full" '((14.999 20.000) (14.999 20.750)) 0 0 0 nil nil)
schCreateWireLabel(cv nil '(14.999 20.250) "D12" "lowerLeft" "R90" "stick" 0.0625 nil)
schCreatePin(cv nil "D12" "inputOutput" nil '(14.999 20.750) "R270")
schCreateWire(cv "route" "full" '((15.312 19.000) (15.312 18.250)) 0 0 0 nil nil)
schCreateWireLabel(cv nil '(15.312 18.750) "POC" "lowerRight" "R90" "stick" 0.0625 nil)
schCreateWire(cv "route" "full" '((15.126 19.000) (15.126 18.250)) 0 0 0 nil nil)
schCreateWireLabel(cv nil '(15.126 18.750) "VIOL" "lowerRight" "R90" "stick" 0.0625 nil)
schCreateWire(cv "route" "full" '((14.938 19.000) (14.938 18.250)) 0 0 0 nil nil)
schCreateWireLabel(cv nil '(14.938 18.750) "GIOL" "lowerRight" "R90" "stick" 0.0625 nil)
schCreateWire(cv "route" "full" '((14.749 19.000) (14.749 18.250)) 0 0 0 nil nil)
schCreateWireLabel(cv nil '(14.749 18.750) "VIOH" "lowerRight" "R90" "stick" 0.0625 nil)
schCreateWire(cv "route" "full" '((14.376 19.000) (14.376 18.250)) 0 0 0 nil nil)
schCreateWireLabel(cv nil '(14.376 18.750) "GIOH" "lowerRight" "R90" "stick" 0.0625 nil)
dbCreateInst(cv pddw16sdgz_v_gMaster "D13_top2" '(13.6875 20.0) "R180")
schCreateWire(cv "route" "full" '((13.562 19.000) (13.562 18.250)) 0 0 0 nil nil)
schCreateWireLabel(cv nil '(13.562 18.750) "VIOL" "lowerRight" "R90" "stick" 0.0625 nil)
schCreateWire(cv "route" "full" '((13.438 19.000) (13.438 18.250)) 0 0 0 nil nil)
dbCreateInst(cv noConnMaster "noConn_D13_top2_C" '(13.438 18.250) "R0")
schCreateWire(cv "route" "full" '((13.812 19.000) (13.812 18.250)) 0 0 0 nil nil)
schCreateWireLabel(cv nil '(13.812 18.750) "GIOL" "lowerRight" "R90" "stick" 0.0625 nil)
schCreateWire(cv "route" "full" '((13.938 19.000) (13.938 18.250)) 0 0 0 nil nil)
schCreateWireLabel(cv nil '(13.938 18.750) "D13_CORE" "lowerRight" "R90" "stick" 0.0625 nil)
schCreatePin(cv nil "D13_CORE" "inputOutput" nil '(13.938 18.250) "R90")
schCreateWire(cv "route" "full" '((12.999 20.000) (12.999 20.750)) 0 0 0 nil nil)
schCreateWireLabel(cv nil '(12.999 20.250) "D13" "lowerLeft" "R90" "stick" 0.0625 nil)
schCreatePin(cv nil "D13" "inputOutput" nil '(12.999 20.750) "R270")
schCreateWire(cv "route" "full" '((13.312 19.000) (13.312 18.250)) 0 0 0 nil nil)
schCreateWireLabel(cv nil '(13.312 18.750) "POC" "lowerRight" "R90" "stick" 0.0625 nil)
schCreateWire(cv "route" "full" '((13.126 19.000) (13.126 18.250)) 0 0 0 nil nil)
schCreateWireLabel(cv nil '(13.126 18.750) "VIOL" "lowerRight" "R90" "stick" 0.0625 nil)
schCreateWire(cv "route" "full" '((12.938 19.000) (12.938 18.250)) 0 0 0 nil nil)
schCreateWireLabel(cv nil '(12.938 18.750) "GIOL" "lowerRight" "R90" "stick" 0.0625 nil)
schCreateWire(cv "route" "full" '((12.749 19.000) (12.749 18.250)) 0 0 0 nil nil)
schCreateWireLabel(cv nil '(12.749 18.750) "VIOH" "lowerRight" "R90" "stick" 0.0625 nil)
schCreateWire(cv "route" "full" '((12.376 19.000) (12.376 18.250)) 0 0 0 nil nil)
schCreateWireLabel(cv nil '(12.376 18.750) "GIOH" "lowerRight" "R90" "stick" 0.0625 nil)
dbCreateInst(cv pddw16sdgz_v_gMaster "D14_top3" '(11.6875 20.0) "R180")
schCreateWire(cv "route" "full" '((11.562 19.000) (11.562 18.250)) 0 0 0 nil nil)
schCreateWireLabel(cv nil '(11.562 18.750) "VIOL" "lowerRight" "R90" "stick" 0.0625 nil)
schCreateWire(cv "route" "full" '((11.438 19.000) (11.438 18.250)) 0 0 0 nil nil)
dbCreateInst(cv noConnMaster "noConn_D14_top3_C" '(11.438 18.250) "R0")
schCreateWire(cv "route" "full" '((11.812 19.000) (11.812 18.250)) 0 0 0 nil nil)
schCreateWireLabel(cv nil '(11.812 18.750) "GIOL" "lowerRight" "R90" "stick" 0.0625 nil)
schCreateWire(cv "route" "full" '((11.938 19.000) (11.938 18.250)) 0 0 0 nil nil)
schCreateWireLabel(cv nil '(11.938 18.750) "D14_CORE" "lowerRight" "R90" "stick" 0.0625 nil)
schCreatePin(cv nil "D14_CORE" "inputOutput" nil '(11.938 18.250) "R90")
schCreateWire(cv "route" "full" '((10.999 20.000) (10.999 20.750)) 0 0 0 nil nil)
schCreateWireLabel(cv nil '(10.999 20.250) "D14" "lowerLeft" "R90" "stick" 0.0625 nil)
schCreatePin(cv nil "D14" "inputOutput" nil '(10.999 20.750) "R270")
schCreateWire(cv "route" "full" '((11.312 19.000) (11.312 18.250)) 0 0 0 nil nil)
schCreateWireLabel(cv nil '(11.312 18.750) "POC" "lowerRight" "R90" "stick" 0.0625 nil)
schCreateWire(cv "route" "full" '((11.126 19.000) (11.126 18.250)) 0 0 0 nil nil)
schCreateWireLabel(cv nil '(11.126 18.750) "VIOL" "lowerRight" "R90" "stick" 0.0625 nil)
schCreateWire(cv "route" "full" '((10.938 19.000) (10.938 18.250)) 0 0 0 nil nil)
schCreateWireLabel(cv nil '(10.938 18.750) "GIOL" "lowerRight" "R90" "stick" 0.0625 nil)
schCreateWire(cv "route" "full" '((10.749 19.000) (10.749 18.250)) 0 0 0 nil nil)
schCreateWireLabel(cv nil '(10.749 18.750) "VIOH" "lowerRight" "R90" "stick" 0.0625 nil)
schCreateWire(cv "route" "full" '((10.376 19.000) (10.376 18.250)) 0 0 0 nil nil)
schCreateWireLabel(cv nil '(10.376 18.750) "GIOH" "lowerRight" "R90" "stick" 0.0625 nil)
pvdd1dgz_v_gMaster = dbOpenCellView("tphn28hpcpgv18" "PVDD1DGZ_V_G" "symbol")
dbCreateInst(cv pvdd1dgz_v_gMaster "VIOL_top4" '(10.0 20.0) "R180")
schCreateWire(cv "route" "full" '((9.625 19.000) (9.625 18.250)) 0 0 0 nil nil)
schCreateWireLabel(cv nil '(9.625 18.750) "POC" "lowerRight" "R90" "stick" 0.0625 nil)
schCreateWire(cv "route" "full" '((9.000 20.000) (9.000 20.750)) 0 0 0 nil nil)
schCreateWireLabel(cv nil '(9.000 20.250) "VIOL" "lowerLeft" "R90" "stick" 0.0625 nil)
schCreatePin(cv nil "VIOL" "inputOutput" nil '(9.000 20.750) "R270")
schCreateWire(cv "route" "full" '((9.250 19.000) (9.250 18.250)) 0 0 0 nil nil)
schCreateWireLabel(cv nil '(9.250 18.750) "GIOL" "lowerRight" "R90" "stick" 0.0625 nil)
schCreateWire(cv "route" "full" '((9.062 19.000) (9.062 18.250)) 0 0 0 nil nil)
schCreateWireLabel(cv nil '(9.062 18.750) "VIOH" "lowerRight" "R90" "stick" 0.0625 nil)
schCreateWire(cv "route" "full" '((8.688 19.000) (8.688 18.250)) 0 0 0 nil nil)
schCreateWireLabel(cv nil '(8.688 18.750) "GIOH" "lowerRight" "R90" "stick" 0.0625 nil)
pvss1dgz_v_gMaster = dbOpenCellView("tphn28hpcpgv18" "PVSS1DGZ_V_G" "symbol")
dbCreateInst(cv pvss1dgz_v_gMaster "GIOL_top5" '(8.0 20.0) "R180")
schCreateWire(cv "route" "full" '((7.625 19.000) (7.625 18.250)) 0 0 0 nil nil)
schCreateWireLabel(cv nil '(7.625 18.750) "POC" "lowerRight" "R90" "stick" 0.0625 nil)
schCreateWire(cv "route" "full" '((7.438 19.000) (7.438 18.250)) 0 0 0 nil nil)
schCreateWireLabel(cv nil '(7.438 18.750) "VIOL" "lowerRight" "R90" "stick" 0.0625 nil)
schCreateWire(cv "route" "full" '((7.000 20.000) (7.000 20.750)) 0 0 0 nil nil)
schCreateWireLabel(cv nil '(7.000 20.250) "GIOL" "lowerLeft" "R90" "stick" 0.0625 nil)
schCreatePin(cv nil "GIOL" "inputOutput" nil '(7.000 20.750) "R270")
schCreateWire(cv "route" "full" '((7.062 19.000) (7.062 18.250)) 0 0 0 nil nil)
schCreateWireLabel(cv nil '(7.062 18.750) "VIOH" "lowerRight" "R90" "stick" 0.0625 nil)
schCreateWire(cv "route" "full" '((6.688 19.000) (6.688 18.250)) 0 0 0 nil nil)
schCreateWireLabel(cv nil '(6.688 18.750) "GIOH" "lowerRight" "R90" "stick" 0.0625 nil)
pvdd2poc_v_gMaster = dbOpenCellView("tphn28hpcpgv18" "PVDD2POC_V_G" "symbol")
dbCreateInst(cv pvdd2poc_v_gMaster "VIOH_top6" '(6.0 20.0) "R180")
schCreateWire(cv "route" "full" '((5.625 19.000) (5.625 18.250)) 0 0 0 nil nil)
schCreateWireLabel(cv nil '(5.625 18.750) "POC" "lowerRight" "R90" "stick" 0.0625 nil)
schCreateWire(cv "route" "full" '((5.438 19.000) (5.438 18.250)) 0 0 0 nil nil)
schCreateWireLabel(cv nil '(5.438 18.750) "VIOL" "lowerRight" "R90" "stick" 0.0625 nil)
schCreateWire(cv "route" "full" '((5.250 19.000) (5.250 18.250)) 0 0 0 nil nil)
schCreateWireLabel(cv nil '(5.250 18.750) "GIOL" "lowerRight" "R90" "stick" 0.0625 nil)
schCreateWire(cv "route" "full" '((5.000 20.000) (5.000 20.750)) 0 0 0 nil nil)
schCreateWireLabel(cv nil '(5.000 20.250) "VIOH" "lowerLeft" "R90" "stick" 0.0625 nil)
schCreatePin(cv nil "VIOH" "inputOutput" nil '(5.000 20.750) "R270")
schCreateWire(cv "route" "full" '((4.688 19.000) (4.688 18.250)) 0 0 0 nil nil)
schCreateWireLabel(cv nil '(4.688 18.750) "GIOH" "lowerRight" "R90" "stick" 0.0625 nil)
pvss2dgz_v_gMaster = dbOpenCellView("tphn28hpcpgv18" "PVSS2DGZ_V_G" "symbol")
dbCreateInst(cv pvss2dgz_v_gMaster "GIOH_top7" '(4.0 20.0) "R180")
schCreateWire(cv "route" "full" '((3.625 19.000) (3.625 18.250)) 0 0 0 nil nil)
schCreateWireLabel(cv nil '(3.625 18.750) "POC" "lowerRight" "R90" "stick" 0.0625 nil)
schCreateWire(cv "route" "full" '((3.438 19.000) (3.438 18.250)) 0 0 0 nil nil)
schCreateWireLabel(cv nil '(3.438 18.750) "VIOL" "lowerRight" "R90" "stick" 0.0625 nil)
schCreateWire(cv "route" "full" '((3.250 19.000) (3.250 18.250)) 0 0 0 nil nil)
schCreateWireLabel(cv nil '(3.250 18.750) "GIOL" "lowerRight" "R90" "stick" 0.0625 nil)
schCreateWire(cv "route" "full" '((3.062 19.000) (3.062 18.250)) 0 0 0 nil nil)
schCreateWireLabel(cv nil '(3.062 18.750) "VIOH" "lowerRight" "R90" "stick" 0.0625 nil)
schCreateWire(cv "route" "full" '((3.000 20.000) (3.000 20.750)) 0 0 0 nil nil)
schCreateWireLabel(cv nil '(3.000 20.250) "GIOH" "lowerLeft" "R90" "stick" 0.0625 nil)
schCreatePin(cv nil "GIOH" "inputOutput" nil '(3.000 20.750) "R270")
schCheck(cv)
dbSave(cv)
t
