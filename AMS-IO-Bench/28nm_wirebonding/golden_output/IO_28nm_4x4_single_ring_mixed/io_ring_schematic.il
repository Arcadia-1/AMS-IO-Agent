pdb3ac_h_gMaster = dbOpenCellView("tphn28hpcpgv18" "PDB3AC_H_G" "symbol")
dbCreateInst(cv pdb3ac_h_gMaster "VIN_left0" '(0 8.8125) "R270")
schCreateWire(cv "route" "full" '((0.000 9.001) (-0.750 9.001)) 0 0 0 nil nil)
schCreateWireLabel(cv nil '(-0.250 9.001) "VIN" "lowerRight" "R0" "stick" 0.0625 nil)
schCreatePin(cv nil "VIN" "inputOutput" nil '(-0.750 9.001) "R0")
schCreateWire(cv "route" "full" '((0.875 9.062) (1.625 9.062)) 0 0 0 nil nil)
schCreateWireLabel(cv nil '(1.125 9.062) "AVSS" "lowerLeft" "R0" "stick" 0.0625 nil)
schCreateWire(cv "route" "full" '((0.875 8.688) (1.625 8.688)) 0 0 0 nil nil)
schCreateWireLabel(cv nil '(1.125 8.688) "GIOL" "lowerLeft" "R0" "stick" 0.0625 nil)
schCreateWire(cv "route" "full" '((0.875 9.438) (1.625 9.438)) 0 0 0 nil nil)
schCreateWireLabel(cv nil '(1.125 9.438) "AVDD" "lowerLeft" "R0" "stick" 0.0625 nil)
dbCreateInst(cv pdb3ac_h_gMaster "VIP_left1" '(0 6.8125) "R270")
schCreateWire(cv "route" "full" '((0.000 7.000) (-0.750 7.000)) 0 0 0 nil nil)
schCreateWireLabel(cv nil '(-0.250 7.000) "VIP" "lowerRight" "R0" "stick" 0.0625 nil)
schCreatePin(cv nil "VIP" "inputOutput" nil '(-0.750 7.000) "R0")
schCreateWire(cv "route" "full" '((0.875 7.062) (1.625 7.062)) 0 0 0 nil nil)
schCreateWireLabel(cv nil '(1.125 7.062) "AVSS" "lowerLeft" "R0" "stick" 0.0625 nil)
schCreateWire(cv "route" "full" '((0.875 6.688) (1.625 6.688)) 0 0 0 nil nil)
schCreateWireLabel(cv nil '(1.125 6.688) "GIOL" "lowerLeft" "R0" "stick" 0.0625 nil)
schCreateWire(cv "route" "full" '((0.875 7.438) (1.625 7.438)) 0 0 0 nil nil)
schCreateWireLabel(cv nil '(1.125 7.438) "AVDD" "lowerLeft" "R0" "stick" 0.0625 nil)
dbCreateInst(cv pdb3ac_h_gMaster "VCM_left2" '(0 4.8125) "R270")
schCreateWire(cv "route" "full" '((0.000 5.000) (-0.750 5.000)) 0 0 0 nil nil)
schCreateWireLabel(cv nil '(-0.250 5.000) "VCM" "lowerRight" "R0" "stick" 0.0625 nil)
schCreatePin(cv nil "VCM" "inputOutput" nil '(-0.750 5.000) "R0")
schCreateWire(cv "route" "full" '((0.875 5.062) (1.625 5.062)) 0 0 0 nil nil)
schCreateWireLabel(cv nil '(1.125 5.062) "AVSS" "lowerLeft" "R0" "stick" 0.0625 nil)
schCreateWire(cv "route" "full" '((0.875 4.688) (1.625 4.688)) 0 0 0 nil nil)
schCreateWireLabel(cv nil '(1.125 4.688) "GIOL" "lowerLeft" "R0" "stick" 0.0625 nil)
schCreateWire(cv "route" "full" '((0.875 5.438) (1.625 5.438)) 0 0 0 nil nil)
schCreateWireLabel(cv nil '(1.125 5.438) "AVDD" "lowerLeft" "R0" "stick" 0.0625 nil)
pvdd3ac_h_gMaster = dbOpenCellView("tphn28hpcpgv18" "PVDD3AC_H_G" "symbol")
dbCreateInst(cv pvdd3ac_h_gMaster "AVDD_left3" '(0 2.8125) "R270")
schCreateWire(cv "route" "full" '((0.875 3.438) (1.625 3.438)) 0 0 0 nil nil)
schCreateWireLabel(cv nil '(1.125 3.438) "AVDD_CORE" "lowerLeft" "R0" "stick" 0.0625 nil)
schCreatePin(cv nil "AVDD_CORE" "inputOutput" nil '(1.625 3.438) "R180")
schCreateWire(cv "route" "full" '((0.875 3.062) (1.625 3.062)) 0 0 0 nil nil)
schCreateWireLabel(cv nil '(1.125 3.062) "AVSS" "lowerLeft" "R0" "stick" 0.0625 nil)
schCreateWire(cv "route" "full" '((0.875 2.688) (1.625 2.688)) 0 0 0 nil nil)
schCreateWireLabel(cv nil '(1.125 2.688) "GIOL" "lowerLeft" "R0" "stick" 0.0625 nil)
schCreateWire(cv "route" "full" '((0.000 3.001) (-0.750 3.001)) 0 0 0 nil nil)
schCreateWireLabel(cv nil '(-0.250 3.001) "AVDD" "lowerRight" "R0" "stick" 0.0625 nil)
schCreatePin(cv nil "AVDD" "inputOutput" nil '(-0.750 3.001) "R0")
pvss3ac_v_gMaster = dbOpenCellView("tphn28hpcpgv18" "PVSS3AC_V_G" "symbol")
dbCreateInst(cv pvss3ac_v_gMaster "AVSS_bottom0" '(3.1875 0) "R0")
schCreateWire(cv "route" "full" '((2.999 0.000) (2.999 -0.750)) 0 0 0 nil nil)
schCreateWireLabel(cv nil '(2.999 -0.250) "AVSS" "lowerRight" "R90" "stick" 0.0625 nil)
schCreatePin(cv nil "AVSS" "inputOutput" nil '(2.999 -0.750) "R90")
schCreateWire(cv "route" "full" '((3.312 0.875) (3.312 1.625)) 0 0 0 nil nil)
schCreateWireLabel(cv nil '(3.312 1.125) "GIOL" "lowerLeft" "R90" "stick" 0.0625 nil)
schCreateWire(cv "route" "full" '((2.562 0.875) (2.562 1.625)) 0 0 0 nil nil)
schCreateWireLabel(cv nil '(2.562 1.125) "AVSS_CORE" "lowerLeft" "R90" "stick" 0.0625 nil)
schCreatePin(cv nil "AVSS_CORE" "inputOutput" nil '(2.562 1.625) "R270")
schCreateWire(cv "route" "full" '((2.938 0.875) (2.938 1.625)) 0 0 0 nil nil)
schCreateWireLabel(cv nil '(2.938 1.125) "AVDD" "lowerLeft" "R90" "stick" 0.0625 nil)
pddw16sdgz_v_gMaster = dbOpenCellView("tphn28hpcpgv18" "PDDW16SDGZ_V_G" "symbol")
dbCreateInst(cv pddw16sdgz_v_gMaster "D0_bottom1" '(4.3125 0) "R0")
schCreateWire(cv "route" "full" '((4.438 1.000) (4.438 1.750)) 0 0 0 nil nil)
schCreateWireLabel(cv nil '(4.438 1.250) "VIOL" "lowerLeft" "R90" "stick" 0.0625 nil)
noConnMaster = dbOpenCellView("basic" "noConn" "symbol")
schCreateWire(cv "route" "full" '((4.562 1.000) (4.562 1.750)) 0 0 0 nil nil)
dbCreateInst(cv noConnMaster "noConn_D0_bottom1_C" '(4.562 1.750) "R180")
schCreateWire(cv "route" "full" '((4.188 1.000) (4.188 1.750)) 0 0 0 nil nil)
schCreateWireLabel(cv nil '(4.188 1.250) "GIOL" "lowerLeft" "R90" "stick" 0.0625 nil)
schCreateWire(cv "route" "full" '((4.062 1.000) (4.062 1.750)) 0 0 0 nil nil)
schCreateWireLabel(cv nil '(4.062 1.250) "D0_CORE" "lowerLeft" "R90" "stick" 0.0625 nil)
schCreatePin(cv nil "D0_CORE" "inputOutput" nil '(4.062 1.750) "R270")
schCreateWire(cv "route" "full" '((5.000 0.000) (5.000 -0.750)) 0 0 0 nil nil)
schCreateWireLabel(cv nil '(5.000 -0.250) "D0" "lowerRight" "R90" "stick" 0.0625 nil)
schCreatePin(cv nil "D0" "inputOutput" nil '(5.000 -0.750) "R90")
schCreateWire(cv "route" "full" '((4.688 1.000) (4.688 1.750)) 0 0 0 nil nil)
schCreateWireLabel(cv nil '(4.688 1.250) "POC" "lowerLeft" "R90" "stick" 0.0625 nil)
schCreateWire(cv "route" "full" '((4.875 1.000) (4.875 1.750)) 0 0 0 nil nil)
schCreateWireLabel(cv nil '(4.875 1.250) "VIOL" "lowerLeft" "R90" "stick" 0.0625 nil)
schCreateWire(cv "route" "full" '((5.062 1.000) (5.062 1.750)) 0 0 0 nil nil)
schCreateWireLabel(cv nil '(5.062 1.250) "GIOL" "lowerLeft" "R90" "stick" 0.0625 nil)
schCreateWire(cv "route" "full" '((5.250 1.000) (5.250 1.750)) 0 0 0 nil nil)
schCreateWireLabel(cv nil '(5.250 1.250) "VIOH" "lowerLeft" "R90" "stick" 0.0625 nil)
schCreateWire(cv "route" "full" '((5.625 1.000) (5.625 1.750)) 0 0 0 nil nil)
schCreateWireLabel(cv nil '(5.625 1.250) "GIOH" "lowerLeft" "R90" "stick" 0.0625 nil)
dbCreateInst(cv pddw16sdgz_v_gMaster "D1_bottom2" '(6.3125 0) "R0")
schCreateWire(cv "route" "full" '((6.438 1.000) (6.438 1.750)) 0 0 0 nil nil)
schCreateWireLabel(cv nil '(6.438 1.250) "VIOL" "lowerLeft" "R90" "stick" 0.0625 nil)
schCreateWire(cv "route" "full" '((6.562 1.000) (6.562 1.750)) 0 0 0 nil nil)
dbCreateInst(cv noConnMaster "noConn_D1_bottom2_C" '(6.562 1.750) "R180")
schCreateWire(cv "route" "full" '((6.188 1.000) (6.188 1.750)) 0 0 0 nil nil)
schCreateWireLabel(cv nil '(6.188 1.250) "GIOL" "lowerLeft" "R90" "stick" 0.0625 nil)
schCreateWire(cv "route" "full" '((6.062 1.000) (6.062 1.750)) 0 0 0 nil nil)
schCreateWireLabel(cv nil '(6.062 1.250) "D1_CORE" "lowerLeft" "R90" "stick" 0.0625 nil)
schCreatePin(cv nil "D1_CORE" "inputOutput" nil '(6.062 1.750) "R270")
schCreateWire(cv "route" "full" '((7.000 0.000) (7.000 -0.750)) 0 0 0 nil nil)
schCreateWireLabel(cv nil '(7.000 -0.250) "D1" "lowerRight" "R90" "stick" 0.0625 nil)
schCreatePin(cv nil "D1" "inputOutput" nil '(7.000 -0.750) "R90")
schCreateWire(cv "route" "full" '((6.688 1.000) (6.688 1.750)) 0 0 0 nil nil)
schCreateWireLabel(cv nil '(6.688 1.250) "POC" "lowerLeft" "R90" "stick" 0.0625 nil)
schCreateWire(cv "route" "full" '((6.875 1.000) (6.875 1.750)) 0 0 0 nil nil)
schCreateWireLabel(cv nil '(6.875 1.250) "VIOL" "lowerLeft" "R90" "stick" 0.0625 nil)
schCreateWire(cv "route" "full" '((7.062 1.000) (7.062 1.750)) 0 0 0 nil nil)
schCreateWireLabel(cv nil '(7.062 1.250) "GIOL" "lowerLeft" "R90" "stick" 0.0625 nil)
schCreateWire(cv "route" "full" '((7.250 1.000) (7.250 1.750)) 0 0 0 nil nil)
schCreateWireLabel(cv nil '(7.250 1.250) "VIOH" "lowerLeft" "R90" "stick" 0.0625 nil)
schCreateWire(cv "route" "full" '((7.625 1.000) (7.625 1.750)) 0 0 0 nil nil)
schCreateWireLabel(cv nil '(7.625 1.250) "GIOH" "lowerLeft" "R90" "stick" 0.0625 nil)
dbCreateInst(cv pddw16sdgz_v_gMaster "D2_bottom3" '(8.3125 0) "R0")
schCreateWire(cv "route" "full" '((8.438 1.000) (8.438 1.750)) 0 0 0 nil nil)
schCreateWireLabel(cv nil '(8.438 1.250) "VIOL" "lowerLeft" "R90" "stick" 0.0625 nil)
schCreateWire(cv "route" "full" '((8.562 1.000) (8.562 1.750)) 0 0 0 nil nil)
dbCreateInst(cv noConnMaster "noConn_D2_bottom3_C" '(8.562 1.750) "R180")
schCreateWire(cv "route" "full" '((8.188 1.000) (8.188 1.750)) 0 0 0 nil nil)
schCreateWireLabel(cv nil '(8.188 1.250) "GIOL" "lowerLeft" "R90" "stick" 0.0625 nil)
schCreateWire(cv "route" "full" '((8.062 1.000) (8.062 1.750)) 0 0 0 nil nil)
schCreateWireLabel(cv nil '(8.062 1.250) "D2_CORE" "lowerLeft" "R90" "stick" 0.0625 nil)
schCreatePin(cv nil "D2_CORE" "inputOutput" nil '(8.062 1.750) "R270")
schCreateWire(cv "route" "full" '((9.001 0.000) (9.001 -0.750)) 0 0 0 nil nil)
schCreateWireLabel(cv nil '(9.001 -0.250) "D2" "lowerRight" "R90" "stick" 0.0625 nil)
schCreatePin(cv nil "D2" "inputOutput" nil '(9.001 -0.750) "R90")
schCreateWire(cv "route" "full" '((8.688 1.000) (8.688 1.750)) 0 0 0 nil nil)
schCreateWireLabel(cv nil '(8.688 1.250) "POC" "lowerLeft" "R90" "stick" 0.0625 nil)
schCreateWire(cv "route" "full" '((8.874 1.000) (8.874 1.750)) 0 0 0 nil nil)
schCreateWireLabel(cv nil '(8.874 1.250) "VIOL" "lowerLeft" "R90" "stick" 0.0625 nil)
schCreateWire(cv "route" "full" '((9.062 1.000) (9.062 1.750)) 0 0 0 nil nil)
schCreateWireLabel(cv nil '(9.062 1.250) "GIOL" "lowerLeft" "R90" "stick" 0.0625 nil)
schCreateWire(cv "route" "full" '((9.251 1.000) (9.251 1.750)) 0 0 0 nil nil)
schCreateWireLabel(cv nil '(9.251 1.250) "VIOH" "lowerLeft" "R90" "stick" 0.0625 nil)
schCreateWire(cv "route" "full" '((9.624 1.000) (9.624 1.750)) 0 0 0 nil nil)
schCreateWireLabel(cv nil '(9.624 1.250) "GIOH" "lowerLeft" "R90" "stick" 0.0625 nil)
pddw16sdgz_h_gMaster = dbOpenCellView("tphn28hpcpgv18" "PDDW16SDGZ_H_G" "symbol")
dbCreateInst(cv pddw16sdgz_h_gMaster "D3_right0" '(12.0 2.3125) "R90")
schCreateWire(cv "route" "full" '((11.000 2.438) (10.250 2.438)) 0 0 0 nil nil)
schCreateWireLabel(cv nil '(10.750 2.438) "VIOL" "lowerRight" "R0" "stick" 0.0625 nil)
schCreateWire(cv "route" "full" '((11.000 2.562) (10.250 2.562)) 0 0 0 nil nil)
dbCreateInst(cv noConnMaster "noConn_D3_right0_C" '(10.250 2.562) "R270")
schCreateWire(cv "route" "full" '((11.000 2.188) (10.250 2.188)) 0 0 0 nil nil)
schCreateWireLabel(cv nil '(10.750 2.188) "GIOL" "lowerRight" "R0" "stick" 0.0625 nil)
schCreateWire(cv "route" "full" '((11.000 2.062) (10.250 2.062)) 0 0 0 nil nil)
schCreateWireLabel(cv nil '(10.750 2.062) "D3_CORE" "lowerRight" "R0" "stick" 0.0625 nil)
schCreatePin(cv nil "D3_CORE" "inputOutput" nil '(10.250 2.062) "R0")
schCreateWire(cv "route" "full" '((12.000 3.000) (12.750 3.000)) 0 0 0 nil nil)
schCreateWireLabel(cv nil '(12.250 3.000) "D3" "lowerLeft" "R0" "stick" 0.0625 nil)
schCreatePin(cv nil "D3" "inputOutput" nil '(12.750 3.000) "R180")
schCreateWire(cv "route" "full" '((11.000 2.688) (10.250 2.688)) 0 0 0 nil nil)
schCreateWireLabel(cv nil '(10.750 2.688) "POC" "lowerRight" "R0" "stick" 0.0625 nil)
schCreateWire(cv "route" "full" '((11.000 2.875) (10.250 2.875)) 0 0 0 nil nil)
schCreateWireLabel(cv nil '(10.750 2.875) "VIOL" "lowerRight" "R0" "stick" 0.0625 nil)
schCreateWire(cv "route" "full" '((11.000 3.062) (10.250 3.062)) 0 0 0 nil nil)
schCreateWireLabel(cv nil '(10.750 3.062) "GIOL" "lowerRight" "R0" "stick" 0.0625 nil)
schCreateWire(cv "route" "full" '((11.000 3.250) (10.250 3.250)) 0 0 0 nil nil)
schCreateWireLabel(cv nil '(10.750 3.250) "VIOH" "lowerRight" "R0" "stick" 0.0625 nil)
schCreateWire(cv "route" "full" '((11.000 3.625) (10.250 3.625)) 0 0 0 nil nil)
schCreateWireLabel(cv nil '(10.750 3.625) "GIOH" "lowerRight" "R0" "stick" 0.0625 nil)
pvdd1dgz_h_gMaster = dbOpenCellView("tphn28hpcpgv18" "PVDD1DGZ_H_G" "symbol")
dbCreateInst(cv pvdd1dgz_h_gMaster "VIOL_right1" '(12.0 4.0) "R90")
schCreateWire(cv "route" "full" '((11.000 4.375) (10.250 4.375)) 0 0 0 nil nil)
schCreateWireLabel(cv nil '(10.750 4.375) "POC" "lowerRight" "R0" "stick" 0.0625 nil)
schCreateWire(cv "route" "full" '((12.000 5.000) (12.750 5.000)) 0 0 0 nil nil)
schCreateWireLabel(cv nil '(12.250 5.000) "VIOL" "lowerLeft" "R0" "stick" 0.0625 nil)
schCreatePin(cv nil "VIOL" "inputOutput" nil '(12.750 5.000) "R180")
schCreateWire(cv "route" "full" '((11.000 4.750) (10.250 4.750)) 0 0 0 nil nil)
schCreateWireLabel(cv nil '(10.750 4.750) "GIOL" "lowerRight" "R0" "stick" 0.0625 nil)
schCreateWire(cv "route" "full" '((11.000 4.938) (10.250 4.938)) 0 0 0 nil nil)
schCreateWireLabel(cv nil '(10.750 4.938) "VIOH" "lowerRight" "R0" "stick" 0.0625 nil)
schCreateWire(cv "route" "full" '((11.000 5.312) (10.250 5.312)) 0 0 0 nil nil)
schCreateWireLabel(cv nil '(10.750 5.312) "GIOH" "lowerRight" "R0" "stick" 0.0625 nil)
pvss1dgz_h_gMaster = dbOpenCellView("tphn28hpcpgv18" "PVSS1DGZ_H_G" "symbol")
dbCreateInst(cv pvss1dgz_h_gMaster "GIOL_right2" '(12.0 6.0) "R90")
schCreateWire(cv "route" "full" '((11.000 6.375) (10.250 6.375)) 0 0 0 nil nil)
schCreateWireLabel(cv nil '(10.750 6.375) "POC" "lowerRight" "R0" "stick" 0.0625 nil)
schCreateWire(cv "route" "full" '((11.000 6.562) (10.250 6.562)) 0 0 0 nil nil)
schCreateWireLabel(cv nil '(10.750 6.562) "VIOL" "lowerRight" "R0" "stick" 0.0625 nil)
schCreateWire(cv "route" "full" '((12.000 7.000) (12.750 7.000)) 0 0 0 nil nil)
schCreateWireLabel(cv nil '(12.250 7.000) "GIOL" "lowerLeft" "R0" "stick" 0.0625 nil)
schCreatePin(cv nil "GIOL" "inputOutput" nil '(12.750 7.000) "R180")
schCreateWire(cv "route" "full" '((11.000 6.938) (10.250 6.938)) 0 0 0 nil nil)
schCreateWireLabel(cv nil '(10.750 6.938) "VIOH" "lowerRight" "R0" "stick" 0.0625 nil)
schCreateWire(cv "route" "full" '((11.000 7.312) (10.250 7.312)) 0 0 0 nil nil)
schCreateWireLabel(cv nil '(10.750 7.312) "GIOH" "lowerRight" "R0" "stick" 0.0625 nil)
pvdd2poc_h_gMaster = dbOpenCellView("tphn28hpcpgv18" "PVDD2POC_H_G" "symbol")
dbCreateInst(cv pvdd2poc_h_gMaster "VIOH_right3" '(12.0 8.0) "R90")
schCreateWire(cv "route" "full" '((11.000 8.375) (10.250 8.375)) 0 0 0 nil nil)
schCreateWireLabel(cv nil '(10.750 8.375) "POC" "lowerRight" "R0" "stick" 0.0625 nil)
schCreateWire(cv "route" "full" '((11.000 8.562) (10.250 8.562)) 0 0 0 nil nil)
schCreateWireLabel(cv nil '(10.750 8.562) "VIOL" "lowerRight" "R0" "stick" 0.0625 nil)
schCreateWire(cv "route" "full" '((11.000 8.750) (10.250 8.750)) 0 0 0 nil nil)
schCreateWireLabel(cv nil '(10.750 8.750) "GIOL" "lowerRight" "R0" "stick" 0.0625 nil)
schCreateWire(cv "route" "full" '((12.000 9.000) (12.750 9.000)) 0 0 0 nil nil)
schCreateWireLabel(cv nil '(12.250 9.000) "VIOH" "lowerLeft" "R0" "stick" 0.0625 nil)
schCreatePin(cv nil "VIOH" "inputOutput" nil '(12.750 9.000) "R180")
schCreateWire(cv "route" "full" '((11.000 9.312) (10.250 9.312)) 0 0 0 nil nil)
schCreateWireLabel(cv nil '(10.750 9.312) "GIOH" "lowerRight" "R0" "stick" 0.0625 nil)
pvss2dgz_v_gMaster = dbOpenCellView("tphn28hpcpgv18" "PVSS2DGZ_V_G" "symbol")
dbCreateInst(cv pvss2dgz_v_gMaster "GIOH_top0" '(10.0 12.0) "R180")
schCreateWire(cv "route" "full" '((9.625 11.000) (9.625 10.250)) 0 0 0 nil nil)
schCreateWireLabel(cv nil '(9.625 10.750) "POC" "lowerRight" "R90" "stick" 0.0625 nil)
schCreateWire(cv "route" "full" '((9.438 11.000) (9.438 10.250)) 0 0 0 nil nil)
schCreateWireLabel(cv nil '(9.438 10.750) "VIOL" "lowerRight" "R90" "stick" 0.0625 nil)
schCreateWire(cv "route" "full" '((9.250 11.000) (9.250 10.250)) 0 0 0 nil nil)
schCreateWireLabel(cv nil '(9.250 10.750) "GIOL" "lowerRight" "R90" "stick" 0.0625 nil)
schCreateWire(cv "route" "full" '((9.062 11.000) (9.062 10.250)) 0 0 0 nil nil)
schCreateWireLabel(cv nil '(9.062 10.750) "VIOH" "lowerRight" "R90" "stick" 0.0625 nil)
schCreateWire(cv "route" "full" '((9.000 12.000) (9.000 12.750)) 0 0 0 nil nil)
schCreateWireLabel(cv nil '(9.000 12.250) "GIOH" "lowerLeft" "R90" "stick" 0.0625 nil)
schCreatePin(cv nil "GIOH" "inputOutput" nil '(9.000 12.750) "R270")
dbCreateInst(cv pddw16sdgz_v_gMaster "RSTN_top1" '(7.6875 12.0) "R180")
schCreateWire(cv "route" "full" '((7.562 11.000) (7.562 10.250)) 0 0 0 nil nil)
schCreateWireLabel(cv nil '(7.562 10.750) "GIOL" "lowerRight" "R90" "stick" 0.0625 nil)
schCreateWire(cv "route" "full" '((7.438 11.000) (7.438 10.250)) 0 0 0 nil nil)
schCreateWireLabel(cv nil '(7.438 10.750) "RSTN_CORE" "lowerRight" "R90" "stick" 0.0625 nil)
schCreatePin(cv nil "RSTN_CORE" "inputOutput" nil '(7.438 10.250) "R90")
schCreateWire(cv "route" "full" '((7.812 11.000) (7.812 10.250)) 0 0 0 nil nil)
schCreateWireLabel(cv nil '(7.812 10.750) "VIOL" "lowerRight" "R90" "stick" 0.0625 nil)
schCreateWire(cv "route" "full" '((7.938 11.000) (7.938 10.250)) 0 0 0 nil nil)
schCreateWireLabel(cv nil '(7.938 10.750) "GIOL" "lowerRight" "R90" "stick" 0.0625 nil)
schCreateWire(cv "route" "full" '((7.000 12.000) (7.000 12.750)) 0 0 0 nil nil)
schCreateWireLabel(cv nil '(7.000 12.250) "RSTN" "lowerLeft" "R90" "stick" 0.0625 nil)
schCreatePin(cv nil "RSTN" "inputOutput" nil '(7.000 12.750) "R270")
schCreateWire(cv "route" "full" '((7.312 11.000) (7.312 10.250)) 0 0 0 nil nil)
schCreateWireLabel(cv nil '(7.312 10.750) "POC" "lowerRight" "R90" "stick" 0.0625 nil)
schCreateWire(cv "route" "full" '((7.125 11.000) (7.125 10.250)) 0 0 0 nil nil)
schCreateWireLabel(cv nil '(7.125 10.750) "VIOL" "lowerRight" "R90" "stick" 0.0625 nil)
schCreateWire(cv "route" "full" '((6.938 11.000) (6.938 10.250)) 0 0 0 nil nil)
schCreateWireLabel(cv nil '(6.938 10.750) "GIOL" "lowerRight" "R90" "stick" 0.0625 nil)
schCreateWire(cv "route" "full" '((6.750 11.000) (6.750 10.250)) 0 0 0 nil nil)
schCreateWireLabel(cv nil '(6.750 10.750) "VIOH" "lowerRight" "R90" "stick" 0.0625 nil)
schCreateWire(cv "route" "full" '((6.375 11.000) (6.375 10.250)) 0 0 0 nil nil)
schCreateWireLabel(cv nil '(6.375 10.750) "GIOH" "lowerRight" "R90" "stick" 0.0625 nil)
dbCreateInst(cv pddw16sdgz_v_gMaster "SCK_top2" '(5.6875 12.0) "R180")
schCreateWire(cv "route" "full" '((5.562 11.000) (5.562 10.250)) 0 0 0 nil nil)
schCreateWireLabel(cv nil '(5.562 10.750) "GIOL" "lowerRight" "R90" "stick" 0.0625 nil)
schCreateWire(cv "route" "full" '((5.438 11.000) (5.438 10.250)) 0 0 0 nil nil)
schCreateWireLabel(cv nil '(5.438 10.750) "SCK_CORE" "lowerRight" "R90" "stick" 0.0625 nil)
schCreatePin(cv nil "SCK_CORE" "inputOutput" nil '(5.438 10.250) "R90")
schCreateWire(cv "route" "full" '((5.812 11.000) (5.812 10.250)) 0 0 0 nil nil)
schCreateWireLabel(cv nil '(5.812 10.750) "VIOL" "lowerRight" "R90" "stick" 0.0625 nil)
schCreateWire(cv "route" "full" '((5.938 11.000) (5.938 10.250)) 0 0 0 nil nil)
schCreateWireLabel(cv nil '(5.938 10.750) "GIOL" "lowerRight" "R90" "stick" 0.0625 nil)
schCreateWire(cv "route" "full" '((5.000 12.000) (5.000 12.750)) 0 0 0 nil nil)
schCreateWireLabel(cv nil '(5.000 12.250) "SCK" "lowerLeft" "R90" "stick" 0.0625 nil)
schCreatePin(cv nil "SCK" "inputOutput" nil '(5.000 12.750) "R270")
schCreateWire(cv "route" "full" '((5.312 11.000) (5.312 10.250)) 0 0 0 nil nil)
schCreateWireLabel(cv nil '(5.312 10.750) "POC" "lowerRight" "R90" "stick" 0.0625 nil)
schCreateWire(cv "route" "full" '((5.125 11.000) (5.125 10.250)) 0 0 0 nil nil)
schCreateWireLabel(cv nil '(5.125 10.750) "VIOL" "lowerRight" "R90" "stick" 0.0625 nil)
schCreateWire(cv "route" "full" '((4.938 11.000) (4.938 10.250)) 0 0 0 nil nil)
schCreateWireLabel(cv nil '(4.938 10.750) "GIOL" "lowerRight" "R90" "stick" 0.0625 nil)
schCreateWire(cv "route" "full" '((4.750 11.000) (4.750 10.250)) 0 0 0 nil nil)
schCreateWireLabel(cv nil '(4.750 10.750) "VIOH" "lowerRight" "R90" "stick" 0.0625 nil)
schCreateWire(cv "route" "full" '((4.375 11.000) (4.375 10.250)) 0 0 0 nil nil)
schCreateWireLabel(cv nil '(4.375 10.750) "GIOH" "lowerRight" "R90" "stick" 0.0625 nil)
dbCreateInst(cv pddw16sdgz_v_gMaster "SDI_top3" '(3.6875 12.0) "R180")
schCreateWire(cv "route" "full" '((3.562 11.000) (3.562 10.250)) 0 0 0 nil nil)
schCreateWireLabel(cv nil '(3.562 10.750) "GIOL" "lowerRight" "R90" "stick" 0.0625 nil)
schCreateWire(cv "route" "full" '((3.438 11.000) (3.438 10.250)) 0 0 0 nil nil)
schCreateWireLabel(cv nil '(3.438 10.750) "SDI_CORE" "lowerRight" "R90" "stick" 0.0625 nil)
schCreatePin(cv nil "SDI_CORE" "inputOutput" nil '(3.438 10.250) "R90")
schCreateWire(cv "route" "full" '((3.812 11.000) (3.812 10.250)) 0 0 0 nil nil)
schCreateWireLabel(cv nil '(3.812 10.750) "VIOL" "lowerRight" "R90" "stick" 0.0625 nil)
schCreateWire(cv "route" "full" '((3.938 11.000) (3.938 10.250)) 0 0 0 nil nil)
schCreateWireLabel(cv nil '(3.938 10.750) "GIOL" "lowerRight" "R90" "stick" 0.0625 nil)
schCreateWire(cv "route" "full" '((3.000 12.000) (3.000 12.750)) 0 0 0 nil nil)
schCreateWireLabel(cv nil '(3.000 12.250) "SDI" "lowerLeft" "R90" "stick" 0.0625 nil)
schCreatePin(cv nil "SDI" "inputOutput" nil '(3.000 12.750) "R270")
schCreateWire(cv "route" "full" '((3.312 11.000) (3.312 10.250)) 0 0 0 nil nil)
schCreateWireLabel(cv nil '(3.312 10.750) "POC" "lowerRight" "R90" "stick" 0.0625 nil)
schCreateWire(cv "route" "full" '((3.125 11.000) (3.125 10.250)) 0 0 0 nil nil)
schCreateWireLabel(cv nil '(3.125 10.750) "VIOL" "lowerRight" "R90" "stick" 0.0625 nil)
schCreateWire(cv "route" "full" '((2.938 11.000) (2.938 10.250)) 0 0 0 nil nil)
schCreateWireLabel(cv nil '(2.938 10.750) "GIOL" "lowerRight" "R90" "stick" 0.0625 nil)
schCreateWire(cv "route" "full" '((2.750 11.000) (2.750 10.250)) 0 0 0 nil nil)
schCreateWireLabel(cv nil '(2.750 10.750) "VIOH" "lowerRight" "R90" "stick" 0.0625 nil)
schCreateWire(cv "route" "full" '((2.375 11.000) (2.375 10.250)) 0 0 0 nil nil)
schCreateWireLabel(cv nil '(2.375 10.750) "GIOH" "lowerRight" "R90" "stick" 0.0625 nil)
schCheck(cv)
dbSave(cv)
t
