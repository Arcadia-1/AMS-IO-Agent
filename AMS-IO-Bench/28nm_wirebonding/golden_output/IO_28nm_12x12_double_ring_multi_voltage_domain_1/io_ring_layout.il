; Generated Layout Script with Dual Ring Support

; ==================== All Components (Sorted by Placement Order) ====================
dbCreateParamInstByMasterName(cv "tphn28hpcpgv18" "PDDW16SDGZ_H_G" "layout" "SDI_left_11" list(0 150) "R270")
dbCreateParamInstByMasterName(cv "PAD" "PAD60GU" "layout" "pad60gu_SDI_left_11" list(0 150) "R270")
dbCreateParamInstByMasterName(cv "tphn28hpcpgv18" "PDDW16SDGZ_H_G" "layout" "SCK_left_10" list(0 210) "R270")
dbCreateParamInstByMasterName(cv "PAD" "PAD60GU" "layout" "pad60gu_SCK_left_10" list(0 210) "R270")
dbCreateParamInstByMasterName(cv "tphn28hpcpgv18" "PDDW16SDGZ_H_G" "layout" "D9_left_9" list(0 270) "R270")
dbCreateParamInstByMasterName(cv "PAD" "PAD60GU" "layout" "pad60gu_D9_left_9" list(0 270) "R270")
dbCreateParamInstByMasterName(cv "tphn28hpcpgv18" "PDDW16SDGZ_H_G" "layout" "D8_left_8" list(0 330) "R270")
dbCreateParamInstByMasterName(cv "PAD" "PAD60GU" "layout" "pad60gu_D8_left_8" list(0 330) "R270")
dbCreateParamInstByMasterName(cv "tphn28hpcpgv18" "PDDW16SDGZ_H_G" "layout" "D7_left_7" list(0 390) "R270")
dbCreateParamInstByMasterName(cv "PAD" "PAD60GU" "layout" "pad60gu_D7_left_7" list(0 390) "R270")
dbCreateParamInstByMasterName(cv "tphn28hpcpgv18" "PDDW16SDGZ_H_G" "layout" "D6_left_6" list(0 450) "R270")
dbCreateParamInstByMasterName(cv "PAD" "PAD60GU" "layout" "pad60gu_D6_left_6" list(0 450) "R270")
dbCreateParamInstByMasterName(cv "tphn28hpcpgv18" "PDDW16SDGZ_H_G" "layout" "D5_left_5" list(0 510) "R270")
dbCreateParamInstByMasterName(cv "PAD" "PAD60GU" "layout" "pad60gu_D5_left_5" list(0 510) "R270")
dbCreateParamInstByMasterName(cv "tphn28hpcpgv18" "PDDW16SDGZ_H_G" "layout" "D4_left_4" list(0 570) "R270")
dbCreateParamInstByMasterName(cv "PAD" "PAD60GU" "layout" "pad60gu_D4_left_4" list(0 570) "R270")
dbCreateParamInstByMasterName(cv "tphn28hpcpgv18" "PDDW16SDGZ_H_G" "layout" "D3_left_3" list(0 630) "R270")
dbCreateParamInstByMasterName(cv "PAD" "PAD60GU" "layout" "pad60gu_D3_left_3" list(0 630) "R270")
dbCreateParamInstByMasterName(cv "tphn28hpcpgv18" "PDDW16SDGZ_H_G" "layout" "D2_left_2" list(0 690) "R270")
dbCreateParamInstByMasterName(cv "PAD" "PAD60GU" "layout" "pad60gu_D2_left_2" list(0 690) "R270")
dbCreateParamInstByMasterName(cv "tphn28hpcpgv18" "PDDW16SDGZ_H_G" "layout" "D1_left_1" list(0 750) "R270")
dbCreateParamInstByMasterName(cv "PAD" "PAD60GU" "layout" "pad60gu_D1_left_1" list(0 750) "R270")
dbCreateParamInstByMasterName(cv "tphn28hpcpgv18" "PDDW16SDGZ_H_G" "layout" "D0_left_0" list(0 810) "R270")
dbCreateParamInstByMasterName(cv "PAD" "PAD60GU" "layout" "pad60gu_D0_left_0" list(0 810) "R270")
dbCreateParamInstByMasterName(cv "tphn28hpcpgv18" "PCORNERA_G" "layout" "CORNER_TL_top_left" list(0 940) "R270")
dbCreateParamInstByMasterName(cv "tphn28hpcpgv18" "PVSS3AC_V_G" "layout" "AVSS_bottom_11" list(790 0) "R0")
dbCreateParamInstByMasterName(cv "PAD" "PAD60GU" "layout" "pad60gu_AVSS_bottom_11" list(790 0) "R0")
dbCreateParamInstByMasterName(cv "tphn28hpcpgv18" "PVDD3AC_V_G" "layout" "AVDD_bottom_10" list(730 0) "R0")
dbCreateParamInstByMasterName(cv "PAD" "PAD60GU" "layout" "pad60gu_AVDD_bottom_10" list(730 0) "R0")
dbCreateParamInstByMasterName(cv "tphn28hpcpgv18" "PDB3AC_V_G" "layout" "IBREF_bottom_9" list(670 0) "R0")
dbCreateParamInstByMasterName(cv "PAD" "PAD60GU" "layout" "pad60gu_IBREF_bottom_9" list(670 0) "R0")
dbCreateParamInstByMasterName(cv "tphn28hpcpgv18" "PDB3AC_V_G" "layout" "IBAMP_bottom_8" list(610 0) "R0")
dbCreateParamInstByMasterName(cv "PAD" "PAD60GU" "layout" "pad60gu_IBAMP_bottom_8" list(610 0) "R0")
dbCreateParamInstByMasterName(cv "tphn28hpcpgv18" "PDB3AC_V_G" "layout" "VCM_bottom_7" list(550 0) "R0")
dbCreateParamInstByMasterName(cv "PAD" "PAD60GU" "layout" "pad60gu_VCM_bottom_7" list(550 0) "R0")
dbCreateParamInstByMasterName(cv "tphn28hpcpgv18" "PVSS1DGZ_V_G" "layout" "GIOL_bottom_6" list(490 0) "R0")
dbCreateParamInstByMasterName(cv "PAD" "PAD60GU" "layout" "pad60gu_GIOL_bottom_6" list(490 0) "R0")
dbCreateParamInstByMasterName(cv "tphn28hpcpgv18" "PVDD1DGZ_V_G" "layout" "VIOL_bottom_5" list(430 0) "R0")
dbCreateParamInstByMasterName(cv "PAD" "PAD60GU" "layout" "pad60gu_VIOL_bottom_5" list(430 0) "R0")
dbCreateParamInstByMasterName(cv "tphn28hpcpgv18" "PVSS2DGZ_V_G" "layout" "GIOH_bottom_4" list(370 0) "R0")
dbCreateParamInstByMasterName(cv "PAD" "PAD60GU" "layout" "pad60gu_GIOH_bottom_4" list(370 0) "R0")
dbCreateParamInstByMasterName(cv "tphn28hpcpgv18" "PVDD2POC_V_G" "layout" "VIOH_bottom_3" list(310 0) "R0")
dbCreateParamInstByMasterName(cv "PAD" "PAD60GU" "layout" "pad60gu_VIOH_bottom_3" list(310 0) "R0")
dbCreateParamInstByMasterName(cv "tphn28hpcpgv18" "PDDW16SDGZ_V_G" "layout" "SYNC_bottom_2" list(250 0) "R0")
dbCreateParamInstByMasterName(cv "PAD" "PAD60GU" "layout" "pad60gu_SYNC_bottom_2" list(250 0) "R0")
dbCreateParamInstByMasterName(cv "tphn28hpcpgv18" "PDDW16SDGZ_V_G" "layout" "RST_bottom_1" list(190 0) "R0")
dbCreateParamInstByMasterName(cv "PAD" "PAD60GU" "layout" "pad60gu_RST_bottom_1" list(190 0) "R0")
dbCreateParamInstByMasterName(cv "tphn28hpcpgv18" "PDDW16SDGZ_V_G" "layout" "SDO_bottom_0" list(130 0) "R0")
dbCreateParamInstByMasterName(cv "PAD" "PAD60GU" "layout" "pad60gu_SDO_bottom_0" list(130 0) "R0")
dbCreateParamInstByMasterName(cv "tphn28hpcpgv18" "PCORNER_G" "layout" "CORNER_BL_bottom_left" list(0 0) "R0")
dbCreateParamInstByMasterName(cv "tphn28hpcpgv18" "PVSS3AC_H_G" "layout" "VSS_CKB_right_11" list(940 790) "R90")
dbCreateParamInstByMasterName(cv "PAD" "PAD60GU" "layout" "pad60gu_VSS_CKB_right_11" list(940 790) "R90")
dbCreateParamInstByMasterName(cv "tphn28hpcpgv18" "PVDD3AC_H_G" "layout" "VDD_CKB_right_10" list(940 730) "R90")
dbCreateParamInstByMasterName(cv "PAD" "PAD60GU" "layout" "pad60gu_VDD_CKB_right_10" list(940 730) "R90")
dbCreateParamInstByMasterName(cv "tphn28hpcpgv18" "PDB3AC_H_G" "layout" "IB8_right_9" list(940 670) "R90")
dbCreateParamInstByMasterName(cv "PAD" "PAD60GU" "layout" "pad60gu_IB8_right_9" list(940 670) "R90")
dbCreateParamInstByMasterName(cv "tphn28hpcpgv18" "PDB3AC_H_G" "layout" "IB7_right_8" list(940 610) "R90")
dbCreateParamInstByMasterName(cv "PAD" "PAD60GU" "layout" "pad60gu_IB7_right_8" list(940 610) "R90")
dbCreateParamInstByMasterName(cv "tphn28hpcpgv18" "PDB3AC_H_G" "layout" "IB6_right_7" list(940 550) "R90")
dbCreateParamInstByMasterName(cv "PAD" "PAD60GU" "layout" "pad60gu_IB6_right_7" list(940 550) "R90")
dbCreateParamInstByMasterName(cv "tphn28hpcpgv18" "PDB3AC_H_G" "layout" "IB5_right_6" list(940 490) "R90")
dbCreateParamInstByMasterName(cv "PAD" "PAD60GU" "layout" "pad60gu_IB5_right_6" list(940 490) "R90")
dbCreateParamInstByMasterName(cv "tphn28hpcpgv18" "PDB3AC_H_G" "layout" "IB4_right_5" list(940 430) "R90")
dbCreateParamInstByMasterName(cv "PAD" "PAD60GU" "layout" "pad60gu_IB4_right_5" list(940 430) "R90")
dbCreateParamInstByMasterName(cv "tphn28hpcpgv18" "PDB3AC_H_G" "layout" "IB3_right_4" list(940 370) "R90")
dbCreateParamInstByMasterName(cv "PAD" "PAD60GU" "layout" "pad60gu_IB3_right_4" list(940 370) "R90")
dbCreateParamInstByMasterName(cv "tphn28hpcpgv18" "PDB3AC_H_G" "layout" "IB2_right_3" list(940 310) "R90")
dbCreateParamInstByMasterName(cv "PAD" "PAD60GU" "layout" "pad60gu_IB2_right_3" list(940 310) "R90")
dbCreateParamInstByMasterName(cv "tphn28hpcpgv18" "PDB3AC_H_G" "layout" "IB1_right_2" list(940 250) "R90")
dbCreateParamInstByMasterName(cv "PAD" "PAD60GU" "layout" "pad60gu_IB1_right_2" list(940 250) "R90")
dbCreateParamInstByMasterName(cv "tphn28hpcpgv18" "PDB3AC_H_G" "layout" "VIP_right_1" list(940 190) "R90")
dbCreateParamInstByMasterName(cv "PAD" "PAD60GU" "layout" "pad60gu_VIP_right_1" list(940 190) "R90")
dbCreateParamInstByMasterName(cv "tphn28hpcpgv18" "PDB3AC_H_G" "layout" "VIN_right_0" list(940 130) "R90")
dbCreateParamInstByMasterName(cv "PAD" "PAD60GU" "layout" "pad60gu_VIN_right_0" list(940 130) "R90")
dbCreateParamInstByMasterName(cv "tphn28hpcpgv18" "PCORNERA_G" "layout" "CORNER_BR_bottom_right" list(940 0) "R90")
dbCreateParamInstByMasterName(cv "tphn28hpcpgv18" "PDB3AC_V_G" "layout" "IBIAS8_top_11" list(150 940) "R180")
dbCreateParamInstByMasterName(cv "PAD" "PAD60GU" "layout" "pad60gu_IBIAS8_top_11" list(150 940) "R180")
dbCreateParamInstByMasterName(cv "tphn28hpcpgv18" "PDB3AC_V_G" "layout" "IBIAS7_top_10" list(210 940) "R180")
dbCreateParamInstByMasterName(cv "PAD" "PAD60GU" "layout" "pad60gu_IBIAS7_top_10" list(210 940) "R180")
dbCreateParamInstByMasterName(cv "tphn28hpcpgv18" "PDB3AC_V_G" "layout" "IBIAS6_top_9" list(270 940) "R180")
dbCreateParamInstByMasterName(cv "PAD" "PAD60GU" "layout" "pad60gu_IBIAS6_top_9" list(270 940) "R180")
dbCreateParamInstByMasterName(cv "tphn28hpcpgv18" "PDB3AC_V_G" "layout" "IBIAS5_top_8" list(330 940) "R180")
dbCreateParamInstByMasterName(cv "PAD" "PAD60GU" "layout" "pad60gu_IBIAS5_top_8" list(330 940) "R180")
dbCreateParamInstByMasterName(cv "tphn28hpcpgv18" "PVSS3AC_V_G" "layout" "VSSSAR_top_7" list(390 940) "R180")
dbCreateParamInstByMasterName(cv "PAD" "PAD60GU" "layout" "pad60gu_VSSSAR_top_7" list(390 940) "R180")
dbCreateParamInstByMasterName(cv "tphn28hpcpgv18" "PVDD3AC_V_G" "layout" "VDDSAR_top_6" list(450 940) "R180")
dbCreateParamInstByMasterName(cv "PAD" "PAD60GU" "layout" "pad60gu_VDDSAR_top_6" list(450 940) "R180")
dbCreateParamInstByMasterName(cv "tphn28hpcpgv18" "PDB3AC_V_G" "layout" "IBIAS4_top_5" list(510 940) "R180")
dbCreateParamInstByMasterName(cv "PAD" "PAD60GU" "layout" "pad60gu_IBIAS4_top_5" list(510 940) "R180")
dbCreateParamInstByMasterName(cv "tphn28hpcpgv18" "PDB3AC_V_G" "layout" "IBIAS3_top_4" list(570 940) "R180")
dbCreateParamInstByMasterName(cv "PAD" "PAD60GU" "layout" "pad60gu_IBIAS3_top_4" list(570 940) "R180")
dbCreateParamInstByMasterName(cv "tphn28hpcpgv18" "PDB3AC_V_G" "layout" "IBIAS2_top_3" list(630 940) "R180")
dbCreateParamInstByMasterName(cv "PAD" "PAD60GU" "layout" "pad60gu_IBIAS2_top_3" list(630 940) "R180")
dbCreateParamInstByMasterName(cv "tphn28hpcpgv18" "PDB3AC_V_G" "layout" "IBIAS_top_2" list(690 940) "R180")
dbCreateParamInstByMasterName(cv "PAD" "PAD60GU" "layout" "pad60gu_IBIAS_top_2" list(690 940) "R180")
dbCreateParamInstByMasterName(cv "tphn28hpcpgv18" "PDB3AC_V_G" "layout" "CLKN_top_1" list(750 940) "R180")
dbCreateParamInstByMasterName(cv "PAD" "PAD60GU" "layout" "pad60gu_CLKN_top_1" list(750 940) "R180")
dbCreateParamInstByMasterName(cv "tphn28hpcpgv18" "PDB3AC_V_G" "layout" "CLKP_top_0" list(810 940) "R180")
dbCreateParamInstByMasterName(cv "PAD" "PAD60GU" "layout" "pad60gu_CLKP_top_0" list(810 940) "R180")
dbCreateParamInstByMasterName(cv "tphn28hpcpgv18" "PCORNERA_G" "layout" "CORNER_TR_top_right" list(940 940) "R180")

; ==================== Inner Ring Pads ====================
dbCreateParamInstByMasterName(cv "tphn28hpcpgv18" "PDDW16SDGZ_H_G" "layout" "inner_pad_D10_left_8_9" list(0 300) "R270")
dbCreateParamInstByMasterName(cv "PAD" "PAD60NU" "layout" "inner_pad60nu_D10_left_8_9" list(0 300) "R270")
dbCreateParamInstByMasterName(cv "tphn28hpcpgv18" "PDB3AC_V_G" "layout" "inner_pad_VCM2_bottom_7_8" list(580 0) "R0")
dbCreateParamInstByMasterName(cv "PAD" "PAD60NU" "layout" "inner_pad60nu_VCM2_bottom_7_8" list(580 0) "R0")

; ==================== Filler Components ====================
dbCreateParamInstByMasterName(cv "tphn28hpcpgv18" "PFILLER20A_G" "layout" "sep_bottom_right_corner" list(810 0) "R0")
dbCreateParamInstByMasterName(cv "tphn28hpcpgv18" "PFILLER20_G" "layout" "filler_bottom_left_corner" list(110 0) "R0")
dbCreateParamInstByMasterName(cv "tphn28hpcpgv18" "PFILLER20A_G" "layout" "filler_R0_1_1" list(770 0) "R0")
dbCreateParamInstByMasterName(cv "tphn28hpcpgv18" "PFILLER20A_G" "layout" "filler_R0_1_2" list(750 0) "R0")
dbCreateParamInstByMasterName(cv "tphn28hpcpgv18" "PFILLER20A_G" "layout" "filler_R0_2_1" list(710 0) "R0")
dbCreateParamInstByMasterName(cv "tphn28hpcpgv18" "PFILLER20A_G" "layout" "filler_R0_2_2" list(690 0) "R0")
dbCreateParamInstByMasterName(cv "tphn28hpcpgv18" "PFILLER20A_G" "layout" "filler_R0_3_1" list(650 0) "R0")
dbCreateParamInstByMasterName(cv "tphn28hpcpgv18" "PFILLER20A_G" "layout" "filler_R0_3_2" list(630 0) "R0")
dbCreateParamInstByMasterName(cv "tphn28hpcpgv18" "PFILLER10A_G" "layout" "filler_R0_4_1" list(600 0) "R0")
dbCreateParamInstByMasterName(cv "tphn28hpcpgv18" "PFILLER10A_G" "layout" "filler_R0_4_2" list(570 0) "R0")
dbCreateParamInstByMasterName(cv "tphn28hpcpgv18" "PRCUTA_G" "layout" "filler_R0_5_1" list(530 0) "R0")
dbCreateParamInstByMasterName(cv "tphn28hpcpgv18" "PRCUTA_G" "layout" "filler_R0_5_2" list(510 0) "R0")
dbCreateParamInstByMasterName(cv "tphn28hpcpgv18" "PFILLER20_G" "layout" "filler_R0_6_1" list(470 0) "R0")
dbCreateParamInstByMasterName(cv "tphn28hpcpgv18" "PFILLER20_G" "layout" "filler_R0_6_2" list(450 0) "R0")
dbCreateParamInstByMasterName(cv "tphn28hpcpgv18" "PFILLER20_G" "layout" "filler_R0_7_1" list(410 0) "R0")
dbCreateParamInstByMasterName(cv "tphn28hpcpgv18" "PFILLER20_G" "layout" "filler_R0_7_2" list(390 0) "R0")
dbCreateParamInstByMasterName(cv "tphn28hpcpgv18" "PFILLER20_G" "layout" "filler_R0_8_1" list(350 0) "R0")
dbCreateParamInstByMasterName(cv "tphn28hpcpgv18" "PFILLER20_G" "layout" "filler_R0_8_2" list(330 0) "R0")
dbCreateParamInstByMasterName(cv "tphn28hpcpgv18" "PFILLER20_G" "layout" "filler_R0_9_1" list(290 0) "R0")
dbCreateParamInstByMasterName(cv "tphn28hpcpgv18" "PFILLER20_G" "layout" "filler_R0_9_2" list(270 0) "R0")
dbCreateParamInstByMasterName(cv "tphn28hpcpgv18" "PFILLER20_G" "layout" "filler_R0_10_1" list(230 0) "R0")
dbCreateParamInstByMasterName(cv "tphn28hpcpgv18" "PFILLER20_G" "layout" "filler_R0_10_2" list(210 0) "R0")
dbCreateParamInstByMasterName(cv "tphn28hpcpgv18" "PFILLER20_G" "layout" "filler_R0_11_1" list(170 0) "R0")
dbCreateParamInstByMasterName(cv "tphn28hpcpgv18" "PFILLER20_G" "layout" "filler_R0_11_2" list(150 0) "R0")
dbCreateParamInstByMasterName(cv "tphn28hpcpgv18" "PFILLER20A_G" "layout" "filler_right_top_corner" list(940 810) "R90")
dbCreateParamInstByMasterName(cv "tphn28hpcpgv18" "PFILLER20A_G" "layout" "filler_right_bottom_corner" list(940 110) "R90")
dbCreateParamInstByMasterName(cv "tphn28hpcpgv18" "PFILLER20A_G" "layout" "filler_R90_1_1" list(940 770) "R90")
dbCreateParamInstByMasterName(cv "tphn28hpcpgv18" "PFILLER20A_G" "layout" "filler_R90_1_2" list(940 750) "R90")
dbCreateParamInstByMasterName(cv "tphn28hpcpgv18" "PRCUTA_G" "layout" "filler_R90_2_1" list(940 710) "R90")
dbCreateParamInstByMasterName(cv "tphn28hpcpgv18" "PRCUTA_G" "layout" "filler_R90_2_2" list(940 690) "R90")
dbCreateParamInstByMasterName(cv "tphn28hpcpgv18" "PFILLER20A_G" "layout" "filler_R90_3_1" list(940 650) "R90")
dbCreateParamInstByMasterName(cv "tphn28hpcpgv18" "PFILLER20A_G" "layout" "filler_R90_3_2" list(940 630) "R90")
dbCreateParamInstByMasterName(cv "tphn28hpcpgv18" "PFILLER20A_G" "layout" "filler_R90_4_1" list(940 590) "R90")
dbCreateParamInstByMasterName(cv "tphn28hpcpgv18" "PFILLER20A_G" "layout" "filler_R90_4_2" list(940 570) "R90")
dbCreateParamInstByMasterName(cv "tphn28hpcpgv18" "PFILLER20A_G" "layout" "filler_R90_5_1" list(940 530) "R90")
dbCreateParamInstByMasterName(cv "tphn28hpcpgv18" "PFILLER20A_G" "layout" "filler_R90_5_2" list(940 510) "R90")
dbCreateParamInstByMasterName(cv "tphn28hpcpgv18" "PFILLER20A_G" "layout" "filler_R90_6_1" list(940 470) "R90")
dbCreateParamInstByMasterName(cv "tphn28hpcpgv18" "PFILLER20A_G" "layout" "filler_R90_6_2" list(940 450) "R90")
dbCreateParamInstByMasterName(cv "tphn28hpcpgv18" "PFILLER20A_G" "layout" "filler_R90_7_1" list(940 410) "R90")
dbCreateParamInstByMasterName(cv "tphn28hpcpgv18" "PFILLER20A_G" "layout" "filler_R90_7_2" list(940 390) "R90")
dbCreateParamInstByMasterName(cv "tphn28hpcpgv18" "PFILLER20A_G" "layout" "filler_R90_8_1" list(940 350) "R90")
dbCreateParamInstByMasterName(cv "tphn28hpcpgv18" "PFILLER20A_G" "layout" "filler_R90_8_2" list(940 330) "R90")
dbCreateParamInstByMasterName(cv "tphn28hpcpgv18" "PFILLER20A_G" "layout" "filler_R90_9_1" list(940 290) "R90")
dbCreateParamInstByMasterName(cv "tphn28hpcpgv18" "PFILLER20A_G" "layout" "filler_R90_9_2" list(940 270) "R90")
dbCreateParamInstByMasterName(cv "tphn28hpcpgv18" "PFILLER20A_G" "layout" "filler_R90_10_1" list(940 230) "R90")
dbCreateParamInstByMasterName(cv "tphn28hpcpgv18" "PFILLER20A_G" "layout" "filler_R90_10_2" list(940 210) "R90")
dbCreateParamInstByMasterName(cv "tphn28hpcpgv18" "PFILLER20A_G" "layout" "filler_R90_11_1" list(940 170) "R90")
dbCreateParamInstByMasterName(cv "tphn28hpcpgv18" "PFILLER20A_G" "layout" "filler_R90_11_2" list(940 150) "R90")
dbCreateParamInstByMasterName(cv "tphn28hpcpgv18" "PRCUTA_G" "layout" "sep_top_left_corner" list(130 940) "R180")
dbCreateParamInstByMasterName(cv "tphn28hpcpgv18" "PFILLER20A_G" "layout" "filler_top_right_corner" list(830 940) "R180")
dbCreateParamInstByMasterName(cv "tphn28hpcpgv18" "PFILLER20A_G" "layout" "filler_R180_1_1" list(170 940) "R180")
dbCreateParamInstByMasterName(cv "tphn28hpcpgv18" "PFILLER20A_G" "layout" "filler_R180_1_2" list(190 940) "R180")
dbCreateParamInstByMasterName(cv "tphn28hpcpgv18" "PFILLER20A_G" "layout" "filler_R180_2_1" list(230 940) "R180")
dbCreateParamInstByMasterName(cv "tphn28hpcpgv18" "PFILLER20A_G" "layout" "filler_R180_2_2" list(250 940) "R180")
dbCreateParamInstByMasterName(cv "tphn28hpcpgv18" "PFILLER20A_G" "layout" "filler_R180_3_1" list(290 940) "R180")
dbCreateParamInstByMasterName(cv "tphn28hpcpgv18" "PFILLER20A_G" "layout" "filler_R180_3_2" list(310 940) "R180")
dbCreateParamInstByMasterName(cv "tphn28hpcpgv18" "PFILLER20A_G" "layout" "filler_R180_4_1" list(350 940) "R180")
dbCreateParamInstByMasterName(cv "tphn28hpcpgv18" "PFILLER20A_G" "layout" "filler_R180_4_2" list(370 940) "R180")
dbCreateParamInstByMasterName(cv "tphn28hpcpgv18" "PFILLER20A_G" "layout" "filler_R180_5_1" list(410 940) "R180")
dbCreateParamInstByMasterName(cv "tphn28hpcpgv18" "PFILLER20A_G" "layout" "filler_R180_5_2" list(430 940) "R180")
dbCreateParamInstByMasterName(cv "tphn28hpcpgv18" "PFILLER20A_G" "layout" "filler_R180_6_1" list(470 940) "R180")
dbCreateParamInstByMasterName(cv "tphn28hpcpgv18" "PFILLER20A_G" "layout" "filler_R180_6_2" list(490 940) "R180")
dbCreateParamInstByMasterName(cv "tphn28hpcpgv18" "PFILLER20A_G" "layout" "filler_R180_7_1" list(530 940) "R180")
dbCreateParamInstByMasterName(cv "tphn28hpcpgv18" "PFILLER20A_G" "layout" "filler_R180_7_2" list(550 940) "R180")
dbCreateParamInstByMasterName(cv "tphn28hpcpgv18" "PFILLER20A_G" "layout" "filler_R180_8_1" list(590 940) "R180")
dbCreateParamInstByMasterName(cv "tphn28hpcpgv18" "PFILLER20A_G" "layout" "filler_R180_8_2" list(610 940) "R180")
dbCreateParamInstByMasterName(cv "tphn28hpcpgv18" "PFILLER20A_G" "layout" "filler_R180_9_1" list(650 940) "R180")
dbCreateParamInstByMasterName(cv "tphn28hpcpgv18" "PFILLER20A_G" "layout" "filler_R180_9_2" list(670 940) "R180")
dbCreateParamInstByMasterName(cv "tphn28hpcpgv18" "PRCUTA_G" "layout" "filler_R180_10_1" list(710 940) "R180")
dbCreateParamInstByMasterName(cv "tphn28hpcpgv18" "PRCUTA_G" "layout" "filler_R180_10_2" list(730 940) "R180")
dbCreateParamInstByMasterName(cv "tphn28hpcpgv18" "PFILLER20A_G" "layout" "filler_R180_11_1" list(770 940) "R180")
dbCreateParamInstByMasterName(cv "tphn28hpcpgv18" "PFILLER20A_G" "layout" "filler_R180_11_2" list(790 940) "R180")
dbCreateParamInstByMasterName(cv "tphn28hpcpgv18" "PFILLER20_G" "layout" "filler_left_bottom_corner" list(0 130) "R270")
dbCreateParamInstByMasterName(cv "tphn28hpcpgv18" "PRCUTA_G" "layout" "sep_left_top_corner" list(0 830) "R270")
dbCreateParamInstByMasterName(cv "tphn28hpcpgv18" "PFILLER20_G" "layout" "filler_R270_1_1" list(0 170) "R270")
dbCreateParamInstByMasterName(cv "tphn28hpcpgv18" "PFILLER20_G" "layout" "filler_R270_1_2" list(0 190) "R270")
dbCreateParamInstByMasterName(cv "tphn28hpcpgv18" "PFILLER20_G" "layout" "filler_R270_2_1" list(0 230) "R270")
dbCreateParamInstByMasterName(cv "tphn28hpcpgv18" "PFILLER20_G" "layout" "filler_R270_2_2" list(0 250) "R270")
dbCreateParamInstByMasterName(cv "tphn28hpcpgv18" "PFILLER10_G" "layout" "filler_R270_3_1" list(0 280) "R270")
dbCreateParamInstByMasterName(cv "tphn28hpcpgv18" "PFILLER10_G" "layout" "filler_R270_3_2" list(0 310) "R270")
dbCreateParamInstByMasterName(cv "tphn28hpcpgv18" "PFILLER20_G" "layout" "filler_R270_4_1" list(0 350) "R270")
dbCreateParamInstByMasterName(cv "tphn28hpcpgv18" "PFILLER20_G" "layout" "filler_R270_4_2" list(0 370) "R270")
dbCreateParamInstByMasterName(cv "tphn28hpcpgv18" "PFILLER20_G" "layout" "filler_R270_5_1" list(0 410) "R270")
dbCreateParamInstByMasterName(cv "tphn28hpcpgv18" "PFILLER20_G" "layout" "filler_R270_5_2" list(0 430) "R270")
dbCreateParamInstByMasterName(cv "tphn28hpcpgv18" "PFILLER20_G" "layout" "filler_R270_6_1" list(0 470) "R270")
dbCreateParamInstByMasterName(cv "tphn28hpcpgv18" "PFILLER20_G" "layout" "filler_R270_6_2" list(0 490) "R270")
dbCreateParamInstByMasterName(cv "tphn28hpcpgv18" "PFILLER20_G" "layout" "filler_R270_7_1" list(0 530) "R270")
dbCreateParamInstByMasterName(cv "tphn28hpcpgv18" "PFILLER20_G" "layout" "filler_R270_7_2" list(0 550) "R270")
dbCreateParamInstByMasterName(cv "tphn28hpcpgv18" "PFILLER20_G" "layout" "filler_R270_8_1" list(0 590) "R270")
dbCreateParamInstByMasterName(cv "tphn28hpcpgv18" "PFILLER20_G" "layout" "filler_R270_8_2" list(0 610) "R270")
dbCreateParamInstByMasterName(cv "tphn28hpcpgv18" "PFILLER20_G" "layout" "filler_R270_9_1" list(0 650) "R270")
dbCreateParamInstByMasterName(cv "tphn28hpcpgv18" "PFILLER20_G" "layout" "filler_R270_9_2" list(0 670) "R270")
dbCreateParamInstByMasterName(cv "tphn28hpcpgv18" "PFILLER20_G" "layout" "filler_R270_10_1" list(0 710) "R270")
dbCreateParamInstByMasterName(cv "tphn28hpcpgv18" "PFILLER20_G" "layout" "filler_R270_10_2" list(0 730) "R270")
dbCreateParamInstByMasterName(cv "tphn28hpcpgv18" "PFILLER20_G" "layout" "filler_R270_11_1" list(0 770) "R270")
dbCreateParamInstByMasterName(cv "tphn28hpcpgv18" "PFILLER20_G" "layout" "filler_R270_11_2" list(0 790) "R270")

; ==================== Digital IO Features (with Inner Pad Support) ====================
dbCreatePath(cv list("M3" "drawing") list(list(130 110.5) list(510 110.5)) 0.2)
dbCreatePath(cv list("M3" "drawing") list(list(130 109.24) list(510 109.24)) 0.2)
dbCreatePath(cv list("M3" "drawing") list(list(110.5 130) list(110.5 810)) 0.2)
dbCreatePath(cv list("M3" "drawing") list(list(109.24 130) list(109.24 810)) 0.2)
dbCreatePath(cv list("M3" "drawing") list(list(130 110.5) list(110.5 110.5)) 0.2 "extendExtend")
dbCreatePath(cv list("M3" "drawing") list(list(110.5 110.5) list(110.5 130)) 0.2 "extendExtend")
dbCreatePath(cv list("M3" "drawing") list(list(130 109.24) list(109.24 109.24)) 0.2 "extendExtend")
dbCreatePath(cv list("M3" "drawing") list(list(109.24 109.24) list(109.24 130)) 0.2 "extendExtend")
dbCreatePath(cv list("M3" "drawing") list(list(432.345 110.12) list(432.345 110.5)) 0.2)
tech = techGetTechFile(cv)
viaParams = list(list("cutRows" 2) list("cutColumns" 4))
viaDefId = techFindViaDefByName(tech "M3_M2")
newVia = dbCreateVia(cv viaDefId list(432.345 110.12) "R0" viaParams)
dbCreatePath(cv list("M3" "drawing") list(list(492.39 110.12) list(492.39 109.24)) 0.2)
tech = techGetTechFile(cv)
viaParams = list(list("cutRows" 2) list("cutColumns" 4))
viaDefId = techFindViaDefByName(tech "M3_M2")
newVia = dbCreateVia(cv viaDefId list(492.39 110.12) "R0" viaParams)
dbCreatePath(cv list("M3" "drawing") list(list(109.875 799.8) list(110.5 799.8)) 0.26)
dbCreatePath(cv list("M3" "drawing") list(list(109.875 804.1) list(109.24 804.1)) 0.26)
dbCreateLabel(cv list("M4" "pin") list(109.875 808.275) "D0_CORE" "centerLeft" "R0" "roman" 2)
dbCreatePath(cv list("M3" "drawing") list(list(109.875 739.8) list(110.5 739.8)) 0.26)
dbCreatePath(cv list("M3" "drawing") list(list(109.875 744.1) list(109.24 744.1)) 0.26)
dbCreateLabel(cv list("M4" "pin") list(109.875 748.275) "D1_CORE" "centerLeft" "R0" "roman" 2)
dbCreatePath(cv list("M3" "drawing") list(list(109.875 679.8) list(110.5 679.8)) 0.26)
dbCreatePath(cv list("M3" "drawing") list(list(109.875 684.1) list(109.24 684.1)) 0.26)
dbCreateLabel(cv list("M4" "pin") list(109.875 688.275) "D2_CORE" "centerLeft" "R0" "roman" 2)
dbCreatePath(cv list("M3" "drawing") list(list(109.875 619.8) list(110.5 619.8)) 0.26)
dbCreatePath(cv list("M3" "drawing") list(list(109.875 624.1) list(109.24 624.1)) 0.26)
dbCreateLabel(cv list("M4" "pin") list(109.875 628.275) "D3_CORE" "centerLeft" "R0" "roman" 2)
dbCreatePath(cv list("M3" "drawing") list(list(109.875 559.8) list(110.5 559.8)) 0.26)
dbCreatePath(cv list("M3" "drawing") list(list(109.875 564.1) list(109.24 564.1)) 0.26)
dbCreateLabel(cv list("M4" "pin") list(109.875 568.275) "D4_CORE" "centerLeft" "R0" "roman" 2)
dbCreatePath(cv list("M3" "drawing") list(list(109.875 499.8) list(110.5 499.8)) 0.26)
dbCreatePath(cv list("M3" "drawing") list(list(109.875 504.1) list(109.24 504.1)) 0.26)
dbCreateLabel(cv list("M4" "pin") list(109.875 508.275) "D5_CORE" "centerLeft" "R0" "roman" 2)
dbCreatePath(cv list("M3" "drawing") list(list(109.875 439.8) list(110.5 439.8)) 0.26)
dbCreatePath(cv list("M3" "drawing") list(list(109.875 444.1) list(109.24 444.1)) 0.26)
dbCreateLabel(cv list("M4" "pin") list(109.875 448.275) "D6_CORE" "centerLeft" "R0" "roman" 2)
dbCreatePath(cv list("M3" "drawing") list(list(109.875 379.8) list(110.5 379.8)) 0.26)
dbCreatePath(cv list("M3" "drawing") list(list(109.875 384.1) list(109.24 384.1)) 0.26)
dbCreateLabel(cv list("M4" "pin") list(109.875 388.275) "D7_CORE" "centerLeft" "R0" "roman" 2)
dbCreatePath(cv list("M3" "drawing") list(list(109.875 319.8) list(110.5 319.8)) 0.26)
dbCreatePath(cv list("M3" "drawing") list(list(109.875 324.1) list(109.24 324.1)) 0.26)
dbCreateLabel(cv list("M4" "pin") list(109.875 328.275) "D8_CORE" "centerLeft" "R0" "roman" 2)
dbCreatePath(cv list("M3" "drawing") list(list(109.875 259.8) list(110.5 259.8)) 0.26)
dbCreatePath(cv list("M3" "drawing") list(list(109.875 264.1) list(109.24 264.1)) 0.26)
dbCreateLabel(cv list("M4" "pin") list(109.875 268.275) "D9_CORE" "centerLeft" "R0" "roman" 2)
dbCreatePath(cv list("M3" "drawing") list(list(109.875 199.8) list(109.24 199.8)) 0.26)
dbCreatePath(cv list("M3" "drawing") list(list(109.875 208.275) list(109.24 208.275)) 0.26)
dbCreatePath(cv list("M3" "drawing") list(list(109.875 204.1) list(110.5 204.1)) 0.26)
dbCreateLabel(cv list("M4" "pin") list(109.875 195.67) "SCK_CORE" "centerLeft" "R0" "roman" 2)
dbCreatePath(cv list("M3" "drawing") list(list(109.875 139.8) list(109.24 139.8)) 0.26)
dbCreatePath(cv list("M3" "drawing") list(list(109.875 148.275) list(109.24 148.275)) 0.26)
dbCreatePath(cv list("M3" "drawing") list(list(109.875 144.1) list(110.5 144.1)) 0.26)
dbCreateLabel(cv list("M4" "pin") list(109.875 135.67) "SDI_CORE" "centerLeft" "R0" "roman" 2)
dbCreatePath(cv list("M3" "drawing") list(list(140.2 109.875) list(140.2 110.5)) 0.26)
dbCreatePath(cv list("M3" "drawing") list(list(135.9 109.875) list(135.9 109.24)) 0.26)
dbCreateLabel(cv list("M4" "pin") list(131.725 109.875) "SDO_CORE" "centerLeft" "R90" "roman" 2)
dbCreatePath(cv list("M3" "drawing") list(list(200.2 109.875) list(200.2 109.24)) 0.26)
dbCreatePath(cv list("M3" "drawing") list(list(191.725 109.875) list(191.725 109.24)) 0.26)
dbCreatePath(cv list("M3" "drawing") list(list(195.9 109.875) list(195.9 110.5)) 0.26)
dbCreateLabel(cv list("M4" "pin") list(204.33 109.875) "RST_CORE" "centerLeft" "R90" "roman" 2)
dbCreatePath(cv list("M3" "drawing") list(list(260.2 109.875) list(260.2 109.24)) 0.26)
dbCreatePath(cv list("M3" "drawing") list(list(251.725 109.875) list(251.725 109.24)) 0.26)
dbCreatePath(cv list("M3" "drawing") list(list(255.9 109.875) list(255.9 110.5)) 0.26)
dbCreateLabel(cv list("M4" "pin") list(264.33 109.875) "SYNC_CORE" "centerLeft" "R90" "roman" 2)
dbCreatePath(cv list("M3" "drawing") list(list(109.875 289.8) list(110.5 289.8)) 0.26)
dbCreatePath(cv list("M3" "drawing") list(list(109.875 294.1) list(109.24 294.1)) 0.26)
dbCreateLabel(cv list("M4" "pin") list(109.875 298.275) "D10_CORE" "centerLeft" "R0" "roman" 2)

; ==================== Pin Labels (with Inner Pad Support) ====================
dbCreateLabel(cv list("AP" "pin") list(-11 800) "D0" "centerRight" "R0" "roman" 10)
dbCreateLabel(cv list("AP" "pin") list(-11 740) "D1" "centerRight" "R0" "roman" 10)
dbCreateLabel(cv list("AP" "pin") list(-11 680) "D2" "centerRight" "R0" "roman" 10)
dbCreateLabel(cv list("AP" "pin") list(-11 620) "D3" "centerRight" "R0" "roman" 10)
dbCreateLabel(cv list("AP" "pin") list(-11 560) "D4" "centerRight" "R0" "roman" 10)
dbCreateLabel(cv list("AP" "pin") list(-11 500) "D5" "centerRight" "R0" "roman" 10)
dbCreateLabel(cv list("AP" "pin") list(-11 440) "D6" "centerRight" "R0" "roman" 10)
dbCreateLabel(cv list("AP" "pin") list(-11 380) "D7" "centerRight" "R0" "roman" 10)
dbCreateLabel(cv list("AP" "pin") list(-11 320) "D8" "centerRight" "R0" "roman" 10)
dbCreateLabel(cv list("AP" "pin") list(-11 260) "D9" "centerRight" "R0" "roman" 10)
dbCreateLabel(cv list("AP" "pin") list(-11 200) "SCK" "centerRight" "R0" "roman" 10)
dbCreateLabel(cv list("AP" "pin") list(-11 140) "SDI" "centerRight" "R0" "roman" 10)
dbCreateLabel(cv list("AP" "pin") list(140 -11) "SDO" "centerRight" "R90" "roman" 10)
dbCreateLabel(cv list("AP" "pin") list(200 -11) "RST" "centerRight" "R90" "roman" 10)
dbCreateLabel(cv list("AP" "pin") list(260 -11) "SYNC" "centerRight" "R90" "roman" 10)
dbCreateLabel(cv list("AP" "pin") list(320 -11) "VIOH" "centerRight" "R90" "roman" 10)
dbCreateLabel(cv list("AP" "pin") list(380 -11) "GIOH" "centerRight" "R90" "roman" 10)
dbCreateLabel(cv list("AP" "pin") list(440 -11) "VIOL" "centerRight" "R90" "roman" 10)
dbCreateLabel(cv list("AP" "pin") list(500 -11) "GIOL" "centerRight" "R90" "roman" 10)
dbCreateLabel(cv list("AP" "pin") list(560 -11) "VCM" "centerRight" "R90" "roman" 10)
dbCreateLabel(cv list("AP" "pin") list(620 -11) "IBAMP" "centerRight" "R90" "roman" 10)
dbCreateLabel(cv list("AP" "pin") list(680 -11) "IBREF" "centerRight" "R90" "roman" 10)
dbCreateLabel(cv list("AP" "pin") list(740 -11) "AVDD" "centerRight" "R90" "roman" 10)
dbCreateLabel(cv list("M2" "pin") list(740 109.9) "AVDD_CORE" "centerLeft" "R90" "roman" 2)
dbCreateLabel(cv list("AP" "pin") list(800 -11) "AVSS" "centerRight" "R90" "roman" 10)
dbCreateLabel(cv list("M2" "pin") list(800 109.9) "AVSS_CORE" "centerLeft" "R90" "roman" 2)
dbCreateLabel(cv list("AP" "pin") list(951 140) "VIN" "centerLeft" "R0" "roman" 10)
dbCreateLabel(cv list("AP" "pin") list(951 200) "VIP" "centerLeft" "R0" "roman" 10)
dbCreateLabel(cv list("AP" "pin") list(951 260) "IB1" "centerLeft" "R0" "roman" 10)
dbCreateLabel(cv list("AP" "pin") list(951 320) "IB2" "centerLeft" "R0" "roman" 10)
dbCreateLabel(cv list("AP" "pin") list(951 380) "IB3" "centerLeft" "R0" "roman" 10)
dbCreateLabel(cv list("AP" "pin") list(951 440) "IB4" "centerLeft" "R0" "roman" 10)
dbCreateLabel(cv list("AP" "pin") list(951 500) "IB5" "centerLeft" "R0" "roman" 10)
dbCreateLabel(cv list("AP" "pin") list(951 560) "IB6" "centerLeft" "R0" "roman" 10)
dbCreateLabel(cv list("AP" "pin") list(951 620) "IB7" "centerLeft" "R0" "roman" 10)
dbCreateLabel(cv list("AP" "pin") list(951 680) "IB8" "centerLeft" "R0" "roman" 10)
dbCreateLabel(cv list("AP" "pin") list(951 740) "VDD_CKB" "centerLeft" "R0" "roman" 10)
dbCreateLabel(cv list("M2" "pin") list(830.1 740) "VDD_CKB_CORE" "centerRight" "R0" "roman" 2)
dbCreateLabel(cv list("AP" "pin") list(951 800) "VSS_CKB" "centerLeft" "R0" "roman" 10)
dbCreateLabel(cv list("M2" "pin") list(830.1 800) "VSS_CKB_CORE" "centerRight" "R0" "roman" 2)
dbCreateLabel(cv list("AP" "pin") list(800 951) "CLKP" "centerLeft" "R90" "roman" 10)
dbCreateLabel(cv list("AP" "pin") list(740 951) "CLKN" "centerLeft" "R90" "roman" 10)
dbCreateLabel(cv list("AP" "pin") list(680 951) "IBIAS" "centerLeft" "R90" "roman" 10)
dbCreateLabel(cv list("AP" "pin") list(620 951) "IBIAS2" "centerLeft" "R90" "roman" 10)
dbCreateLabel(cv list("AP" "pin") list(560 951) "IBIAS3" "centerLeft" "R90" "roman" 10)
dbCreateLabel(cv list("AP" "pin") list(500 951) "IBIAS4" "centerLeft" "R90" "roman" 10)
dbCreateLabel(cv list("AP" "pin") list(440 951) "VDDSAR" "centerLeft" "R90" "roman" 10)
dbCreateLabel(cv list("M2" "pin") list(440 830.1) "VDDSAR_CORE" "centerRight" "R90" "roman" 2)
dbCreateLabel(cv list("AP" "pin") list(380 951) "VSSSAR" "centerLeft" "R90" "roman" 10)
dbCreateLabel(cv list("M2" "pin") list(380 830.1) "VSSSAR_CORE" "centerRight" "R90" "roman" 2)
dbCreateLabel(cv list("AP" "pin") list(320 951) "IBIAS5" "centerLeft" "R90" "roman" 10)
dbCreateLabel(cv list("AP" "pin") list(260 951) "IBIAS6" "centerLeft" "R90" "roman" 10)
dbCreateLabel(cv list("AP" "pin") list(200 951) "IBIAS7" "centerLeft" "R90" "roman" 10)
dbCreateLabel(cv list("AP" "pin") list(140 951) "IBIAS8" "centerLeft" "R90" "roman" 10)
dbCreateLabel(cv list("AP" "pin") list(152 290) "D10" "centerLeft" "R0" "roman" 10)
dbCreateLabel(cv list("AP" "pin") list(590 152) "VCM2" "centerLeft" "R90" "roman" 10)

dbSave(cv)
t
