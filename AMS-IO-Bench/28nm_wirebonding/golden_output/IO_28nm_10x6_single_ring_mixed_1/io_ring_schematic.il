pddw16sdgz_h_gMaster = dbOpenCellView("tphn28hpcpgv18" "PDDW16SDGZ_H_G" "symbol")
dbCreateInst(cv pddw16sdgz_h_gMaster "D0_left0" '(0 21.6875) "R270")
schCreateWire(cv "route" "full" '((1.000 21.562) (1.750 21.562)) 0 0 0 nil nil)
schCreateWireLabel(cv nil '(1.250 21.562) "VIOL" "lowerLeft" "R0" "stick" 0.0625 nil)
noConnMaster = dbOpenCellView("basic" "noConn" "symbol")
schCreateWire(cv "route" "full" '((1.000 21.438) (1.750 21.438)) 0 0 0 nil nil)
dbCreateInst(cv noConnMaster "noConn_D0_left0_C" '(1.750 21.438) "R90")
schCreateWire(cv "route" "full" '((1.000 21.812) (1.750 21.812)) 0 0 0 nil nil)
schCreateWireLabel(cv nil '(1.250 21.812) "GIOL" "lowerLeft" "R0" "stick" 0.0625 nil)
schCreateWire(cv "route" "full" '((1.000 21.938) (1.750 21.938)) 0 0 0 nil nil)
schCreateWireLabel(cv nil '(1.250 21.938) "D0_CORE" "lowerLeft" "R0" "stick" 0.0625 nil)
schCreatePin(cv nil "D0_CORE" "inputOutput" nil '(1.750 21.938) "R180")
schCreateWire(cv "route" "full" '((0.000 21.000) (-0.750 21.000)) 0 0 0 nil nil)
schCreateWireLabel(cv nil '(-0.250 21.000) "D0" "lowerRight" "R0" "stick" 0.0625 nil)
schCreatePin(cv nil "D0" "inputOutput" nil '(-0.750 21.000) "R0")
schCreateWire(cv "route" "full" '((1.000 21.312) (1.750 21.312)) 0 0 0 nil nil)
schCreateWireLabel(cv nil '(1.250 21.312) "POC" "lowerLeft" "R0" "stick" 0.0625 nil)
schCreateWire(cv "route" "full" '((1.000 21.125) (1.750 21.125)) 0 0 0 nil nil)
schCreateWireLabel(cv nil '(1.250 21.125) "VIOL" "lowerLeft" "R0" "stick" 0.0625 nil)
schCreateWire(cv "route" "full" '((1.000 20.938) (1.750 20.938)) 0 0 0 nil nil)
schCreateWireLabel(cv nil '(1.250 20.938) "GIOL" "lowerLeft" "R0" "stick" 0.0625 nil)
schCreateWire(cv "route" "full" '((1.000 20.750) (1.750 20.750)) 0 0 0 nil nil)
schCreateWireLabel(cv nil '(1.250 20.750) "VIOH" "lowerLeft" "R0" "stick" 0.0625 nil)
schCreateWire(cv "route" "full" '((1.000 20.375) (1.750 20.375)) 0 0 0 nil nil)
schCreateWireLabel(cv nil '(1.250 20.375) "GIOH" "lowerLeft" "R0" "stick" 0.0625 nil)
dbCreateInst(cv pddw16sdgz_h_gMaster "D1_left1" '(0 19.6875) "R270")
schCreateWire(cv "route" "full" '((1.000 19.562) (1.750 19.562)) 0 0 0 nil nil)
schCreateWireLabel(cv nil '(1.250 19.562) "VIOL" "lowerLeft" "R0" "stick" 0.0625 nil)
schCreateWire(cv "route" "full" '((1.000 19.438) (1.750 19.438)) 0 0 0 nil nil)
dbCreateInst(cv noConnMaster "noConn_D1_left1_C" '(1.750 19.438) "R90")
schCreateWire(cv "route" "full" '((1.000 19.812) (1.750 19.812)) 0 0 0 nil nil)
schCreateWireLabel(cv nil '(1.250 19.812) "GIOL" "lowerLeft" "R0" "stick" 0.0625 nil)
schCreateWire(cv "route" "full" '((1.000 19.938) (1.750 19.938)) 0 0 0 nil nil)
schCreateWireLabel(cv nil '(1.250 19.938) "D1_CORE" "lowerLeft" "R0" "stick" 0.0625 nil)
schCreatePin(cv nil "D1_CORE" "inputOutput" nil '(1.750 19.938) "R180")
schCreateWire(cv "route" "full" '((0.000 19.000) (-0.750 19.000)) 0 0 0 nil nil)
schCreateWireLabel(cv nil '(-0.250 19.000) "D1" "lowerRight" "R0" "stick" 0.0625 nil)
schCreatePin(cv nil "D1" "inputOutput" nil '(-0.750 19.000) "R0")
schCreateWire(cv "route" "full" '((1.000 19.312) (1.750 19.312)) 0 0 0 nil nil)
schCreateWireLabel(cv nil '(1.250 19.312) "POC" "lowerLeft" "R0" "stick" 0.0625 nil)
schCreateWire(cv "route" "full" '((1.000 19.125) (1.750 19.125)) 0 0 0 nil nil)
schCreateWireLabel(cv nil '(1.250 19.125) "VIOL" "lowerLeft" "R0" "stick" 0.0625 nil)
schCreateWire(cv "route" "full" '((1.000 18.938) (1.750 18.938)) 0 0 0 nil nil)
schCreateWireLabel(cv nil '(1.250 18.938) "GIOL" "lowerLeft" "R0" "stick" 0.0625 nil)
schCreateWire(cv "route" "full" '((1.000 18.750) (1.750 18.750)) 0 0 0 nil nil)
schCreateWireLabel(cv nil '(1.250 18.750) "VIOH" "lowerLeft" "R0" "stick" 0.0625 nil)
schCreateWire(cv "route" "full" '((1.000 18.375) (1.750 18.375)) 0 0 0 nil nil)
schCreateWireLabel(cv nil '(1.250 18.375) "GIOH" "lowerLeft" "R0" "stick" 0.0625 nil)
dbCreateInst(cv pddw16sdgz_h_gMaster "D2_left2" '(0 17.6875) "R270")
schCreateWire(cv "route" "full" '((1.000 17.562) (1.750 17.562)) 0 0 0 nil nil)
schCreateWireLabel(cv nil '(1.250 17.562) "VIOL" "lowerLeft" "R0" "stick" 0.0625 nil)
schCreateWire(cv "route" "full" '((1.000 17.438) (1.750 17.438)) 0 0 0 nil nil)
dbCreateInst(cv noConnMaster "noConn_D2_left2_C" '(1.750 17.438) "R90")
schCreateWire(cv "route" "full" '((1.000 17.812) (1.750 17.812)) 0 0 0 nil nil)
schCreateWireLabel(cv nil '(1.250 17.812) "GIOL" "lowerLeft" "R0" "stick" 0.0625 nil)
schCreateWire(cv "route" "full" '((1.000 17.938) (1.750 17.938)) 0 0 0 nil nil)
schCreateWireLabel(cv nil '(1.250 17.938) "D2_CORE" "lowerLeft" "R0" "stick" 0.0625 nil)
schCreatePin(cv nil "D2_CORE" "inputOutput" nil '(1.750 17.938) "R180")
schCreateWire(cv "route" "full" '((0.000 17.000) (-0.750 17.000)) 0 0 0 nil nil)
schCreateWireLabel(cv nil '(-0.250 17.000) "D2" "lowerRight" "R0" "stick" 0.0625 nil)
schCreatePin(cv nil "D2" "inputOutput" nil '(-0.750 17.000) "R0")
schCreateWire(cv "route" "full" '((1.000 17.312) (1.750 17.312)) 0 0 0 nil nil)
schCreateWireLabel(cv nil '(1.250 17.312) "POC" "lowerLeft" "R0" "stick" 0.0625 nil)
schCreateWire(cv "route" "full" '((1.000 17.125) (1.750 17.125)) 0 0 0 nil nil)
schCreateWireLabel(cv nil '(1.250 17.125) "VIOL" "lowerLeft" "R0" "stick" 0.0625 nil)
schCreateWire(cv "route" "full" '((1.000 16.938) (1.750 16.938)) 0 0 0 nil nil)
schCreateWireLabel(cv nil '(1.250 16.938) "GIOL" "lowerLeft" "R0" "stick" 0.0625 nil)
schCreateWire(cv "route" "full" '((1.000 16.750) (1.750 16.750)) 0 0 0 nil nil)
schCreateWireLabel(cv nil '(1.250 16.750) "VIOH" "lowerLeft" "R0" "stick" 0.0625 nil)
schCreateWire(cv "route" "full" '((1.000 16.375) (1.750 16.375)) 0 0 0 nil nil)
schCreateWireLabel(cv nil '(1.250 16.375) "GIOH" "lowerLeft" "R0" "stick" 0.0625 nil)
dbCreateInst(cv pddw16sdgz_h_gMaster "D3_left3" '(0 15.6875) "R270")
schCreateWire(cv "route" "full" '((1.000 15.562) (1.750 15.562)) 0 0 0 nil nil)
schCreateWireLabel(cv nil '(1.250 15.562) "VIOL" "lowerLeft" "R0" "stick" 0.0625 nil)
schCreateWire(cv "route" "full" '((1.000 15.438) (1.750 15.438)) 0 0 0 nil nil)
dbCreateInst(cv noConnMaster "noConn_D3_left3_C" '(1.750 15.438) "R90")
schCreateWire(cv "route" "full" '((1.000 15.812) (1.750 15.812)) 0 0 0 nil nil)
schCreateWireLabel(cv nil '(1.250 15.812) "GIOL" "lowerLeft" "R0" "stick" 0.0625 nil)
schCreateWire(cv "route" "full" '((1.000 15.938) (1.750 15.938)) 0 0 0 nil nil)
schCreateWireLabel(cv nil '(1.250 15.938) "D3_CORE" "lowerLeft" "R0" "stick" 0.0625 nil)
schCreatePin(cv nil "D3_CORE" "inputOutput" nil '(1.750 15.938) "R180")
schCreateWire(cv "route" "full" '((0.000 14.999) (-0.750 14.999)) 0 0 0 nil nil)
schCreateWireLabel(cv nil '(-0.250 14.999) "D3" "lowerRight" "R0" "stick" 0.0625 nil)
schCreatePin(cv nil "D3" "inputOutput" nil '(-0.750 14.999) "R0")
schCreateWire(cv "route" "full" '((1.000 15.312) (1.750 15.312)) 0 0 0 nil nil)
schCreateWireLabel(cv nil '(1.250 15.312) "POC" "lowerLeft" "R0" "stick" 0.0625 nil)
schCreateWire(cv "route" "full" '((1.000 15.126) (1.750 15.126)) 0 0 0 nil nil)
schCreateWireLabel(cv nil '(1.250 15.126) "VIOL" "lowerLeft" "R0" "stick" 0.0625 nil)
schCreateWire(cv "route" "full" '((1.000 14.938) (1.750 14.938)) 0 0 0 nil nil)
schCreateWireLabel(cv nil '(1.250 14.938) "GIOL" "lowerLeft" "R0" "stick" 0.0625 nil)
schCreateWire(cv "route" "full" '((1.000 14.749) (1.750 14.749)) 0 0 0 nil nil)
schCreateWireLabel(cv nil '(1.250 14.749) "VIOH" "lowerLeft" "R0" "stick" 0.0625 nil)
schCreateWire(cv "route" "full" '((1.000 14.376) (1.750 14.376)) 0 0 0 nil nil)
schCreateWireLabel(cv nil '(1.250 14.376) "GIOH" "lowerLeft" "R0" "stick" 0.0625 nil)
dbCreateInst(cv pddw16sdgz_h_gMaster "D4_left4" '(0 13.6875) "R270")
schCreateWire(cv "route" "full" '((1.000 13.562) (1.750 13.562)) 0 0 0 nil nil)
schCreateWireLabel(cv nil '(1.250 13.562) "VIOL" "lowerLeft" "R0" "stick" 0.0625 nil)
schCreateWire(cv "route" "full" '((1.000 13.438) (1.750 13.438)) 0 0 0 nil nil)
dbCreateInst(cv noConnMaster "noConn_D4_left4_C" '(1.750 13.438) "R90")
schCreateWire(cv "route" "full" '((1.000 13.812) (1.750 13.812)) 0 0 0 nil nil)
schCreateWireLabel(cv nil '(1.250 13.812) "GIOL" "lowerLeft" "R0" "stick" 0.0625 nil)
schCreateWire(cv "route" "full" '((1.000 13.938) (1.750 13.938)) 0 0 0 nil nil)
schCreateWireLabel(cv nil '(1.250 13.938) "D4_CORE" "lowerLeft" "R0" "stick" 0.0625 nil)
schCreatePin(cv nil "D4_CORE" "inputOutput" nil '(1.750 13.938) "R180")
schCreateWire(cv "route" "full" '((0.000 12.999) (-0.750 12.999)) 0 0 0 nil nil)
schCreateWireLabel(cv nil '(-0.250 12.999) "D4" "lowerRight" "R0" "stick" 0.0625 nil)
schCreatePin(cv nil "D4" "inputOutput" nil '(-0.750 12.999) "R0")
schCreateWire(cv "route" "full" '((1.000 13.312) (1.750 13.312)) 0 0 0 nil nil)
schCreateWireLabel(cv nil '(1.250 13.312) "POC" "lowerLeft" "R0" "stick" 0.0625 nil)
schCreateWire(cv "route" "full" '((1.000 13.126) (1.750 13.126)) 0 0 0 nil nil)
schCreateWireLabel(cv nil '(1.250 13.126) "VIOL" "lowerLeft" "R0" "stick" 0.0625 nil)
schCreateWire(cv "route" "full" '((1.000 12.938) (1.750 12.938)) 0 0 0 nil nil)
schCreateWireLabel(cv nil '(1.250 12.938) "GIOL" "lowerLeft" "R0" "stick" 0.0625 nil)
schCreateWire(cv "route" "full" '((1.000 12.749) (1.750 12.749)) 0 0 0 nil nil)
schCreateWireLabel(cv nil '(1.250 12.749) "VIOH" "lowerLeft" "R0" "stick" 0.0625 nil)
schCreateWire(cv "route" "full" '((1.000 12.376) (1.750 12.376)) 0 0 0 nil nil)
schCreateWireLabel(cv nil '(1.250 12.376) "GIOH" "lowerLeft" "R0" "stick" 0.0625 nil)
dbCreateInst(cv pddw16sdgz_h_gMaster "D5_left5" '(0 11.6875) "R270")
schCreateWire(cv "route" "full" '((1.000 11.562) (1.750 11.562)) 0 0 0 nil nil)
schCreateWireLabel(cv nil '(1.250 11.562) "VIOL" "lowerLeft" "R0" "stick" 0.0625 nil)
schCreateWire(cv "route" "full" '((1.000 11.438) (1.750 11.438)) 0 0 0 nil nil)
dbCreateInst(cv noConnMaster "noConn_D5_left5_C" '(1.750 11.438) "R90")
schCreateWire(cv "route" "full" '((1.000 11.812) (1.750 11.812)) 0 0 0 nil nil)
schCreateWireLabel(cv nil '(1.250 11.812) "GIOL" "lowerLeft" "R0" "stick" 0.0625 nil)
schCreateWire(cv "route" "full" '((1.000 11.938) (1.750 11.938)) 0 0 0 nil nil)
schCreateWireLabel(cv nil '(1.250 11.938) "D5_CORE" "lowerLeft" "R0" "stick" 0.0625 nil)
schCreatePin(cv nil "D5_CORE" "inputOutput" nil '(1.750 11.938) "R180")
schCreateWire(cv "route" "full" '((0.000 10.999) (-0.750 10.999)) 0 0 0 nil nil)
schCreateWireLabel(cv nil '(-0.250 10.999) "D5" "lowerRight" "R0" "stick" 0.0625 nil)
schCreatePin(cv nil "D5" "inputOutput" nil '(-0.750 10.999) "R0")
schCreateWire(cv "route" "full" '((1.000 11.312) (1.750 11.312)) 0 0 0 nil nil)
schCreateWireLabel(cv nil '(1.250 11.312) "POC" "lowerLeft" "R0" "stick" 0.0625 nil)
schCreateWire(cv "route" "full" '((1.000 11.126) (1.750 11.126)) 0 0 0 nil nil)
schCreateWireLabel(cv nil '(1.250 11.126) "VIOL" "lowerLeft" "R0" "stick" 0.0625 nil)
schCreateWire(cv "route" "full" '((1.000 10.938) (1.750 10.938)) 0 0 0 nil nil)
schCreateWireLabel(cv nil '(1.250 10.938) "GIOL" "lowerLeft" "R0" "stick" 0.0625 nil)
schCreateWire(cv "route" "full" '((1.000 10.749) (1.750 10.749)) 0 0 0 nil nil)
schCreateWireLabel(cv nil '(1.250 10.749) "VIOH" "lowerLeft" "R0" "stick" 0.0625 nil)
schCreateWire(cv "route" "full" '((1.000 10.376) (1.750 10.376)) 0 0 0 nil nil)
schCreateWireLabel(cv nil '(1.250 10.376) "GIOH" "lowerLeft" "R0" "stick" 0.0625 nil)
dbCreateInst(cv pddw16sdgz_h_gMaster "D6_left6" '(0 9.6875) "R270")
schCreateWire(cv "route" "full" '((1.000 9.562) (1.750 9.562)) 0 0 0 nil nil)
schCreateWireLabel(cv nil '(1.250 9.562) "VIOL" "lowerLeft" "R0" "stick" 0.0625 nil)
schCreateWire(cv "route" "full" '((1.000 9.438) (1.750 9.438)) 0 0 0 nil nil)
dbCreateInst(cv noConnMaster "noConn_D6_left6_C" '(1.750 9.438) "R90")
schCreateWire(cv "route" "full" '((1.000 9.812) (1.750 9.812)) 0 0 0 nil nil)
schCreateWireLabel(cv nil '(1.250 9.812) "GIOL" "lowerLeft" "R0" "stick" 0.0625 nil)
schCreateWire(cv "route" "full" '((1.000 9.938) (1.750 9.938)) 0 0 0 nil nil)
schCreateWireLabel(cv nil '(1.250 9.938) "D6_CORE" "lowerLeft" "R0" "stick" 0.0625 nil)
schCreatePin(cv nil "D6_CORE" "inputOutput" nil '(1.750 9.938) "R180")
schCreateWire(cv "route" "full" '((0.000 8.999) (-0.750 8.999)) 0 0 0 nil nil)
schCreateWireLabel(cv nil '(-0.250 8.999) "D6" "lowerRight" "R0" "stick" 0.0625 nil)
schCreatePin(cv nil "D6" "inputOutput" nil '(-0.750 8.999) "R0")
schCreateWire(cv "route" "full" '((1.000 9.312) (1.750 9.312)) 0 0 0 nil nil)
schCreateWireLabel(cv nil '(1.250 9.312) "POC" "lowerLeft" "R0" "stick" 0.0625 nil)
schCreateWire(cv "route" "full" '((1.000 9.126) (1.750 9.126)) 0 0 0 nil nil)
schCreateWireLabel(cv nil '(1.250 9.126) "VIOL" "lowerLeft" "R0" "stick" 0.0625 nil)
schCreateWire(cv "route" "full" '((1.000 8.938) (1.750 8.938)) 0 0 0 nil nil)
schCreateWireLabel(cv nil '(1.250 8.938) "GIOL" "lowerLeft" "R0" "stick" 0.0625 nil)
schCreateWire(cv "route" "full" '((1.000 8.749) (1.750 8.749)) 0 0 0 nil nil)
schCreateWireLabel(cv nil '(1.250 8.749) "VIOH" "lowerLeft" "R0" "stick" 0.0625 nil)
schCreateWire(cv "route" "full" '((1.000 8.376) (1.750 8.376)) 0 0 0 nil nil)
schCreateWireLabel(cv nil '(1.250 8.376) "GIOH" "lowerLeft" "R0" "stick" 0.0625 nil)
dbCreateInst(cv pddw16sdgz_h_gMaster "D7_left7" '(0 7.6875) "R270")
schCreateWire(cv "route" "full" '((1.000 7.562) (1.750 7.562)) 0 0 0 nil nil)
schCreateWireLabel(cv nil '(1.250 7.562) "VIOL" "lowerLeft" "R0" "stick" 0.0625 nil)
schCreateWire(cv "route" "full" '((1.000 7.438) (1.750 7.438)) 0 0 0 nil nil)
dbCreateInst(cv noConnMaster "noConn_D7_left7_C" '(1.750 7.438) "R90")
schCreateWire(cv "route" "full" '((1.000 7.812) (1.750 7.812)) 0 0 0 nil nil)
schCreateWireLabel(cv nil '(1.250 7.812) "GIOL" "lowerLeft" "R0" "stick" 0.0625 nil)
schCreateWire(cv "route" "full" '((1.000 7.938) (1.750 7.938)) 0 0 0 nil nil)
schCreateWireLabel(cv nil '(1.250 7.938) "D7_CORE" "lowerLeft" "R0" "stick" 0.0625 nil)
schCreatePin(cv nil "D7_CORE" "inputOutput" nil '(1.750 7.938) "R180")
schCreateWire(cv "route" "full" '((0.000 7.000) (-0.750 7.000)) 0 0 0 nil nil)
schCreateWireLabel(cv nil '(-0.250 7.000) "D7" "lowerRight" "R0" "stick" 0.0625 nil)
schCreatePin(cv nil "D7" "inputOutput" nil '(-0.750 7.000) "R0")
schCreateWire(cv "route" "full" '((1.000 7.312) (1.750 7.312)) 0 0 0 nil nil)
schCreateWireLabel(cv nil '(1.250 7.312) "POC" "lowerLeft" "R0" "stick" 0.0625 nil)
schCreateWire(cv "route" "full" '((1.000 7.125) (1.750 7.125)) 0 0 0 nil nil)
schCreateWireLabel(cv nil '(1.250 7.125) "VIOL" "lowerLeft" "R0" "stick" 0.0625 nil)
schCreateWire(cv "route" "full" '((1.000 6.938) (1.750 6.938)) 0 0 0 nil nil)
schCreateWireLabel(cv nil '(1.250 6.938) "GIOL" "lowerLeft" "R0" "stick" 0.0625 nil)
schCreateWire(cv "route" "full" '((1.000 6.750) (1.750 6.750)) 0 0 0 nil nil)
schCreateWireLabel(cv nil '(1.250 6.750) "VIOH" "lowerLeft" "R0" "stick" 0.0625 nil)
schCreateWire(cv "route" "full" '((1.000 6.375) (1.750 6.375)) 0 0 0 nil nil)
schCreateWireLabel(cv nil '(1.250 6.375) "GIOH" "lowerLeft" "R0" "stick" 0.0625 nil)
dbCreateInst(cv pddw16sdgz_h_gMaster "D8_left8" '(0 5.6875) "R270")
schCreateWire(cv "route" "full" '((1.000 5.562) (1.750 5.562)) 0 0 0 nil nil)
schCreateWireLabel(cv nil '(1.250 5.562) "VIOL" "lowerLeft" "R0" "stick" 0.0625 nil)
schCreateWire(cv "route" "full" '((1.000 5.438) (1.750 5.438)) 0 0 0 nil nil)
dbCreateInst(cv noConnMaster "noConn_D8_left8_C" '(1.750 5.438) "R90")
schCreateWire(cv "route" "full" '((1.000 5.812) (1.750 5.812)) 0 0 0 nil nil)
schCreateWireLabel(cv nil '(1.250 5.812) "GIOL" "lowerLeft" "R0" "stick" 0.0625 nil)
schCreateWire(cv "route" "full" '((1.000 5.938) (1.750 5.938)) 0 0 0 nil nil)
schCreateWireLabel(cv nil '(1.250 5.938) "D8_CORE" "lowerLeft" "R0" "stick" 0.0625 nil)
schCreatePin(cv nil "D8_CORE" "inputOutput" nil '(1.750 5.938) "R180")
schCreateWire(cv "route" "full" '((0.000 5.000) (-0.750 5.000)) 0 0 0 nil nil)
schCreateWireLabel(cv nil '(-0.250 5.000) "D8" "lowerRight" "R0" "stick" 0.0625 nil)
schCreatePin(cv nil "D8" "inputOutput" nil '(-0.750 5.000) "R0")
schCreateWire(cv "route" "full" '((1.000 5.312) (1.750 5.312)) 0 0 0 nil nil)
schCreateWireLabel(cv nil '(1.250 5.312) "POC" "lowerLeft" "R0" "stick" 0.0625 nil)
schCreateWire(cv "route" "full" '((1.000 5.125) (1.750 5.125)) 0 0 0 nil nil)
schCreateWireLabel(cv nil '(1.250 5.125) "VIOL" "lowerLeft" "R0" "stick" 0.0625 nil)
schCreateWire(cv "route" "full" '((1.000 4.938) (1.750 4.938)) 0 0 0 nil nil)
schCreateWireLabel(cv nil '(1.250 4.938) "GIOL" "lowerLeft" "R0" "stick" 0.0625 nil)
schCreateWire(cv "route" "full" '((1.000 4.750) (1.750 4.750)) 0 0 0 nil nil)
schCreateWireLabel(cv nil '(1.250 4.750) "VIOH" "lowerLeft" "R0" "stick" 0.0625 nil)
schCreateWire(cv "route" "full" '((1.000 4.375) (1.750 4.375)) 0 0 0 nil nil)
schCreateWireLabel(cv nil '(1.250 4.375) "GIOH" "lowerLeft" "R0" "stick" 0.0625 nil)
dbCreateInst(cv pddw16sdgz_h_gMaster "D9_left9" '(0 3.6875) "R270")
schCreateWire(cv "route" "full" '((1.000 3.562) (1.750 3.562)) 0 0 0 nil nil)
schCreateWireLabel(cv nil '(1.250 3.562) "VIOL" "lowerLeft" "R0" "stick" 0.0625 nil)
schCreateWire(cv "route" "full" '((1.000 3.438) (1.750 3.438)) 0 0 0 nil nil)
dbCreateInst(cv noConnMaster "noConn_D9_left9_C" '(1.750 3.438) "R90")
schCreateWire(cv "route" "full" '((1.000 3.812) (1.750 3.812)) 0 0 0 nil nil)
schCreateWireLabel(cv nil '(1.250 3.812) "GIOL" "lowerLeft" "R0" "stick" 0.0625 nil)
schCreateWire(cv "route" "full" '((1.000 3.938) (1.750 3.938)) 0 0 0 nil nil)
schCreateWireLabel(cv nil '(1.250 3.938) "D9_CORE" "lowerLeft" "R0" "stick" 0.0625 nil)
schCreatePin(cv nil "D9_CORE" "inputOutput" nil '(1.750 3.938) "R180")
schCreateWire(cv "route" "full" '((0.000 3.000) (-0.750 3.000)) 0 0 0 nil nil)
schCreateWireLabel(cv nil '(-0.250 3.000) "D9" "lowerRight" "R0" "stick" 0.0625 nil)
schCreatePin(cv nil "D9" "inputOutput" nil '(-0.750 3.000) "R0")
schCreateWire(cv "route" "full" '((1.000 3.312) (1.750 3.312)) 0 0 0 nil nil)
schCreateWireLabel(cv nil '(1.250 3.312) "POC" "lowerLeft" "R0" "stick" 0.0625 nil)
schCreateWire(cv "route" "full" '((1.000 3.125) (1.750 3.125)) 0 0 0 nil nil)
schCreateWireLabel(cv nil '(1.250 3.125) "VIOL" "lowerLeft" "R0" "stick" 0.0625 nil)
schCreateWire(cv "route" "full" '((1.000 2.938) (1.750 2.938)) 0 0 0 nil nil)
schCreateWireLabel(cv nil '(1.250 2.938) "GIOL" "lowerLeft" "R0" "stick" 0.0625 nil)
schCreateWire(cv "route" "full" '((1.000 2.750) (1.750 2.750)) 0 0 0 nil nil)
schCreateWireLabel(cv nil '(1.250 2.750) "VIOH" "lowerLeft" "R0" "stick" 0.0625 nil)
schCreateWire(cv "route" "full" '((1.000 2.375) (1.750 2.375)) 0 0 0 nil nil)
schCreateWireLabel(cv nil '(1.250 2.375) "GIOH" "lowerLeft" "R0" "stick" 0.0625 nil)
pddw16sdgz_v_gMaster = dbOpenCellView("tphn28hpcpgv18" "PDDW16SDGZ_V_G" "symbol")
dbCreateInst(cv pddw16sdgz_v_gMaster "SCK_bottom0" '(2.3125 0) "R0")
schCreateWire(cv "route" "full" '((2.438 1.000) (2.438 1.750)) 0 0 0 nil nil)
schCreateWireLabel(cv nil '(2.438 1.250) "GIOL" "lowerLeft" "R90" "stick" 0.0625 nil)
schCreateWire(cv "route" "full" '((2.562 1.000) (2.562 1.750)) 0 0 0 nil nil)
schCreateWireLabel(cv nil '(2.562 1.250) "SCK_CORE" "lowerLeft" "R90" "stick" 0.0625 nil)
schCreatePin(cv nil "SCK_CORE" "inputOutput" nil '(2.562 1.750) "R270")
schCreateWire(cv "route" "full" '((2.188 1.000) (2.188 1.750)) 0 0 0 nil nil)
schCreateWireLabel(cv nil '(2.188 1.250) "VIOL" "lowerLeft" "R90" "stick" 0.0625 nil)
schCreateWire(cv "route" "full" '((2.062 1.000) (2.062 1.750)) 0 0 0 nil nil)
schCreateWireLabel(cv nil '(2.062 1.250) "GIOL" "lowerLeft" "R90" "stick" 0.0625 nil)
schCreateWire(cv "route" "full" '((3.000 0.000) (3.000 -0.750)) 0 0 0 nil nil)
schCreateWireLabel(cv nil '(3.000 -0.250) "SCK" "lowerRight" "R90" "stick" 0.0625 nil)
schCreatePin(cv nil "SCK" "inputOutput" nil '(3.000 -0.750) "R90")
schCreateWire(cv "route" "full" '((2.688 1.000) (2.688 1.750)) 0 0 0 nil nil)
schCreateWireLabel(cv nil '(2.688 1.250) "POC" "lowerLeft" "R90" "stick" 0.0625 nil)
schCreateWire(cv "route" "full" '((2.875 1.000) (2.875 1.750)) 0 0 0 nil nil)
schCreateWireLabel(cv nil '(2.875 1.250) "VIOL" "lowerLeft" "R90" "stick" 0.0625 nil)
schCreateWire(cv "route" "full" '((3.062 1.000) (3.062 1.750)) 0 0 0 nil nil)
schCreateWireLabel(cv nil '(3.062 1.250) "GIOL" "lowerLeft" "R90" "stick" 0.0625 nil)
schCreateWire(cv "route" "full" '((3.250 1.000) (3.250 1.750)) 0 0 0 nil nil)
schCreateWireLabel(cv nil '(3.250 1.250) "VIOH" "lowerLeft" "R90" "stick" 0.0625 nil)
schCreateWire(cv "route" "full" '((3.625 1.000) (3.625 1.750)) 0 0 0 nil nil)
schCreateWireLabel(cv nil '(3.625 1.250) "GIOH" "lowerLeft" "R90" "stick" 0.0625 nil)
dbCreateInst(cv pddw16sdgz_v_gMaster "SDI_bottom1" '(4.3125 0) "R0")
schCreateWire(cv "route" "full" '((4.438 1.000) (4.438 1.750)) 0 0 0 nil nil)
schCreateWireLabel(cv nil '(4.438 1.250) "GIOL" "lowerLeft" "R90" "stick" 0.0625 nil)
schCreateWire(cv "route" "full" '((4.562 1.000) (4.562 1.750)) 0 0 0 nil nil)
schCreateWireLabel(cv nil '(4.562 1.250) "SDI_CORE" "lowerLeft" "R90" "stick" 0.0625 nil)
schCreatePin(cv nil "SDI_CORE" "inputOutput" nil '(4.562 1.750) "R270")
schCreateWire(cv "route" "full" '((4.188 1.000) (4.188 1.750)) 0 0 0 nil nil)
schCreateWireLabel(cv nil '(4.188 1.250) "VIOL" "lowerLeft" "R90" "stick" 0.0625 nil)
schCreateWire(cv "route" "full" '((4.062 1.000) (4.062 1.750)) 0 0 0 nil nil)
schCreateWireLabel(cv nil '(4.062 1.250) "GIOL" "lowerLeft" "R90" "stick" 0.0625 nil)
schCreateWire(cv "route" "full" '((5.000 0.000) (5.000 -0.750)) 0 0 0 nil nil)
schCreateWireLabel(cv nil '(5.000 -0.250) "SDI" "lowerRight" "R90" "stick" 0.0625 nil)
schCreatePin(cv nil "SDI" "inputOutput" nil '(5.000 -0.750) "R90")
schCreateWire(cv "route" "full" '((4.688 1.000) (4.688 1.750)) 0 0 0 nil nil)
schCreateWireLabel(cv nil '(4.688 1.250) "POC" "lowerLeft" "R90" "stick" 0.0625 nil)
schCreateWire(cv "route" "full" '((4.875 1.000) (4.875 1.750)) 0 0 0 nil nil)
schCreateWireLabel(cv nil '(4.875 1.250) "VIOL" "lowerLeft" "R90" "stick" 0.0625 nil)
schCreateWire(cv "route" "full" '((5.062 1.000) (5.062 1.750)) 0 0 0 nil nil)
schCreateWireLabel(cv nil '(5.062 1.250) "GIOL" "lowerLeft" "R90" "stick" 0.0625 nil)
schCreateWire(cv "route" "full" '((5.250 1.000) (5.250 1.750)) 0 0 0 nil nil)
schCreateWireLabel(cv nil '(5.250 1.250) "VIOH" "lowerLeft" "R90" "stick" 0.0625 nil)
schCreateWire(cv "route" "full" '((5.625 1.000) (5.625 1.750)) 0 0 0 nil nil)
schCreateWireLabel(cv nil '(5.625 1.250) "GIOH" "lowerLeft" "R90" "stick" 0.0625 nil)
dbCreateInst(cv pddw16sdgz_v_gMaster "SDO_bottom2" '(6.3125 0) "R0")
schCreateWire(cv "route" "full" '((6.438 1.000) (6.438 1.750)) 0 0 0 nil nil)
schCreateWireLabel(cv nil '(6.438 1.250) "VIOL" "lowerLeft" "R90" "stick" 0.0625 nil)
schCreateWire(cv "route" "full" '((6.562 1.000) (6.562 1.750)) 0 0 0 nil nil)
dbCreateInst(cv noConnMaster "noConn_SDO_bottom2_C" '(6.562 1.750) "R180")
schCreateWire(cv "route" "full" '((6.188 1.000) (6.188 1.750)) 0 0 0 nil nil)
schCreateWireLabel(cv nil '(6.188 1.250) "GIOL" "lowerLeft" "R90" "stick" 0.0625 nil)
schCreateWire(cv "route" "full" '((6.062 1.000) (6.062 1.750)) 0 0 0 nil nil)
schCreateWireLabel(cv nil '(6.062 1.250) "SDO_CORE" "lowerLeft" "R90" "stick" 0.0625 nil)
schCreatePin(cv nil "SDO_CORE" "inputOutput" nil '(6.062 1.750) "R270")
schCreateWire(cv "route" "full" '((7.000 0.000) (7.000 -0.750)) 0 0 0 nil nil)
schCreateWireLabel(cv nil '(7.000 -0.250) "SDO" "lowerRight" "R90" "stick" 0.0625 nil)
schCreatePin(cv nil "SDO" "inputOutput" nil '(7.000 -0.750) "R90")
schCreateWire(cv "route" "full" '((6.688 1.000) (6.688 1.750)) 0 0 0 nil nil)
schCreateWireLabel(cv nil '(6.688 1.250) "POC" "lowerLeft" "R90" "stick" 0.0625 nil)
schCreateWire(cv "route" "full" '((6.875 1.000) (6.875 1.750)) 0 0 0 nil nil)
schCreateWireLabel(cv nil '(6.875 1.250) "VIOL" "lowerLeft" "R90" "stick" 0.0625 nil)
schCreateWire(cv "route" "full" '((7.062 1.000) (7.062 1.750)) 0 0 0 nil nil)
schCreateWireLabel(cv nil '(7.062 1.250) "GIOL" "lowerLeft" "R90" "stick" 0.0625 nil)
schCreateWire(cv "route" "full" '((7.250 1.000) (7.250 1.750)) 0 0 0 nil nil)
schCreateWireLabel(cv nil '(7.250 1.250) "VIOH" "lowerLeft" "R90" "stick" 0.0625 nil)
schCreateWire(cv "route" "full" '((7.625 1.000) (7.625 1.750)) 0 0 0 nil nil)
schCreateWireLabel(cv nil '(7.625 1.250) "GIOH" "lowerLeft" "R90" "stick" 0.0625 nil)
dbCreateInst(cv pddw16sdgz_v_gMaster "RST_bottom3" '(8.3125 0) "R0")
schCreateWire(cv "route" "full" '((8.438 1.000) (8.438 1.750)) 0 0 0 nil nil)
schCreateWireLabel(cv nil '(8.438 1.250) "GIOL" "lowerLeft" "R90" "stick" 0.0625 nil)
schCreateWire(cv "route" "full" '((8.562 1.000) (8.562 1.750)) 0 0 0 nil nil)
schCreateWireLabel(cv nil '(8.562 1.250) "RST_CORE" "lowerLeft" "R90" "stick" 0.0625 nil)
schCreatePin(cv nil "RST_CORE" "inputOutput" nil '(8.562 1.750) "R270")
schCreateWire(cv "route" "full" '((8.188 1.000) (8.188 1.750)) 0 0 0 nil nil)
schCreateWireLabel(cv nil '(8.188 1.250) "VIOL" "lowerLeft" "R90" "stick" 0.0625 nil)
schCreateWire(cv "route" "full" '((8.062 1.000) (8.062 1.750)) 0 0 0 nil nil)
schCreateWireLabel(cv nil '(8.062 1.250) "GIOL" "lowerLeft" "R90" "stick" 0.0625 nil)
schCreateWire(cv "route" "full" '((9.001 0.000) (9.001 -0.750)) 0 0 0 nil nil)
schCreateWireLabel(cv nil '(9.001 -0.250) "RST" "lowerRight" "R90" "stick" 0.0625 nil)
schCreatePin(cv nil "RST" "inputOutput" nil '(9.001 -0.750) "R90")
schCreateWire(cv "route" "full" '((8.688 1.000) (8.688 1.750)) 0 0 0 nil nil)
schCreateWireLabel(cv nil '(8.688 1.250) "POC" "lowerLeft" "R90" "stick" 0.0625 nil)
schCreateWire(cv "route" "full" '((8.874 1.000) (8.874 1.750)) 0 0 0 nil nil)
schCreateWireLabel(cv nil '(8.874 1.250) "VIOL" "lowerLeft" "R90" "stick" 0.0625 nil)
schCreateWire(cv "route" "full" '((9.062 1.000) (9.062 1.750)) 0 0 0 nil nil)
schCreateWireLabel(cv nil '(9.062 1.250) "GIOL" "lowerLeft" "R90" "stick" 0.0625 nil)
schCreateWire(cv "route" "full" '((9.251 1.000) (9.251 1.750)) 0 0 0 nil nil)
schCreateWireLabel(cv nil '(9.251 1.250) "VIOH" "lowerLeft" "R90" "stick" 0.0625 nil)
schCreateWire(cv "route" "full" '((9.624 1.000) (9.624 1.750)) 0 0 0 nil nil)
schCreateWireLabel(cv nil '(9.624 1.250) "GIOH" "lowerLeft" "R90" "stick" 0.0625 nil)
dbCreateInst(cv pddw16sdgz_v_gMaster "SYNC_bottom4" '(10.3125 0) "R0")
schCreateWire(cv "route" "full" '((10.438 1.000) (10.438 1.750)) 0 0 0 nil nil)
schCreateWireLabel(cv nil '(10.438 1.250) "GIOL" "lowerLeft" "R90" "stick" 0.0625 nil)
schCreateWire(cv "route" "full" '((10.562 1.000) (10.562 1.750)) 0 0 0 nil nil)
schCreateWireLabel(cv nil '(10.562 1.250) "SYNC_CORE" "lowerLeft" "R90" "stick" 0.0625 nil)
schCreatePin(cv nil "SYNC_CORE" "inputOutput" nil '(10.562 1.750) "R270")
schCreateWire(cv "route" "full" '((10.188 1.000) (10.188 1.750)) 0 0 0 nil nil)
schCreateWireLabel(cv nil '(10.188 1.250) "VIOL" "lowerLeft" "R90" "stick" 0.0625 nil)
schCreateWire(cv "route" "full" '((10.062 1.000) (10.062 1.750)) 0 0 0 nil nil)
schCreateWireLabel(cv nil '(10.062 1.250) "GIOL" "lowerLeft" "R90" "stick" 0.0625 nil)
schCreateWire(cv "route" "full" '((11.001 0.000) (11.001 -0.750)) 0 0 0 nil nil)
schCreateWireLabel(cv nil '(11.001 -0.250) "SYNC" "lowerRight" "R90" "stick" 0.0625 nil)
schCreatePin(cv nil "SYNC" "inputOutput" nil '(11.001 -0.750) "R90")
schCreateWire(cv "route" "full" '((10.688 1.000) (10.688 1.750)) 0 0 0 nil nil)
schCreateWireLabel(cv nil '(10.688 1.250) "POC" "lowerLeft" "R90" "stick" 0.0625 nil)
schCreateWire(cv "route" "full" '((10.874 1.000) (10.874 1.750)) 0 0 0 nil nil)
schCreateWireLabel(cv nil '(10.874 1.250) "VIOL" "lowerLeft" "R90" "stick" 0.0625 nil)
schCreateWire(cv "route" "full" '((11.062 1.000) (11.062 1.750)) 0 0 0 nil nil)
schCreateWireLabel(cv nil '(11.062 1.250) "GIOL" "lowerLeft" "R90" "stick" 0.0625 nil)
schCreateWire(cv "route" "full" '((11.251 1.000) (11.251 1.750)) 0 0 0 nil nil)
schCreateWireLabel(cv nil '(11.251 1.250) "VIOH" "lowerLeft" "R90" "stick" 0.0625 nil)
schCreateWire(cv "route" "full" '((11.624 1.000) (11.624 1.750)) 0 0 0 nil nil)
schCreateWireLabel(cv nil '(11.624 1.250) "GIOH" "lowerLeft" "R90" "stick" 0.0625 nil)
dbCreateInst(cv pddw16sdgz_v_gMaster "CLKO_bottom5" '(12.3125 0) "R0")
schCreateWire(cv "route" "full" '((12.438 1.000) (12.438 1.750)) 0 0 0 nil nil)
schCreateWireLabel(cv nil '(12.438 1.250) "VIOL" "lowerLeft" "R90" "stick" 0.0625 nil)
schCreateWire(cv "route" "full" '((12.562 1.000) (12.562 1.750)) 0 0 0 nil nil)
dbCreateInst(cv noConnMaster "noConn_CLKO_bottom5_C" '(12.562 1.750) "R180")
schCreateWire(cv "route" "full" '((12.188 1.000) (12.188 1.750)) 0 0 0 nil nil)
schCreateWireLabel(cv nil '(12.188 1.250) "GIOL" "lowerLeft" "R90" "stick" 0.0625 nil)
schCreateWire(cv "route" "full" '((12.062 1.000) (12.062 1.750)) 0 0 0 nil nil)
schCreateWireLabel(cv nil '(12.062 1.250) "CLKO_CORE" "lowerLeft" "R90" "stick" 0.0625 nil)
schCreatePin(cv nil "CLKO_CORE" "inputOutput" nil '(12.062 1.750) "R270")
schCreateWire(cv "route" "full" '((13.001 0.000) (13.001 -0.750)) 0 0 0 nil nil)
schCreateWireLabel(cv nil '(13.001 -0.250) "CLKO" "lowerRight" "R90" "stick" 0.0625 nil)
schCreatePin(cv nil "CLKO" "inputOutput" nil '(13.001 -0.750) "R90")
schCreateWire(cv "route" "full" '((12.688 1.000) (12.688 1.750)) 0 0 0 nil nil)
schCreateWireLabel(cv nil '(12.688 1.250) "POC" "lowerLeft" "R90" "stick" 0.0625 nil)
schCreateWire(cv "route" "full" '((12.874 1.000) (12.874 1.750)) 0 0 0 nil nil)
schCreateWireLabel(cv nil '(12.874 1.250) "VIOL" "lowerLeft" "R90" "stick" 0.0625 nil)
schCreateWire(cv "route" "full" '((13.062 1.000) (13.062 1.750)) 0 0 0 nil nil)
schCreateWireLabel(cv nil '(13.062 1.250) "GIOL" "lowerLeft" "R90" "stick" 0.0625 nil)
schCreateWire(cv "route" "full" '((13.251 1.000) (13.251 1.750)) 0 0 0 nil nil)
schCreateWireLabel(cv nil '(13.251 1.250) "VIOH" "lowerLeft" "R90" "stick" 0.0625 nil)
schCreateWire(cv "route" "full" '((13.624 1.000) (13.624 1.750)) 0 0 0 nil nil)
schCreateWireLabel(cv nil '(13.624 1.250) "GIOH" "lowerLeft" "R90" "stick" 0.0625 nil)
pvdd1dgz_h_gMaster = dbOpenCellView("tphn28hpcpgv18" "PVDD1DGZ_H_G" "symbol")
dbCreateInst(cv pvdd1dgz_h_gMaster "VIOL_right0" '(16.0 2.0) "R90")
schCreateWire(cv "route" "full" '((15.000 2.375) (14.250 2.375)) 0 0 0 nil nil)
schCreateWireLabel(cv nil '(14.750 2.375) "POC" "lowerRight" "R0" "stick" 0.0625 nil)
schCreateWire(cv "route" "full" '((16.000 3.000) (16.750 3.000)) 0 0 0 nil nil)
schCreateWireLabel(cv nil '(16.250 3.000) "VIOL" "lowerLeft" "R0" "stick" 0.0625 nil)
schCreatePin(cv nil "VIOL" "inputOutput" nil '(16.750 3.000) "R180")
schCreateWire(cv "route" "full" '((15.000 2.750) (14.250 2.750)) 0 0 0 nil nil)
schCreateWireLabel(cv nil '(14.750 2.750) "GIOL" "lowerRight" "R0" "stick" 0.0625 nil)
schCreateWire(cv "route" "full" '((15.000 2.938) (14.250 2.938)) 0 0 0 nil nil)
schCreateWireLabel(cv nil '(14.750 2.938) "VIOH" "lowerRight" "R0" "stick" 0.0625 nil)
schCreateWire(cv "route" "full" '((15.000 3.312) (14.250 3.312)) 0 0 0 nil nil)
schCreateWireLabel(cv nil '(14.750 3.312) "GIOH" "lowerRight" "R0" "stick" 0.0625 nil)
pvss1dgz_h_gMaster = dbOpenCellView("tphn28hpcpgv18" "PVSS1DGZ_H_G" "symbol")
dbCreateInst(cv pvss1dgz_h_gMaster "GIOL_right1" '(16.0 4.0) "R90")
schCreateWire(cv "route" "full" '((15.000 4.375) (14.250 4.375)) 0 0 0 nil nil)
schCreateWireLabel(cv nil '(14.750 4.375) "POC" "lowerRight" "R0" "stick" 0.0625 nil)
schCreateWire(cv "route" "full" '((15.000 4.562) (14.250 4.562)) 0 0 0 nil nil)
schCreateWireLabel(cv nil '(14.750 4.562) "VIOL" "lowerRight" "R0" "stick" 0.0625 nil)
schCreateWire(cv "route" "full" '((16.000 5.000) (16.750 5.000)) 0 0 0 nil nil)
schCreateWireLabel(cv nil '(16.250 5.000) "GIOL" "lowerLeft" "R0" "stick" 0.0625 nil)
schCreatePin(cv nil "GIOL" "inputOutput" nil '(16.750 5.000) "R180")
schCreateWire(cv "route" "full" '((15.000 4.938) (14.250 4.938)) 0 0 0 nil nil)
schCreateWireLabel(cv nil '(14.750 4.938) "VIOH" "lowerRight" "R0" "stick" 0.0625 nil)
schCreateWire(cv "route" "full" '((15.000 5.312) (14.250 5.312)) 0 0 0 nil nil)
schCreateWireLabel(cv nil '(14.750 5.312) "GIOH" "lowerRight" "R0" "stick" 0.0625 nil)
pvdd2poc_h_gMaster = dbOpenCellView("tphn28hpcpgv18" "PVDD2POC_H_G" "symbol")
dbCreateInst(cv pvdd2poc_h_gMaster "VIOH_right2" '(16.0 6.0) "R90")
schCreateWire(cv "route" "full" '((15.000 6.375) (14.250 6.375)) 0 0 0 nil nil)
schCreateWireLabel(cv nil '(14.750 6.375) "POC" "lowerRight" "R0" "stick" 0.0625 nil)
schCreateWire(cv "route" "full" '((15.000 6.562) (14.250 6.562)) 0 0 0 nil nil)
schCreateWireLabel(cv nil '(14.750 6.562) "VIOL" "lowerRight" "R0" "stick" 0.0625 nil)
schCreateWire(cv "route" "full" '((15.000 6.750) (14.250 6.750)) 0 0 0 nil nil)
schCreateWireLabel(cv nil '(14.750 6.750) "GIOL" "lowerRight" "R0" "stick" 0.0625 nil)
schCreateWire(cv "route" "full" '((16.000 7.000) (16.750 7.000)) 0 0 0 nil nil)
schCreateWireLabel(cv nil '(16.250 7.000) "VIOH" "lowerLeft" "R0" "stick" 0.0625 nil)
schCreatePin(cv nil "VIOH" "inputOutput" nil '(16.750 7.000) "R180")
schCreateWire(cv "route" "full" '((15.000 7.312) (14.250 7.312)) 0 0 0 nil nil)
schCreateWireLabel(cv nil '(14.750 7.312) "GIOH" "lowerRight" "R0" "stick" 0.0625 nil)
pvss2dgz_h_gMaster = dbOpenCellView("tphn28hpcpgv18" "PVSS2DGZ_H_G" "symbol")
dbCreateInst(cv pvss2dgz_h_gMaster "GIOH_right3" '(16.0 8.0) "R90")
schCreateWire(cv "route" "full" '((15.000 8.375) (14.250 8.375)) 0 0 0 nil nil)
schCreateWireLabel(cv nil '(14.750 8.375) "POC" "lowerRight" "R0" "stick" 0.0625 nil)
schCreateWire(cv "route" "full" '((15.000 8.562) (14.250 8.562)) 0 0 0 nil nil)
schCreateWireLabel(cv nil '(14.750 8.562) "VIOL" "lowerRight" "R0" "stick" 0.0625 nil)
schCreateWire(cv "route" "full" '((15.000 8.750) (14.250 8.750)) 0 0 0 nil nil)
schCreateWireLabel(cv nil '(14.750 8.750) "GIOL" "lowerRight" "R0" "stick" 0.0625 nil)
schCreateWire(cv "route" "full" '((15.000 8.938) (14.250 8.938)) 0 0 0 nil nil)
schCreateWireLabel(cv nil '(14.750 8.938) "VIOH" "lowerRight" "R0" "stick" 0.0625 nil)
schCreateWire(cv "route" "full" '((16.000 9.000) (16.750 9.000)) 0 0 0 nil nil)
schCreateWireLabel(cv nil '(16.250 9.000) "GIOH" "lowerLeft" "R0" "stick" 0.0625 nil)
schCreatePin(cv nil "GIOH" "inputOutput" nil '(16.750 9.000) "R180")
pdb3ac_h_gMaster = dbOpenCellView("tphn28hpcpgv18" "PDB3AC_H_G" "symbol")
dbCreateInst(cv pdb3ac_h_gMaster "VCM3_right4" '(16.0 11.1875) "R90")
schCreateWire(cv "route" "full" '((16.000 10.999) (16.750 10.999)) 0 0 0 nil nil)
schCreateWireLabel(cv nil '(16.250 10.999) "VCM3" "lowerLeft" "R0" "stick" 0.0625 nil)
schCreatePin(cv nil "VCM3" "inputOutput" nil '(16.750 10.999) "R180")
schCreateWire(cv "route" "full" '((15.125 10.938) (14.375 10.938)) 0 0 0 nil nil)
schCreateWireLabel(cv nil '(14.875 10.938) "AVSS" "lowerRight" "R0" "stick" 0.0625 nil)
schCreateWire(cv "route" "full" '((15.125 11.312) (14.375 11.312)) 0 0 0 nil nil)
schCreateWireLabel(cv nil '(14.875 11.312) "GIOL" "lowerRight" "R0" "stick" 0.0625 nil)
schCreateWire(cv "route" "full" '((15.125 10.562) (14.375 10.562)) 0 0 0 nil nil)
schCreateWireLabel(cv nil '(14.875 10.562) "AVDD" "lowerRight" "R0" "stick" 0.0625 nil)
dbCreateInst(cv pdb3ac_h_gMaster "VCM2_right5" '(16.0 13.1875) "R90")
schCreateWire(cv "route" "full" '((16.000 12.999) (16.750 12.999)) 0 0 0 nil nil)
schCreateWireLabel(cv nil '(16.250 12.999) "VCM2" "lowerLeft" "R0" "stick" 0.0625 nil)
schCreatePin(cv nil "VCM2" "inputOutput" nil '(16.750 12.999) "R180")
schCreateWire(cv "route" "full" '((15.125 12.938) (14.375 12.938)) 0 0 0 nil nil)
schCreateWireLabel(cv nil '(14.875 12.938) "AVSS" "lowerRight" "R0" "stick" 0.0625 nil)
schCreateWire(cv "route" "full" '((15.125 13.312) (14.375 13.312)) 0 0 0 nil nil)
schCreateWireLabel(cv nil '(14.875 13.312) "GIOL" "lowerRight" "R0" "stick" 0.0625 nil)
schCreateWire(cv "route" "full" '((15.125 12.562) (14.375 12.562)) 0 0 0 nil nil)
schCreateWireLabel(cv nil '(14.875 12.562) "AVDD" "lowerRight" "R0" "stick" 0.0625 nil)
dbCreateInst(cv pdb3ac_h_gMaster "VCM_right6" '(16.0 15.1875) "R90")
schCreateWire(cv "route" "full" '((16.000 14.999) (16.750 14.999)) 0 0 0 nil nil)
schCreateWireLabel(cv nil '(16.250 14.999) "VCM" "lowerLeft" "R0" "stick" 0.0625 nil)
schCreatePin(cv nil "VCM" "inputOutput" nil '(16.750 14.999) "R180")
schCreateWire(cv "route" "full" '((15.125 14.938) (14.375 14.938)) 0 0 0 nil nil)
schCreateWireLabel(cv nil '(14.875 14.938) "AVSS" "lowerRight" "R0" "stick" 0.0625 nil)
schCreateWire(cv "route" "full" '((15.125 15.312) (14.375 15.312)) 0 0 0 nil nil)
schCreateWireLabel(cv nil '(14.875 15.312) "GIOL" "lowerRight" "R0" "stick" 0.0625 nil)
schCreateWire(cv "route" "full" '((15.125 14.562) (14.375 14.562)) 0 0 0 nil nil)
schCreateWireLabel(cv nil '(14.875 14.562) "AVDD" "lowerRight" "R0" "stick" 0.0625 nil)
dbCreateInst(cv pdb3ac_h_gMaster "IBAMP_right7" '(16.0 17.1875) "R90")
schCreateWire(cv "route" "full" '((16.000 17.000) (16.750 17.000)) 0 0 0 nil nil)
schCreateWireLabel(cv nil '(16.250 17.000) "IBAMP" "lowerLeft" "R0" "stick" 0.0625 nil)
schCreatePin(cv nil "IBAMP" "inputOutput" nil '(16.750 17.000) "R180")
schCreateWire(cv "route" "full" '((15.125 16.938) (14.375 16.938)) 0 0 0 nil nil)
schCreateWireLabel(cv nil '(14.875 16.938) "AVSS" "lowerRight" "R0" "stick" 0.0625 nil)
schCreateWire(cv "route" "full" '((15.125 17.312) (14.375 17.312)) 0 0 0 nil nil)
schCreateWireLabel(cv nil '(14.875 17.312) "GIOL" "lowerRight" "R0" "stick" 0.0625 nil)
schCreateWire(cv "route" "full" '((15.125 16.562) (14.375 16.562)) 0 0 0 nil nil)
schCreateWireLabel(cv nil '(14.875 16.562) "AVDD" "lowerRight" "R0" "stick" 0.0625 nil)
dbCreateInst(cv pdb3ac_h_gMaster "IBREF_right8" '(16.0 19.1875) "R90")
schCreateWire(cv "route" "full" '((16.000 19.000) (16.750 19.000)) 0 0 0 nil nil)
schCreateWireLabel(cv nil '(16.250 19.000) "IBREF" "lowerLeft" "R0" "stick" 0.0625 nil)
schCreatePin(cv nil "IBREF" "inputOutput" nil '(16.750 19.000) "R180")
schCreateWire(cv "route" "full" '((15.125 18.938) (14.375 18.938)) 0 0 0 nil nil)
schCreateWireLabel(cv nil '(14.875 18.938) "AVSS" "lowerRight" "R0" "stick" 0.0625 nil)
schCreateWire(cv "route" "full" '((15.125 19.312) (14.375 19.312)) 0 0 0 nil nil)
schCreateWireLabel(cv nil '(14.875 19.312) "GIOL" "lowerRight" "R0" "stick" 0.0625 nil)
schCreateWire(cv "route" "full" '((15.125 18.562) (14.375 18.562)) 0 0 0 nil nil)
schCreateWireLabel(cv nil '(14.875 18.562) "AVDD" "lowerRight" "R0" "stick" 0.0625 nil)
pvdd3ac_h_gMaster = dbOpenCellView("tphn28hpcpgv18" "PVDD3AC_H_G" "symbol")
dbCreateInst(cv pvdd3ac_h_gMaster "AVDD_right9" '(16.0 21.1875) "R90")
schCreateWire(cv "route" "full" '((15.125 20.562) (14.375 20.562)) 0 0 0 nil nil)
schCreateWireLabel(cv nil '(14.875 20.562) "AVDD_CORE" "lowerRight" "R0" "stick" 0.0625 nil)
schCreatePin(cv nil "AVDD_CORE" "inputOutput" nil '(14.375 20.562) "R0")
schCreateWire(cv "route" "full" '((15.125 20.938) (14.375 20.938)) 0 0 0 nil nil)
schCreateWireLabel(cv nil '(14.875 20.938) "AVSS" "lowerRight" "R0" "stick" 0.0625 nil)
schCreateWire(cv "route" "full" '((15.125 21.312) (14.375 21.312)) 0 0 0 nil nil)
schCreateWireLabel(cv nil '(14.875 21.312) "GIOL" "lowerRight" "R0" "stick" 0.0625 nil)
schCreateWire(cv "route" "full" '((16.000 21.000) (16.750 21.000)) 0 0 0 nil nil)
schCreateWireLabel(cv nil '(16.250 21.000) "AVDD" "lowerLeft" "R0" "stick" 0.0625 nil)
schCreatePin(cv nil "AVDD" "inputOutput" nil '(16.750 21.000) "R180")
pvss3ac_v_gMaster = dbOpenCellView("tphn28hpcpgv18" "PVSS3AC_V_G" "symbol")
dbCreateInst(cv pvss3ac_v_gMaster "AVSS_top0" '(12.8125 24.0) "R180")
schCreateWire(cv "route" "full" '((13.001 24.000) (13.001 24.750)) 0 0 0 nil nil)
schCreateWireLabel(cv nil '(13.001 24.250) "AVSS" "lowerLeft" "R90" "stick" 0.0625 nil)
schCreatePin(cv nil "AVSS" "inputOutput" nil '(13.001 24.750) "R270")
schCreateWire(cv "route" "full" '((12.688 23.125) (12.688 22.375)) 0 0 0 nil nil)
schCreateWireLabel(cv nil '(12.688 22.875) "GIOL" "lowerRight" "R90" "stick" 0.0625 nil)
schCreateWire(cv "route" "full" '((13.438 23.125) (13.438 22.375)) 0 0 0 nil nil)
schCreateWireLabel(cv nil '(13.438 22.875) "AVSS_CORE" "lowerRight" "R90" "stick" 0.0625 nil)
schCreatePin(cv nil "AVSS_CORE" "inputOutput" nil '(13.438 22.375) "R90")
schCreateWire(cv "route" "full" '((13.062 23.125) (13.062 22.375)) 0 0 0 nil nil)
schCreateWireLabel(cv nil '(13.062 22.875) "AVDD" "lowerRight" "R90" "stick" 0.0625 nil)
pdb3ac_v_gMaster = dbOpenCellView("tphn28hpcpgv18" "PDB3AC_V_G" "symbol")
dbCreateInst(cv pdb3ac_v_gMaster "VIN_top1" '(10.8125 24.0) "R180")
schCreateWire(cv "route" "full" '((11.001 24.000) (11.001 24.750)) 0 0 0 nil nil)
schCreateWireLabel(cv nil '(11.001 24.250) "VIN" "lowerLeft" "R90" "stick" 0.0625 nil)
schCreatePin(cv nil "VIN" "inputOutput" nil '(11.001 24.750) "R270")
schCreateWire(cv "route" "full" '((11.062 23.125) (11.062 22.375)) 0 0 0 nil nil)
schCreateWireLabel(cv nil '(11.062 22.875) "AVSS" "lowerRight" "R90" "stick" 0.0625 nil)
schCreateWire(cv "route" "full" '((10.688 23.125) (10.688 22.375)) 0 0 0 nil nil)
schCreateWireLabel(cv nil '(10.688 22.875) "GIOL" "lowerRight" "R90" "stick" 0.0625 nil)
schCreateWire(cv "route" "full" '((11.438 23.125) (11.438 22.375)) 0 0 0 nil nil)
schCreateWireLabel(cv nil '(11.438 22.875) "AVDD" "lowerRight" "R90" "stick" 0.0625 nil)
dbCreateInst(cv pdb3ac_v_gMaster "VIP_top2" '(8.8125 24.0) "R180")
schCreateWire(cv "route" "full" '((9.001 24.000) (9.001 24.750)) 0 0 0 nil nil)
schCreateWireLabel(cv nil '(9.001 24.250) "VIP" "lowerLeft" "R90" "stick" 0.0625 nil)
schCreatePin(cv nil "VIP" "inputOutput" nil '(9.001 24.750) "R270")
schCreateWire(cv "route" "full" '((9.062 23.125) (9.062 22.375)) 0 0 0 nil nil)
schCreateWireLabel(cv nil '(9.062 22.875) "AVSS" "lowerRight" "R90" "stick" 0.0625 nil)
schCreateWire(cv "route" "full" '((8.688 23.125) (8.688 22.375)) 0 0 0 nil nil)
schCreateWireLabel(cv nil '(8.688 22.875) "GIOL" "lowerRight" "R90" "stick" 0.0625 nil)
schCreateWire(cv "route" "full" '((9.438 23.125) (9.438 22.375)) 0 0 0 nil nil)
schCreateWireLabel(cv nil '(9.438 22.875) "AVDD" "lowerRight" "R90" "stick" 0.0625 nil)
pvdd1ac_v_gMaster = dbOpenCellView("tphn28hpcpgv18" "PVDD1AC_V_G" "symbol")
dbCreateInst(cv pvdd1ac_v_gMaster "GND_top3" '(6.8125 24.0) "R180")
schCreateWire(cv "route" "full" '((7.062 23.125) (7.062 22.375)) 0 0 0 nil nil)
schCreateWireLabel(cv nil '(7.062 22.875) "AVSS" "lowerRight" "R90" "stick" 0.0625 nil)
schCreateWire(cv "route" "full" '((6.688 23.125) (6.688 22.375)) 0 0 0 nil nil)
schCreateWireLabel(cv nil '(6.688 22.875) "GIOL" "lowerRight" "R90" "stick" 0.0625 nil)
schCreateWire(cv "route" "full" '((7.000 24.000) (7.000 24.750)) 0 0 0 nil nil)
schCreateWireLabel(cv nil '(7.000 24.250) "GND" "lowerLeft" "R90" "stick" 0.0625 nil)
schCreatePin(cv nil "GND" "inputOutput" nil '(7.000 24.750) "R270")
schCreateWire(cv "route" "full" '((7.438 23.125) (7.438 22.375)) 0 0 0 nil nil)
schCreateWireLabel(cv nil '(7.438 22.875) "AVDD" "lowerRight" "R90" "stick" 0.0625 nil)
dbCreateInst(cv pvdd1ac_v_gMaster "VDDI_top4" '(4.8125 24.0) "R180")
schCreateWire(cv "route" "full" '((5.062 23.125) (5.062 22.375)) 0 0 0 nil nil)
schCreateWireLabel(cv nil '(5.062 22.875) "AVSS" "lowerRight" "R90" "stick" 0.0625 nil)
schCreateWire(cv "route" "full" '((4.688 23.125) (4.688 22.375)) 0 0 0 nil nil)
schCreateWireLabel(cv nil '(4.688 22.875) "GIOL" "lowerRight" "R90" "stick" 0.0625 nil)
schCreateWire(cv "route" "full" '((5.000 24.000) (5.000 24.750)) 0 0 0 nil nil)
schCreateWireLabel(cv nil '(5.000 24.250) "VDDI" "lowerLeft" "R90" "stick" 0.0625 nil)
schCreatePin(cv nil "VDDI" "inputOutput" nil '(5.000 24.750) "R270")
schCreateWire(cv "route" "full" '((5.438 23.125) (5.438 22.375)) 0 0 0 nil nil)
schCreateWireLabel(cv nil '(5.438 22.875) "AVDD" "lowerRight" "R90" "stick" 0.0625 nil)
pvss1ac_v_gMaster = dbOpenCellView("tphn28hpcpgv18" "PVSS1AC_V_G" "symbol")
dbCreateInst(cv pvss1ac_v_gMaster "VSSI_top5" '(2.8125 24.0) "R180")
schCreateWire(cv "route" "full" '((3.001 24.000) (3.001 24.750)) 0 0 0 nil nil)
schCreateWireLabel(cv nil '(3.001 24.250) "VSSI" "lowerLeft" "R90" "stick" 0.0625 nil)
schCreatePin(cv nil "VSSI" "inputOutput" nil '(3.001 24.750) "R270")
schCreateWire(cv "route" "full" '((3.062 23.125) (3.062 22.375)) 0 0 0 nil nil)
schCreateWireLabel(cv nil '(3.062 22.875) "AVSS" "lowerRight" "R90" "stick" 0.0625 nil)
schCreateWire(cv "route" "full" '((2.688 23.125) (2.688 22.375)) 0 0 0 nil nil)
schCreateWireLabel(cv nil '(2.688 22.875) "GIOL" "lowerRight" "R90" "stick" 0.0625 nil)
schCreateWire(cv "route" "full" '((3.438 23.125) (3.438 22.375)) 0 0 0 nil nil)
schCreateWireLabel(cv nil '(3.438 22.875) "AVDD" "lowerRight" "R90" "stick" 0.0625 nil)
schCheck(cv)
dbSave(cv)
t
