; Generated Layout Script with Dual Ring Support

; ==================== All Components (Sorted by Placement Order) ====================
dbCreateParamInstByMasterName(cv "tphn28hpcpgv18" "PDDW16SDGZ_H_G" "layout" "D5_left_5" list(0 150) "R270")
dbCreateParamInstByMasterName(cv "PAD" "PAD60GU" "layout" "pad60gu_D5_left_5" list(0 150) "R270")
dbCreateParamInstByMasterName(cv "tphn28hpcpgv18" "PDDW16SDGZ_H_G" "layout" "D4_left_4" list(0 210) "R270")
dbCreateParamInstByMasterName(cv "PAD" "PAD60GU" "layout" "pad60gu_D4_left_4" list(0 210) "R270")
dbCreateParamInstByMasterName(cv "tphn28hpcpgv18" "PDDW16SDGZ_H_G" "layout" "D3_left_3" list(0 270) "R270")
dbCreateParamInstByMasterName(cv "PAD" "PAD60GU" "layout" "pad60gu_D3_left_3" list(0 270) "R270")
dbCreateParamInstByMasterName(cv "tphn28hpcpgv18" "PDDW16SDGZ_H_G" "layout" "D2_left_2" list(0 330) "R270")
dbCreateParamInstByMasterName(cv "PAD" "PAD60GU" "layout" "pad60gu_D2_left_2" list(0 330) "R270")
dbCreateParamInstByMasterName(cv "tphn28hpcpgv18" "PDDW16SDGZ_H_G" "layout" "D1_left_1" list(0 390) "R270")
dbCreateParamInstByMasterName(cv "PAD" "PAD60GU" "layout" "pad60gu_D1_left_1" list(0 390) "R270")
dbCreateParamInstByMasterName(cv "tphn28hpcpgv18" "PDDW16SDGZ_H_G" "layout" "D0_left_0" list(0 450) "R270")
dbCreateParamInstByMasterName(cv "PAD" "PAD60GU" "layout" "pad60gu_D0_left_0" list(0 450) "R270")
dbCreateParamInstByMasterName(cv "tphn28hpcpgv18" "PCORNER_G" "layout" "CORNER_TL_top_left" list(0 580) "R270")
dbCreateParamInstByMasterName(cv "tphn28hpcpgv18" "PDDW16SDGZ_V_G" "layout" "D11_bottom_5" list(430 0) "R0")
dbCreateParamInstByMasterName(cv "PAD" "PAD60GU" "layout" "pad60gu_D11_bottom_5" list(430 0) "R0")
dbCreateParamInstByMasterName(cv "tphn28hpcpgv18" "PDDW16SDGZ_V_G" "layout" "D10_bottom_4" list(370 0) "R0")
dbCreateParamInstByMasterName(cv "PAD" "PAD60GU" "layout" "pad60gu_D10_bottom_4" list(370 0) "R0")
dbCreateParamInstByMasterName(cv "tphn28hpcpgv18" "PDDW16SDGZ_V_G" "layout" "D9_bottom_3" list(310 0) "R0")
dbCreateParamInstByMasterName(cv "PAD" "PAD60GU" "layout" "pad60gu_D9_bottom_3" list(310 0) "R0")
dbCreateParamInstByMasterName(cv "tphn28hpcpgv18" "PDDW16SDGZ_V_G" "layout" "D8_bottom_2" list(250 0) "R0")
dbCreateParamInstByMasterName(cv "PAD" "PAD60GU" "layout" "pad60gu_D8_bottom_2" list(250 0) "R0")
dbCreateParamInstByMasterName(cv "tphn28hpcpgv18" "PDDW16SDGZ_V_G" "layout" "D7_bottom_1" list(190 0) "R0")
dbCreateParamInstByMasterName(cv "PAD" "PAD60GU" "layout" "pad60gu_D7_bottom_1" list(190 0) "R0")
dbCreateParamInstByMasterName(cv "tphn28hpcpgv18" "PDDW16SDGZ_V_G" "layout" "D6_bottom_0" list(130 0) "R0")
dbCreateParamInstByMasterName(cv "PAD" "PAD60GU" "layout" "pad60gu_D6_bottom_0" list(130 0) "R0")
dbCreateParamInstByMasterName(cv "tphn28hpcpgv18" "PCORNER_G" "layout" "CORNER_BL_bottom_left" list(0 0) "R0")
dbCreateParamInstByMasterName(cv "tphn28hpcpgv18" "PDDW16SDGZ_H_G" "layout" "D17_right_5" list(580 430) "R90")
dbCreateParamInstByMasterName(cv "PAD" "PAD60GU" "layout" "pad60gu_D17_right_5" list(580 430) "R90")
dbCreateParamInstByMasterName(cv "tphn28hpcpgv18" "PDDW16SDGZ_H_G" "layout" "D16_right_4" list(580 370) "R90")
dbCreateParamInstByMasterName(cv "PAD" "PAD60GU" "layout" "pad60gu_D16_right_4" list(580 370) "R90")
dbCreateParamInstByMasterName(cv "tphn28hpcpgv18" "PDDW16SDGZ_H_G" "layout" "D15_right_3" list(580 310) "R90")
dbCreateParamInstByMasterName(cv "PAD" "PAD60GU" "layout" "pad60gu_D15_right_3" list(580 310) "R90")
dbCreateParamInstByMasterName(cv "tphn28hpcpgv18" "PDDW16SDGZ_H_G" "layout" "D14_right_2" list(580 250) "R90")
dbCreateParamInstByMasterName(cv "PAD" "PAD60GU" "layout" "pad60gu_D14_right_2" list(580 250) "R90")
dbCreateParamInstByMasterName(cv "tphn28hpcpgv18" "PDDW16SDGZ_H_G" "layout" "D13_right_1" list(580 190) "R90")
dbCreateParamInstByMasterName(cv "PAD" "PAD60GU" "layout" "pad60gu_D13_right_1" list(580 190) "R90")
dbCreateParamInstByMasterName(cv "tphn28hpcpgv18" "PDDW16SDGZ_H_G" "layout" "D12_right_0" list(580 130) "R90")
dbCreateParamInstByMasterName(cv "PAD" "PAD60GU" "layout" "pad60gu_D12_right_0" list(580 130) "R90")
dbCreateParamInstByMasterName(cv "tphn28hpcpgv18" "PCORNER_G" "layout" "CORNER_BR_bottom_right" list(580 0) "R90")
dbCreateParamInstByMasterName(cv "tphn28hpcpgv18" "PVSS2DGZ_V_G" "layout" "GIOH_top_5" list(150 580) "R180")
dbCreateParamInstByMasterName(cv "PAD" "PAD60GU" "layout" "pad60gu_GIOH_top_5" list(150 580) "R180")
dbCreateParamInstByMasterName(cv "tphn28hpcpgv18" "PVDD2POC_V_G" "layout" "VIOH_top_4" list(210 580) "R180")
dbCreateParamInstByMasterName(cv "PAD" "PAD60GU" "layout" "pad60gu_VIOH_top_4" list(210 580) "R180")
dbCreateParamInstByMasterName(cv "tphn28hpcpgv18" "PVSS1DGZ_V_G" "layout" "GIOL_top_3" list(270 580) "R180")
dbCreateParamInstByMasterName(cv "PAD" "PAD60GU" "layout" "pad60gu_GIOL_top_3" list(270 580) "R180")
dbCreateParamInstByMasterName(cv "tphn28hpcpgv18" "PVDD1DGZ_V_G" "layout" "VIOL_top_2" list(330 580) "R180")
dbCreateParamInstByMasterName(cv "PAD" "PAD60GU" "layout" "pad60gu_VIOL_top_2" list(330 580) "R180")
dbCreateParamInstByMasterName(cv "tphn28hpcpgv18" "PDDW16SDGZ_V_G" "layout" "D19_top_1" list(390 580) "R180")
dbCreateParamInstByMasterName(cv "PAD" "PAD60GU" "layout" "pad60gu_D19_top_1" list(390 580) "R180")
dbCreateParamInstByMasterName(cv "tphn28hpcpgv18" "PDDW16SDGZ_V_G" "layout" "D18_top_0" list(450 580) "R180")
dbCreateParamInstByMasterName(cv "PAD" "PAD60GU" "layout" "pad60gu_D18_top_0" list(450 580) "R180")
dbCreateParamInstByMasterName(cv "tphn28hpcpgv18" "PCORNER_G" "layout" "CORNER_TR_top_right" list(580 580) "R180")

; ==================== Filler Components ====================
dbCreateParamInstByMasterName(cv "tphn28hpcpgv18" "PFILLER20_G" "layout" "sep_bottom_right_corner" list(450 0) "R0")
dbCreateParamInstByMasterName(cv "tphn28hpcpgv18" "PFILLER20_G" "layout" "filler_bottom_left_corner" list(110 0) "R0")
dbCreateParamInstByMasterName(cv "tphn28hpcpgv18" "PFILLER20_G" "layout" "filler_R0_1_1" list(410 0) "R0")
dbCreateParamInstByMasterName(cv "tphn28hpcpgv18" "PFILLER20_G" "layout" "filler_R0_1_2" list(390 0) "R0")
dbCreateParamInstByMasterName(cv "tphn28hpcpgv18" "PFILLER20_G" "layout" "filler_R0_2_1" list(350 0) "R0")
dbCreateParamInstByMasterName(cv "tphn28hpcpgv18" "PFILLER20_G" "layout" "filler_R0_2_2" list(330 0) "R0")
dbCreateParamInstByMasterName(cv "tphn28hpcpgv18" "PFILLER20_G" "layout" "filler_R0_3_1" list(290 0) "R0")
dbCreateParamInstByMasterName(cv "tphn28hpcpgv18" "PFILLER20_G" "layout" "filler_R0_3_2" list(270 0) "R0")
dbCreateParamInstByMasterName(cv "tphn28hpcpgv18" "PFILLER20_G" "layout" "filler_R0_4_1" list(230 0) "R0")
dbCreateParamInstByMasterName(cv "tphn28hpcpgv18" "PFILLER20_G" "layout" "filler_R0_4_2" list(210 0) "R0")
dbCreateParamInstByMasterName(cv "tphn28hpcpgv18" "PFILLER20_G" "layout" "filler_R0_5_1" list(170 0) "R0")
dbCreateParamInstByMasterName(cv "tphn28hpcpgv18" "PFILLER20_G" "layout" "filler_R0_5_2" list(150 0) "R0")
dbCreateParamInstByMasterName(cv "tphn28hpcpgv18" "PFILLER20_G" "layout" "filler_right_top_corner" list(580 450) "R90")
dbCreateParamInstByMasterName(cv "tphn28hpcpgv18" "PFILLER20_G" "layout" "filler_right_bottom_corner" list(580 110) "R90")
dbCreateParamInstByMasterName(cv "tphn28hpcpgv18" "PFILLER20_G" "layout" "filler_R90_1_1" list(580 410) "R90")
dbCreateParamInstByMasterName(cv "tphn28hpcpgv18" "PFILLER20_G" "layout" "filler_R90_1_2" list(580 390) "R90")
dbCreateParamInstByMasterName(cv "tphn28hpcpgv18" "PFILLER20_G" "layout" "filler_R90_2_1" list(580 350) "R90")
dbCreateParamInstByMasterName(cv "tphn28hpcpgv18" "PFILLER20_G" "layout" "filler_R90_2_2" list(580 330) "R90")
dbCreateParamInstByMasterName(cv "tphn28hpcpgv18" "PFILLER20_G" "layout" "filler_R90_3_1" list(580 290) "R90")
dbCreateParamInstByMasterName(cv "tphn28hpcpgv18" "PFILLER20_G" "layout" "filler_R90_3_2" list(580 270) "R90")
dbCreateParamInstByMasterName(cv "tphn28hpcpgv18" "PFILLER20_G" "layout" "filler_R90_4_1" list(580 230) "R90")
dbCreateParamInstByMasterName(cv "tphn28hpcpgv18" "PFILLER20_G" "layout" "filler_R90_4_2" list(580 210) "R90")
dbCreateParamInstByMasterName(cv "tphn28hpcpgv18" "PFILLER20_G" "layout" "filler_R90_5_1" list(580 170) "R90")
dbCreateParamInstByMasterName(cv "tphn28hpcpgv18" "PFILLER20_G" "layout" "filler_R90_5_2" list(580 150) "R90")
dbCreateParamInstByMasterName(cv "tphn28hpcpgv18" "PFILLER20_G" "layout" "sep_top_left_corner" list(130 580) "R180")
dbCreateParamInstByMasterName(cv "tphn28hpcpgv18" "PFILLER20_G" "layout" "filler_top_right_corner" list(470 580) "R180")
dbCreateParamInstByMasterName(cv "tphn28hpcpgv18" "PFILLER20_G" "layout" "filler_R180_1_1" list(170 580) "R180")
dbCreateParamInstByMasterName(cv "tphn28hpcpgv18" "PFILLER20_G" "layout" "filler_R180_1_2" list(190 580) "R180")
dbCreateParamInstByMasterName(cv "tphn28hpcpgv18" "PFILLER20_G" "layout" "filler_R180_2_1" list(230 580) "R180")
dbCreateParamInstByMasterName(cv "tphn28hpcpgv18" "PFILLER20_G" "layout" "filler_R180_2_2" list(250 580) "R180")
dbCreateParamInstByMasterName(cv "tphn28hpcpgv18" "PFILLER20_G" "layout" "filler_R180_3_1" list(290 580) "R180")
dbCreateParamInstByMasterName(cv "tphn28hpcpgv18" "PFILLER20_G" "layout" "filler_R180_3_2" list(310 580) "R180")
dbCreateParamInstByMasterName(cv "tphn28hpcpgv18" "PFILLER20_G" "layout" "filler_R180_4_1" list(350 580) "R180")
dbCreateParamInstByMasterName(cv "tphn28hpcpgv18" "PFILLER20_G" "layout" "filler_R180_4_2" list(370 580) "R180")
dbCreateParamInstByMasterName(cv "tphn28hpcpgv18" "PFILLER20_G" "layout" "filler_R180_5_1" list(410 580) "R180")
dbCreateParamInstByMasterName(cv "tphn28hpcpgv18" "PFILLER20_G" "layout" "filler_R180_5_2" list(430 580) "R180")
dbCreateParamInstByMasterName(cv "tphn28hpcpgv18" "PFILLER20_G" "layout" "filler_left_bottom_corner" list(0 130) "R270")
dbCreateParamInstByMasterName(cv "tphn28hpcpgv18" "PFILLER20_G" "layout" "sep_left_top_corner" list(0 470) "R270")
dbCreateParamInstByMasterName(cv "tphn28hpcpgv18" "PFILLER20_G" "layout" "filler_R270_1_1" list(0 170) "R270")
dbCreateParamInstByMasterName(cv "tphn28hpcpgv18" "PFILLER20_G" "layout" "filler_R270_1_2" list(0 190) "R270")
dbCreateParamInstByMasterName(cv "tphn28hpcpgv18" "PFILLER20_G" "layout" "filler_R270_2_1" list(0 230) "R270")
dbCreateParamInstByMasterName(cv "tphn28hpcpgv18" "PFILLER20_G" "layout" "filler_R270_2_2" list(0 250) "R270")
dbCreateParamInstByMasterName(cv "tphn28hpcpgv18" "PFILLER20_G" "layout" "filler_R270_3_1" list(0 290) "R270")
dbCreateParamInstByMasterName(cv "tphn28hpcpgv18" "PFILLER20_G" "layout" "filler_R270_3_2" list(0 310) "R270")
dbCreateParamInstByMasterName(cv "tphn28hpcpgv18" "PFILLER20_G" "layout" "filler_R270_4_1" list(0 350) "R270")
dbCreateParamInstByMasterName(cv "tphn28hpcpgv18" "PFILLER20_G" "layout" "filler_R270_4_2" list(0 370) "R270")
dbCreateParamInstByMasterName(cv "tphn28hpcpgv18" "PFILLER20_G" "layout" "filler_R270_5_1" list(0 410) "R270")
dbCreateParamInstByMasterName(cv "tphn28hpcpgv18" "PFILLER20_G" "layout" "filler_R270_5_2" list(0 430) "R270")

; ==================== Digital IO Features (with Inner Pad Support) ====================
dbCreatePath(cv list("M3" "drawing") list(list(130 110.5) list(450 110.5)) 0.2)
dbCreatePath(cv list("M3" "drawing") list(list(130 109.24) list(450 109.24)) 0.2)
dbCreatePath(cv list("M3" "drawing") list(list(469.5 130) list(469.5 450)) 0.2)
dbCreatePath(cv list("M3" "drawing") list(list(470.76 130) list(470.76 450)) 0.2)
dbCreatePath(cv list("M3" "drawing") list(list(130 469.5) list(450 469.5)) 0.2)
dbCreatePath(cv list("M3" "drawing") list(list(130 470.76) list(450 470.76)) 0.2)
dbCreatePath(cv list("M3" "drawing") list(list(110.5 130) list(110.5 450)) 0.2)
dbCreatePath(cv list("M3" "drawing") list(list(109.24 130) list(109.24 450)) 0.2)
dbCreatePath(cv list("M3" "drawing") list(list(130 469.5) list(110.5 469.5)) 0.2 "extendExtend")
dbCreatePath(cv list("M3" "drawing") list(list(110.5 469.5) list(110.5 450)) 0.2 "extendExtend")
dbCreatePath(cv list("M3" "drawing") list(list(130 470.76) list(109.24 470.76)) 0.2 "extendExtend")
dbCreatePath(cv list("M3" "drawing") list(list(109.24 470.76) list(109.24 450)) 0.2 "extendExtend")
dbCreatePath(cv list("M3" "drawing") list(list(450 469.5) list(469.5 469.5)) 0.2 "extendExtend")
dbCreatePath(cv list("M3" "drawing") list(list(469.5 469.5) list(469.5 450)) 0.2 "extendExtend")
dbCreatePath(cv list("M3" "drawing") list(list(450 470.76) list(470.76 470.76)) 0.2 "extendExtend")
dbCreatePath(cv list("M3" "drawing") list(list(470.76 470.76) list(470.76 450)) 0.2 "extendExtend")
dbCreatePath(cv list("M3" "drawing") list(list(130 110.5) list(110.5 110.5)) 0.2 "extendExtend")
dbCreatePath(cv list("M3" "drawing") list(list(110.5 110.5) list(110.5 130)) 0.2 "extendExtend")
dbCreatePath(cv list("M3" "drawing") list(list(130 109.24) list(109.24 109.24)) 0.2 "extendExtend")
dbCreatePath(cv list("M3" "drawing") list(list(109.24 109.24) list(109.24 130)) 0.2 "extendExtend")
dbCreatePath(cv list("M3" "drawing") list(list(450 110.5) list(469.5 110.5)) 0.2 "extendExtend")
dbCreatePath(cv list("M3" "drawing") list(list(469.5 110.5) list(469.5 130)) 0.2 "extendExtend")
dbCreatePath(cv list("M3" "drawing") list(list(450 109.24) list(470.76 109.24)) 0.2 "extendExtend")
dbCreatePath(cv list("M3" "drawing") list(list(470.76 109.24) list(470.76 130)) 0.2 "extendExtend")
dbCreatePath(cv list("M3" "drawing") list(list(327.655 469.88) list(327.655 469.5)) 0.2)
tech = techGetTechFile(cv)
viaParams = list(list("cutRows" 2) list("cutColumns" 4))
viaDefId = techFindViaDefByName(tech "M3_M2")
newVia = dbCreateVia(cv viaDefId list(327.655 469.88) "R180" viaParams)
dbCreatePath(cv list("M3" "drawing") list(list(267.61 469.88) list(267.61 470.76)) 0.2)
tech = techGetTechFile(cv)
viaParams = list(list("cutRows" 2) list("cutColumns" 4))
viaDefId = techFindViaDefByName(tech "M3_M2")
newVia = dbCreateVia(cv viaDefId list(267.61 469.88) "R180" viaParams)
dbCreatePath(cv list("M3" "drawing") list(list(109.875 439.8) list(109.24 439.8)) 0.26)
dbCreatePath(cv list("M3" "drawing") list(list(109.875 448.275) list(109.24 448.275)) 0.26)
dbCreatePath(cv list("M3" "drawing") list(list(109.875 444.1) list(110.5 444.1)) 0.26)
dbCreateLabel(cv list("M4" "pin") list(109.875 435.67) "D0_CORE" "centerLeft" "R0" "roman" 2)
dbCreatePath(cv list("M3" "drawing") list(list(109.875 379.8) list(109.24 379.8)) 0.26)
dbCreatePath(cv list("M3" "drawing") list(list(109.875 388.275) list(109.24 388.275)) 0.26)
dbCreatePath(cv list("M3" "drawing") list(list(109.875 384.1) list(110.5 384.1)) 0.26)
dbCreateLabel(cv list("M4" "pin") list(109.875 375.67) "D1_CORE" "centerLeft" "R0" "roman" 2)
dbCreatePath(cv list("M3" "drawing") list(list(109.875 319.8) list(109.24 319.8)) 0.26)
dbCreatePath(cv list("M3" "drawing") list(list(109.875 328.275) list(109.24 328.275)) 0.26)
dbCreatePath(cv list("M3" "drawing") list(list(109.875 324.1) list(110.5 324.1)) 0.26)
dbCreateLabel(cv list("M4" "pin") list(109.875 315.67) "D2_CORE" "centerLeft" "R0" "roman" 2)
dbCreatePath(cv list("M3" "drawing") list(list(109.875 259.8) list(109.24 259.8)) 0.26)
dbCreatePath(cv list("M3" "drawing") list(list(109.875 268.275) list(109.24 268.275)) 0.26)
dbCreatePath(cv list("M3" "drawing") list(list(109.875 264.1) list(110.5 264.1)) 0.26)
dbCreateLabel(cv list("M4" "pin") list(109.875 255.67) "D3_CORE" "centerLeft" "R0" "roman" 2)
dbCreatePath(cv list("M3" "drawing") list(list(109.875 199.8) list(109.24 199.8)) 0.26)
dbCreatePath(cv list("M3" "drawing") list(list(109.875 208.275) list(109.24 208.275)) 0.26)
dbCreatePath(cv list("M3" "drawing") list(list(109.875 204.1) list(110.5 204.1)) 0.26)
dbCreateLabel(cv list("M4" "pin") list(109.875 195.67) "D4_CORE" "centerLeft" "R0" "roman" 2)
dbCreatePath(cv list("M3" "drawing") list(list(109.875 139.8) list(109.24 139.8)) 0.26)
dbCreatePath(cv list("M3" "drawing") list(list(109.875 148.275) list(109.24 148.275)) 0.26)
dbCreatePath(cv list("M3" "drawing") list(list(109.875 144.1) list(110.5 144.1)) 0.26)
dbCreateLabel(cv list("M4" "pin") list(109.875 135.67) "D5_CORE" "centerLeft" "R0" "roman" 2)
dbCreatePath(cv list("M3" "drawing") list(list(140.2 109.875) list(140.2 109.24)) 0.26)
dbCreatePath(cv list("M3" "drawing") list(list(131.725 109.875) list(131.725 109.24)) 0.26)
dbCreatePath(cv list("M3" "drawing") list(list(135.9 109.875) list(135.9 110.5)) 0.26)
dbCreateLabel(cv list("M4" "pin") list(144.33 109.875) "D6_CORE" "centerLeft" "R90" "roman" 2)
dbCreatePath(cv list("M3" "drawing") list(list(200.2 109.875) list(200.2 109.24)) 0.26)
dbCreatePath(cv list("M3" "drawing") list(list(191.725 109.875) list(191.725 109.24)) 0.26)
dbCreatePath(cv list("M3" "drawing") list(list(195.9 109.875) list(195.9 110.5)) 0.26)
dbCreateLabel(cv list("M4" "pin") list(204.33 109.875) "D7_CORE" "centerLeft" "R90" "roman" 2)
dbCreatePath(cv list("M3" "drawing") list(list(260.2 109.875) list(260.2 109.24)) 0.26)
dbCreatePath(cv list("M3" "drawing") list(list(251.725 109.875) list(251.725 109.24)) 0.26)
dbCreatePath(cv list("M3" "drawing") list(list(255.9 109.875) list(255.9 110.5)) 0.26)
dbCreateLabel(cv list("M4" "pin") list(264.33 109.875) "D8_CORE" "centerLeft" "R90" "roman" 2)
dbCreatePath(cv list("M3" "drawing") list(list(320.2 109.875) list(320.2 109.24)) 0.26)
dbCreatePath(cv list("M3" "drawing") list(list(311.725 109.875) list(311.725 109.24)) 0.26)
dbCreatePath(cv list("M3" "drawing") list(list(315.9 109.875) list(315.9 110.5)) 0.26)
dbCreateLabel(cv list("M4" "pin") list(324.33 109.875) "D9_CORE" "centerLeft" "R90" "roman" 2)
dbCreatePath(cv list("M3" "drawing") list(list(380.2 109.875) list(380.2 109.24)) 0.26)
dbCreatePath(cv list("M3" "drawing") list(list(371.725 109.875) list(371.725 109.24)) 0.26)
dbCreatePath(cv list("M3" "drawing") list(list(375.9 109.875) list(375.9 110.5)) 0.26)
dbCreateLabel(cv list("M4" "pin") list(384.33 109.875) "D10_CORE" "centerLeft" "R90" "roman" 2)
dbCreatePath(cv list("M3" "drawing") list(list(440.2 109.875) list(440.2 109.24)) 0.26)
dbCreatePath(cv list("M3" "drawing") list(list(431.725 109.875) list(431.725 109.24)) 0.26)
dbCreatePath(cv list("M3" "drawing") list(list(435.9 109.875) list(435.9 110.5)) 0.26)
dbCreateLabel(cv list("M4" "pin") list(444.33 109.875) "D11_CORE" "centerLeft" "R90" "roman" 2)
dbCreatePath(cv list("M3" "drawing") list(list(470.76 140.2) list(470.125 140.2)) 0.26)
dbCreatePath(cv list("M3" "drawing") list(list(470.76 131.725) list(470.125 131.725)) 0.26)
dbCreatePath(cv list("M3" "drawing") list(list(469.5 135.9) list(470.125 135.9)) 0.26)
dbCreateLabel(cv list("M4" "pin") list(470.125 144.33) "D12_CORE" "centerRight" "R0" "roman" 2)
dbCreatePath(cv list("M3" "drawing") list(list(470.76 200.2) list(470.125 200.2)) 0.26)
dbCreatePath(cv list("M3" "drawing") list(list(470.76 191.725) list(470.125 191.725)) 0.26)
dbCreatePath(cv list("M3" "drawing") list(list(469.5 195.9) list(470.125 195.9)) 0.26)
dbCreateLabel(cv list("M4" "pin") list(470.125 204.33) "D13_CORE" "centerRight" "R0" "roman" 2)
dbCreatePath(cv list("M3" "drawing") list(list(470.76 260.2) list(470.125 260.2)) 0.26)
dbCreatePath(cv list("M3" "drawing") list(list(470.76 251.725) list(470.125 251.725)) 0.26)
dbCreatePath(cv list("M3" "drawing") list(list(469.5 255.9) list(470.125 255.9)) 0.26)
dbCreateLabel(cv list("M4" "pin") list(470.125 264.33) "D14_CORE" "centerRight" "R0" "roman" 2)
dbCreatePath(cv list("M3" "drawing") list(list(470.76 320.2) list(470.125 320.2)) 0.26)
dbCreatePath(cv list("M3" "drawing") list(list(470.76 311.725) list(470.125 311.725)) 0.26)
dbCreatePath(cv list("M3" "drawing") list(list(469.5 315.9) list(470.125 315.9)) 0.26)
dbCreateLabel(cv list("M4" "pin") list(470.125 324.33) "D15_CORE" "centerRight" "R0" "roman" 2)
dbCreatePath(cv list("M3" "drawing") list(list(470.76 380.2) list(470.125 380.2)) 0.26)
dbCreatePath(cv list("M3" "drawing") list(list(470.76 371.725) list(470.125 371.725)) 0.26)
dbCreatePath(cv list("M3" "drawing") list(list(469.5 375.9) list(470.125 375.9)) 0.26)
dbCreateLabel(cv list("M4" "pin") list(470.125 384.33) "D16_CORE" "centerRight" "R0" "roman" 2)
dbCreatePath(cv list("M3" "drawing") list(list(470.76 440.2) list(470.125 440.2)) 0.26)
dbCreatePath(cv list("M3" "drawing") list(list(470.76 431.725) list(470.125 431.725)) 0.26)
dbCreatePath(cv list("M3" "drawing") list(list(469.5 435.9) list(470.125 435.9)) 0.26)
dbCreateLabel(cv list("M4" "pin") list(470.125 444.33) "D17_CORE" "centerRight" "R0" "roman" 2)
dbCreatePath(cv list("M3" "drawing") list(list(439.8 470.125) list(439.8 470.76)) 0.26)
dbCreatePath(cv list("M3" "drawing") list(list(448.275 470.125) list(448.275 470.76)) 0.26)
dbCreatePath(cv list("M3" "drawing") list(list(444.1 470.125) list(444.1 469.5)) 0.26)
dbCreateLabel(cv list("M4" "pin") list(435.67 470.125) "D18_CORE" "centerRight" "R90" "roman" 2)
dbCreatePath(cv list("M3" "drawing") list(list(379.8 470.125) list(379.8 470.76)) 0.26)
dbCreatePath(cv list("M3" "drawing") list(list(388.275 470.125) list(388.275 470.76)) 0.26)
dbCreatePath(cv list("M3" "drawing") list(list(384.1 470.125) list(384.1 469.5)) 0.26)
dbCreateLabel(cv list("M4" "pin") list(375.67 470.125) "D19_CORE" "centerRight" "R90" "roman" 2)

; ==================== Pin Labels (with Inner Pad Support) ====================
dbCreateLabel(cv list("AP" "pin") list(-11 440) "D0" "centerRight" "R0" "roman" 10)
dbCreateLabel(cv list("AP" "pin") list(-11 380) "D1" "centerRight" "R0" "roman" 10)
dbCreateLabel(cv list("AP" "pin") list(-11 320) "D2" "centerRight" "R0" "roman" 10)
dbCreateLabel(cv list("AP" "pin") list(-11 260) "D3" "centerRight" "R0" "roman" 10)
dbCreateLabel(cv list("AP" "pin") list(-11 200) "D4" "centerRight" "R0" "roman" 10)
dbCreateLabel(cv list("AP" "pin") list(-11 140) "D5" "centerRight" "R0" "roman" 10)
dbCreateLabel(cv list("AP" "pin") list(140 -11) "D6" "centerRight" "R90" "roman" 10)
dbCreateLabel(cv list("AP" "pin") list(200 -11) "D7" "centerRight" "R90" "roman" 10)
dbCreateLabel(cv list("AP" "pin") list(260 -11) "D8" "centerRight" "R90" "roman" 10)
dbCreateLabel(cv list("AP" "pin") list(320 -11) "D9" "centerRight" "R90" "roman" 10)
dbCreateLabel(cv list("AP" "pin") list(380 -11) "D10" "centerRight" "R90" "roman" 10)
dbCreateLabel(cv list("AP" "pin") list(440 -11) "D11" "centerRight" "R90" "roman" 10)
dbCreateLabel(cv list("AP" "pin") list(591 140) "D12" "centerLeft" "R0" "roman" 10)
dbCreateLabel(cv list("AP" "pin") list(591 200) "D13" "centerLeft" "R0" "roman" 10)
dbCreateLabel(cv list("AP" "pin") list(591 260) "D14" "centerLeft" "R0" "roman" 10)
dbCreateLabel(cv list("AP" "pin") list(591 320) "D15" "centerLeft" "R0" "roman" 10)
dbCreateLabel(cv list("AP" "pin") list(591 380) "D16" "centerLeft" "R0" "roman" 10)
dbCreateLabel(cv list("AP" "pin") list(591 440) "D17" "centerLeft" "R0" "roman" 10)
dbCreateLabel(cv list("AP" "pin") list(440 591) "D18" "centerLeft" "R90" "roman" 10)
dbCreateLabel(cv list("AP" "pin") list(380 591) "D19" "centerLeft" "R90" "roman" 10)
dbCreateLabel(cv list("AP" "pin") list(320 591) "VIOL" "centerLeft" "R90" "roman" 10)
dbCreateLabel(cv list("AP" "pin") list(260 591) "GIOL" "centerLeft" "R90" "roman" 10)
dbCreateLabel(cv list("AP" "pin") list(200 591) "VIOH" "centerLeft" "R90" "roman" 10)
dbCreateLabel(cv list("AP" "pin") list(140 591) "GIOH" "centerLeft" "R90" "roman" 10)

dbSave(cv)
t
