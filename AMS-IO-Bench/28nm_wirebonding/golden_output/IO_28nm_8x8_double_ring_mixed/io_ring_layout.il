; Generated Layout Script with Dual Ring Support

; ==================== All Components (Sorted by Placement Order) ====================
dbCreateParamInstByMasterName(cv "tphn28hpcpgv18" "PVSS3AC_H_G" "layout" "AVSS_left_7" list(0 150) "R270")
dbCreateParamInstByMasterName(cv "PAD" "PAD60GU" "layout" "pad60gu_AVSS_left_7" list(0 150) "R270")
dbCreateParamInstByMasterName(cv "tphn28hpcpgv18" "PVDD3AC_H_G" "layout" "AVDD_left_6" list(0 210) "R270")
dbCreateParamInstByMasterName(cv "PAD" "PAD60GU" "layout" "pad60gu_AVDD_left_6" list(0 210) "R270")
dbCreateParamInstByMasterName(cv "tphn28hpcpgv18" "PDB3AC_H_G" "layout" "VREF_left_5" list(0 270) "R270")
dbCreateParamInstByMasterName(cv "PAD" "PAD60GU" "layout" "pad60gu_VREF_left_5" list(0 270) "R270")
dbCreateParamInstByMasterName(cv "tphn28hpcpgv18" "PDB3AC_H_G" "layout" "VCM_left_4" list(0 330) "R270")
dbCreateParamInstByMasterName(cv "PAD" "PAD60GU" "layout" "pad60gu_VCM_left_4" list(0 330) "R270")
dbCreateParamInstByMasterName(cv "tphn28hpcpgv18" "PDB3AC_H_G" "layout" "VIM_left_3" list(0 390) "R270")
dbCreateParamInstByMasterName(cv "PAD" "PAD60GU" "layout" "pad60gu_VIM_left_3" list(0 390) "R270")
dbCreateParamInstByMasterName(cv "tphn28hpcpgv18" "PDB3AC_H_G" "layout" "VIP_left_2" list(0 450) "R270")
dbCreateParamInstByMasterName(cv "PAD" "PAD60GU" "layout" "pad60gu_VIP_left_2" list(0 450) "R270")
dbCreateParamInstByMasterName(cv "tphn28hpcpgv18" "PDB3AC_H_G" "layout" "VINN_left_1" list(0 510) "R270")
dbCreateParamInstByMasterName(cv "PAD" "PAD60GU" "layout" "pad60gu_VINN_left_1" list(0 510) "R270")
dbCreateParamInstByMasterName(cv "tphn28hpcpgv18" "PDB3AC_H_G" "layout" "VINP_left_0" list(0 570) "R270")
dbCreateParamInstByMasterName(cv "PAD" "PAD60GU" "layout" "pad60gu_VINP_left_0" list(0 570) "R270")
dbCreateParamInstByMasterName(cv "tphn28hpcpgv18" "PCORNERA_G" "layout" "CORNER_TOPLEFT_top_left" list(0 700) "R270")
dbCreateParamInstByMasterName(cv "tphn28hpcpgv18" "PDDW16SDGZ_V_G" "layout" "D7_bottom_7" list(550 0) "R0")
dbCreateParamInstByMasterName(cv "PAD" "PAD60GU" "layout" "pad60gu_D7_bottom_7" list(550 0) "R0")
dbCreateParamInstByMasterName(cv "tphn28hpcpgv18" "PDDW16SDGZ_V_G" "layout" "D6_bottom_6" list(490 0) "R0")
dbCreateParamInstByMasterName(cv "PAD" "PAD60GU" "layout" "pad60gu_D6_bottom_6" list(490 0) "R0")
dbCreateParamInstByMasterName(cv "tphn28hpcpgv18" "PDDW16SDGZ_V_G" "layout" "D5_bottom_5" list(430 0) "R0")
dbCreateParamInstByMasterName(cv "PAD" "PAD60GU" "layout" "pad60gu_D5_bottom_5" list(430 0) "R0")
dbCreateParamInstByMasterName(cv "tphn28hpcpgv18" "PDDW16SDGZ_V_G" "layout" "D4_bottom_4" list(370 0) "R0")
dbCreateParamInstByMasterName(cv "PAD" "PAD60GU" "layout" "pad60gu_D4_bottom_4" list(370 0) "R0")
dbCreateParamInstByMasterName(cv "tphn28hpcpgv18" "PDDW16SDGZ_V_G" "layout" "D3_bottom_3" list(310 0) "R0")
dbCreateParamInstByMasterName(cv "PAD" "PAD60GU" "layout" "pad60gu_D3_bottom_3" list(310 0) "R0")
dbCreateParamInstByMasterName(cv "tphn28hpcpgv18" "PDDW16SDGZ_V_G" "layout" "D2_bottom_2" list(250 0) "R0")
dbCreateParamInstByMasterName(cv "PAD" "PAD60GU" "layout" "pad60gu_D2_bottom_2" list(250 0) "R0")
dbCreateParamInstByMasterName(cv "tphn28hpcpgv18" "PDDW16SDGZ_V_G" "layout" "D1_bottom_1" list(190 0) "R0")
dbCreateParamInstByMasterName(cv "PAD" "PAD60GU" "layout" "pad60gu_D1_bottom_1" list(190 0) "R0")
dbCreateParamInstByMasterName(cv "tphn28hpcpgv18" "PDDW16SDGZ_V_G" "layout" "D0_bottom_0" list(130 0) "R0")
dbCreateParamInstByMasterName(cv "PAD" "PAD60GU" "layout" "pad60gu_D0_bottom_0" list(130 0) "R0")
dbCreateParamInstByMasterName(cv "tphn28hpcpgv18" "PCORNERA_G" "layout" "CORNER_BOTTOMLEFT_bottom_left" list(0 0) "R0")
dbCreateParamInstByMasterName(cv "tphn28hpcpgv18" "PDDW16SDGZ_H_G" "layout" "D15_right_7" list(700 550) "R90")
dbCreateParamInstByMasterName(cv "PAD" "PAD60GU" "layout" "pad60gu_D15_right_7" list(700 550) "R90")
dbCreateParamInstByMasterName(cv "tphn28hpcpgv18" "PDDW16SDGZ_H_G" "layout" "D14_right_6" list(700 490) "R90")
dbCreateParamInstByMasterName(cv "PAD" "PAD60GU" "layout" "pad60gu_D14_right_6" list(700 490) "R90")
dbCreateParamInstByMasterName(cv "tphn28hpcpgv18" "PDDW16SDGZ_H_G" "layout" "D13_right_5" list(700 430) "R90")
dbCreateParamInstByMasterName(cv "PAD" "PAD60GU" "layout" "pad60gu_D13_right_5" list(700 430) "R90")
dbCreateParamInstByMasterName(cv "tphn28hpcpgv18" "PDDW16SDGZ_H_G" "layout" "D12_right_4" list(700 370) "R90")
dbCreateParamInstByMasterName(cv "PAD" "PAD60GU" "layout" "pad60gu_D12_right_4" list(700 370) "R90")
dbCreateParamInstByMasterName(cv "tphn28hpcpgv18" "PDDW16SDGZ_H_G" "layout" "D11_right_3" list(700 310) "R90")
dbCreateParamInstByMasterName(cv "PAD" "PAD60GU" "layout" "pad60gu_D11_right_3" list(700 310) "R90")
dbCreateParamInstByMasterName(cv "tphn28hpcpgv18" "PDDW16SDGZ_H_G" "layout" "D10_right_2" list(700 250) "R90")
dbCreateParamInstByMasterName(cv "PAD" "PAD60GU" "layout" "pad60gu_D10_right_2" list(700 250) "R90")
dbCreateParamInstByMasterName(cv "tphn28hpcpgv18" "PDDW16SDGZ_H_G" "layout" "D9_right_1" list(700 190) "R90")
dbCreateParamInstByMasterName(cv "PAD" "PAD60GU" "layout" "pad60gu_D9_right_1" list(700 190) "R90")
dbCreateParamInstByMasterName(cv "tphn28hpcpgv18" "PDDW16SDGZ_H_G" "layout" "D8_right_0" list(700 130) "R90")
dbCreateParamInstByMasterName(cv "PAD" "PAD60GU" "layout" "pad60gu_D8_right_0" list(700 130) "R90")
dbCreateParamInstByMasterName(cv "tphn28hpcpgv18" "PCORNER_G" "layout" "CORNER_BOTTOMRIGHT_bottom_right" list(700 0) "R90")
dbCreateParamInstByMasterName(cv "tphn28hpcpgv18" "PVSS2DGZ_V_G" "layout" "GIOH_top_7" list(150 700) "R180")
dbCreateParamInstByMasterName(cv "PAD" "PAD60GU" "layout" "pad60gu_GIOH_top_7" list(150 700) "R180")
dbCreateParamInstByMasterName(cv "tphn28hpcpgv18" "PVDD2POC_V_G" "layout" "VIOH_top_6" list(210 700) "R180")
dbCreateParamInstByMasterName(cv "PAD" "PAD60GU" "layout" "pad60gu_VIOH_top_6" list(210 700) "R180")
dbCreateParamInstByMasterName(cv "tphn28hpcpgv18" "PVSS1DGZ_V_G" "layout" "GIOL_top_5" list(270 700) "R180")
dbCreateParamInstByMasterName(cv "PAD" "PAD60GU" "layout" "pad60gu_GIOL_top_5" list(270 700) "R180")
dbCreateParamInstByMasterName(cv "tphn28hpcpgv18" "PVDD1DGZ_V_G" "layout" "VIOL_top_4" list(330 700) "R180")
dbCreateParamInstByMasterName(cv "PAD" "PAD60GU" "layout" "pad60gu_VIOL_top_4" list(330 700) "R180")
dbCreateParamInstByMasterName(cv "tphn28hpcpgv18" "PDDW16SDGZ_V_G" "layout" "D19_top_3" list(390 700) "R180")
dbCreateParamInstByMasterName(cv "PAD" "PAD60GU" "layout" "pad60gu_D19_top_3" list(390 700) "R180")
dbCreateParamInstByMasterName(cv "tphn28hpcpgv18" "PDDW16SDGZ_V_G" "layout" "D18_top_2" list(450 700) "R180")
dbCreateParamInstByMasterName(cv "PAD" "PAD60GU" "layout" "pad60gu_D18_top_2" list(450 700) "R180")
dbCreateParamInstByMasterName(cv "tphn28hpcpgv18" "PDDW16SDGZ_V_G" "layout" "D17_top_1" list(510 700) "R180")
dbCreateParamInstByMasterName(cv "PAD" "PAD60GU" "layout" "pad60gu_D17_top_1" list(510 700) "R180")
dbCreateParamInstByMasterName(cv "tphn28hpcpgv18" "PDDW16SDGZ_V_G" "layout" "D16_top_0" list(570 700) "R180")
dbCreateParamInstByMasterName(cv "PAD" "PAD60GU" "layout" "pad60gu_D16_top_0" list(570 700) "R180")
dbCreateParamInstByMasterName(cv "tphn28hpcpgv18" "PCORNER_G" "layout" "CORNER_TOPRIGHT_top_right" list(700 700) "R180")

; ==================== Inner Ring Pads ====================
dbCreateParamInstByMasterName(cv "tphn28hpcpgv18" "PDB3AC_H_G" "layout" "inner_pad_VREF_CORE_left_4_5" list(0 300) "R270")
dbCreateParamInstByMasterName(cv "PAD" "PAD60NU" "layout" "inner_pad60nu_VREF_CORE_left_4_5" list(0 300) "R270")
dbCreateParamInstByMasterName(cv "tphn28hpcpgv18" "PDDW16SDGZ_H_G" "layout" "inner_pad_D24_right_6_7" list(700 520) "R90")
dbCreateParamInstByMasterName(cv "PAD" "PAD60NU" "layout" "inner_pad60nu_D24_right_6_7" list(700 520) "R90")
dbCreateParamInstByMasterName(cv "tphn28hpcpgv18" "PDB3AC_H_G" "layout" "inner_pad_VAMP_CORE_left_0_1" list(0 540) "R270")
dbCreateParamInstByMasterName(cv "PAD" "PAD60NU" "layout" "inner_pad60nu_VAMP_CORE_left_0_1" list(0 540) "R270")

; ==================== Filler Components ====================
dbCreateParamInstByMasterName(cv "tphn28hpcpgv18" "PFILLER20_G" "layout" "sep_bottom_right_corner" list(570 0) "R0")
dbCreateParamInstByMasterName(cv "tphn28hpcpgv18" "PRCUTA_G" "layout" "filler_bottom_left_corner" list(110 0) "R0")
dbCreateParamInstByMasterName(cv "tphn28hpcpgv18" "PFILLER20_G" "layout" "filler_R0_1_1" list(530 0) "R0")
dbCreateParamInstByMasterName(cv "tphn28hpcpgv18" "PFILLER20_G" "layout" "filler_R0_1_2" list(510 0) "R0")
dbCreateParamInstByMasterName(cv "tphn28hpcpgv18" "PFILLER20_G" "layout" "filler_R0_2_1" list(470 0) "R0")
dbCreateParamInstByMasterName(cv "tphn28hpcpgv18" "PFILLER20_G" "layout" "filler_R0_2_2" list(450 0) "R0")
dbCreateParamInstByMasterName(cv "tphn28hpcpgv18" "PFILLER20_G" "layout" "filler_R0_3_1" list(410 0) "R0")
dbCreateParamInstByMasterName(cv "tphn28hpcpgv18" "PFILLER20_G" "layout" "filler_R0_3_2" list(390 0) "R0")
dbCreateParamInstByMasterName(cv "tphn28hpcpgv18" "PFILLER20_G" "layout" "filler_R0_4_1" list(350 0) "R0")
dbCreateParamInstByMasterName(cv "tphn28hpcpgv18" "PFILLER20_G" "layout" "filler_R0_4_2" list(330 0) "R0")
dbCreateParamInstByMasterName(cv "tphn28hpcpgv18" "PFILLER20_G" "layout" "filler_R0_5_1" list(290 0) "R0")
dbCreateParamInstByMasterName(cv "tphn28hpcpgv18" "PFILLER20_G" "layout" "filler_R0_5_2" list(270 0) "R0")
dbCreateParamInstByMasterName(cv "tphn28hpcpgv18" "PFILLER20_G" "layout" "filler_R0_6_1" list(230 0) "R0")
dbCreateParamInstByMasterName(cv "tphn28hpcpgv18" "PFILLER20_G" "layout" "filler_R0_6_2" list(210 0) "R0")
dbCreateParamInstByMasterName(cv "tphn28hpcpgv18" "PFILLER20_G" "layout" "filler_R0_7_1" list(170 0) "R0")
dbCreateParamInstByMasterName(cv "tphn28hpcpgv18" "PFILLER20_G" "layout" "filler_R0_7_2" list(150 0) "R0")
dbCreateParamInstByMasterName(cv "tphn28hpcpgv18" "PFILLER20_G" "layout" "filler_right_top_corner" list(700 570) "R90")
dbCreateParamInstByMasterName(cv "tphn28hpcpgv18" "PFILLER20_G" "layout" "filler_right_bottom_corner" list(700 110) "R90")
dbCreateParamInstByMasterName(cv "tphn28hpcpgv18" "PFILLER10_G" "layout" "filler_R90_1_1" list(700 540) "R90")
dbCreateParamInstByMasterName(cv "tphn28hpcpgv18" "PFILLER10_G" "layout" "filler_R90_1_2" list(700 510) "R90")
dbCreateParamInstByMasterName(cv "tphn28hpcpgv18" "PFILLER20_G" "layout" "filler_R90_2_1" list(700 470) "R90")
dbCreateParamInstByMasterName(cv "tphn28hpcpgv18" "PFILLER20_G" "layout" "filler_R90_2_2" list(700 450) "R90")
dbCreateParamInstByMasterName(cv "tphn28hpcpgv18" "PFILLER20_G" "layout" "filler_R90_3_1" list(700 410) "R90")
dbCreateParamInstByMasterName(cv "tphn28hpcpgv18" "PFILLER20_G" "layout" "filler_R90_3_2" list(700 390) "R90")
dbCreateParamInstByMasterName(cv "tphn28hpcpgv18" "PFILLER20_G" "layout" "filler_R90_4_1" list(700 350) "R90")
dbCreateParamInstByMasterName(cv "tphn28hpcpgv18" "PFILLER20_G" "layout" "filler_R90_4_2" list(700 330) "R90")
dbCreateParamInstByMasterName(cv "tphn28hpcpgv18" "PFILLER20_G" "layout" "filler_R90_5_1" list(700 290) "R90")
dbCreateParamInstByMasterName(cv "tphn28hpcpgv18" "PFILLER20_G" "layout" "filler_R90_5_2" list(700 270) "R90")
dbCreateParamInstByMasterName(cv "tphn28hpcpgv18" "PFILLER20_G" "layout" "filler_R90_6_1" list(700 230) "R90")
dbCreateParamInstByMasterName(cv "tphn28hpcpgv18" "PFILLER20_G" "layout" "filler_R90_6_2" list(700 210) "R90")
dbCreateParamInstByMasterName(cv "tphn28hpcpgv18" "PFILLER20_G" "layout" "filler_R90_7_1" list(700 170) "R90")
dbCreateParamInstByMasterName(cv "tphn28hpcpgv18" "PFILLER20_G" "layout" "filler_R90_7_2" list(700 150) "R90")
dbCreateParamInstByMasterName(cv "tphn28hpcpgv18" "PRCUTA_G" "layout" "sep_top_left_corner" list(130 700) "R180")
dbCreateParamInstByMasterName(cv "tphn28hpcpgv18" "PFILLER20_G" "layout" "filler_top_right_corner" list(590 700) "R180")
dbCreateParamInstByMasterName(cv "tphn28hpcpgv18" "PFILLER20_G" "layout" "filler_R180_1_1" list(170 700) "R180")
dbCreateParamInstByMasterName(cv "tphn28hpcpgv18" "PFILLER20_G" "layout" "filler_R180_1_2" list(190 700) "R180")
dbCreateParamInstByMasterName(cv "tphn28hpcpgv18" "PFILLER20_G" "layout" "filler_R180_2_1" list(230 700) "R180")
dbCreateParamInstByMasterName(cv "tphn28hpcpgv18" "PFILLER20_G" "layout" "filler_R180_2_2" list(250 700) "R180")
dbCreateParamInstByMasterName(cv "tphn28hpcpgv18" "PFILLER20_G" "layout" "filler_R180_3_1" list(290 700) "R180")
dbCreateParamInstByMasterName(cv "tphn28hpcpgv18" "PFILLER20_G" "layout" "filler_R180_3_2" list(310 700) "R180")
dbCreateParamInstByMasterName(cv "tphn28hpcpgv18" "PFILLER20_G" "layout" "filler_R180_4_1" list(350 700) "R180")
dbCreateParamInstByMasterName(cv "tphn28hpcpgv18" "PFILLER20_G" "layout" "filler_R180_4_2" list(370 700) "R180")
dbCreateParamInstByMasterName(cv "tphn28hpcpgv18" "PFILLER20_G" "layout" "filler_R180_5_1" list(410 700) "R180")
dbCreateParamInstByMasterName(cv "tphn28hpcpgv18" "PFILLER20_G" "layout" "filler_R180_5_2" list(430 700) "R180")
dbCreateParamInstByMasterName(cv "tphn28hpcpgv18" "PFILLER20_G" "layout" "filler_R180_6_1" list(470 700) "R180")
dbCreateParamInstByMasterName(cv "tphn28hpcpgv18" "PFILLER20_G" "layout" "filler_R180_6_2" list(490 700) "R180")
dbCreateParamInstByMasterName(cv "tphn28hpcpgv18" "PFILLER20_G" "layout" "filler_R180_7_1" list(530 700) "R180")
dbCreateParamInstByMasterName(cv "tphn28hpcpgv18" "PFILLER20_G" "layout" "filler_R180_7_2" list(550 700) "R180")
dbCreateParamInstByMasterName(cv "tphn28hpcpgv18" "PRCUTA_G" "layout" "filler_left_bottom_corner" list(0 130) "R270")
dbCreateParamInstByMasterName(cv "tphn28hpcpgv18" "PRCUTA_G" "layout" "sep_left_top_corner" list(0 590) "R270")
dbCreateParamInstByMasterName(cv "tphn28hpcpgv18" "PFILLER20A_G" "layout" "filler_R270_1_1" list(0 170) "R270")
dbCreateParamInstByMasterName(cv "tphn28hpcpgv18" "PFILLER20A_G" "layout" "filler_R270_1_2" list(0 190) "R270")
dbCreateParamInstByMasterName(cv "tphn28hpcpgv18" "PFILLER20A_G" "layout" "filler_R270_2_1" list(0 230) "R270")
dbCreateParamInstByMasterName(cv "tphn28hpcpgv18" "PFILLER20A_G" "layout" "filler_R270_2_2" list(0 250) "R270")
dbCreateParamInstByMasterName(cv "tphn28hpcpgv18" "PFILLER10A_G" "layout" "filler_R270_3_1" list(0 280) "R270")
dbCreateParamInstByMasterName(cv "tphn28hpcpgv18" "PFILLER10A_G" "layout" "filler_R270_3_2" list(0 310) "R270")
dbCreateParamInstByMasterName(cv "tphn28hpcpgv18" "PFILLER20A_G" "layout" "filler_R270_4_1" list(0 350) "R270")
dbCreateParamInstByMasterName(cv "tphn28hpcpgv18" "PFILLER20A_G" "layout" "filler_R270_4_2" list(0 370) "R270")
dbCreateParamInstByMasterName(cv "tphn28hpcpgv18" "PFILLER20A_G" "layout" "filler_R270_5_1" list(0 410) "R270")
dbCreateParamInstByMasterName(cv "tphn28hpcpgv18" "PFILLER20A_G" "layout" "filler_R270_5_2" list(0 430) "R270")
dbCreateParamInstByMasterName(cv "tphn28hpcpgv18" "PFILLER20A_G" "layout" "filler_R270_6_1" list(0 470) "R270")
dbCreateParamInstByMasterName(cv "tphn28hpcpgv18" "PFILLER20A_G" "layout" "filler_R270_6_2" list(0 490) "R270")
dbCreateParamInstByMasterName(cv "tphn28hpcpgv18" "PFILLER10A_G" "layout" "filler_R270_7_1" list(0 520) "R270")
dbCreateParamInstByMasterName(cv "tphn28hpcpgv18" "PFILLER10A_G" "layout" "filler_R270_7_2" list(0 550) "R270")

; ==================== Digital IO Features (with Inner Pad Support) ====================
dbCreatePath(cv list("M3" "drawing") list(list(130 110.5) list(570 110.5)) 0.2)
dbCreatePath(cv list("M3" "drawing") list(list(130 109.24) list(570 109.24)) 0.2)
dbCreatePath(cv list("M3" "drawing") list(list(589.5 130) list(589.5 570)) 0.2)
dbCreatePath(cv list("M3" "drawing") list(list(590.76 130) list(590.76 570)) 0.2)
dbCreatePath(cv list("M3" "drawing") list(list(130 589.5) list(570 589.5)) 0.2)
dbCreatePath(cv list("M3" "drawing") list(list(130 590.76) list(570 590.76)) 0.2)
dbCreatePath(cv list("M3" "drawing") list(list(570 589.5) list(589.5 589.5)) 0.2 "extendExtend")
dbCreatePath(cv list("M3" "drawing") list(list(589.5 589.5) list(589.5 570)) 0.2 "extendExtend")
dbCreatePath(cv list("M3" "drawing") list(list(570 590.76) list(590.76 590.76)) 0.2 "extendExtend")
dbCreatePath(cv list("M3" "drawing") list(list(590.76 590.76) list(590.76 570)) 0.2 "extendExtend")
dbCreatePath(cv list("M3" "drawing") list(list(570 110.5) list(589.5 110.5)) 0.2 "extendExtend")
dbCreatePath(cv list("M3" "drawing") list(list(589.5 110.5) list(589.5 130)) 0.2 "extendExtend")
dbCreatePath(cv list("M3" "drawing") list(list(570 109.24) list(590.76 109.24)) 0.2 "extendExtend")
dbCreatePath(cv list("M3" "drawing") list(list(590.76 109.24) list(590.76 130)) 0.2 "extendExtend")
dbCreatePath(cv list("M3" "drawing") list(list(327.655 589.88) list(327.655 589.5)) 0.2)
tech = techGetTechFile(cv)
viaParams = list(list("cutRows" 2) list("cutColumns" 4))
viaDefId = techFindViaDefByName(tech "M3_M2")
newVia = dbCreateVia(cv viaDefId list(327.655 589.88) "R180" viaParams)
dbCreatePath(cv list("M3" "drawing") list(list(267.61 589.88) list(267.61 590.76)) 0.2)
tech = techGetTechFile(cv)
viaParams = list(list("cutRows" 2) list("cutColumns" 4))
viaDefId = techFindViaDefByName(tech "M3_M2")
newVia = dbCreateVia(cv viaDefId list(267.61 589.88) "R180" viaParams)
dbCreatePath(cv list("M3" "drawing") list(list(140.2 109.875) list(140.2 109.24)) 0.26)
dbCreatePath(cv list("M3" "drawing") list(list(131.725 109.875) list(131.725 109.24)) 0.26)
dbCreatePath(cv list("M3" "drawing") list(list(135.9 109.875) list(135.9 110.5)) 0.26)
dbCreateLabel(cv list("M4" "pin") list(144.33 109.875) "D0_CORE" "centerLeft" "R90" "roman" 2)
dbCreatePath(cv list("M3" "drawing") list(list(200.2 109.875) list(200.2 109.24)) 0.26)
dbCreatePath(cv list("M3" "drawing") list(list(191.725 109.875) list(191.725 109.24)) 0.26)
dbCreatePath(cv list("M3" "drawing") list(list(195.9 109.875) list(195.9 110.5)) 0.26)
dbCreateLabel(cv list("M4" "pin") list(204.33 109.875) "D1_CORE" "centerLeft" "R90" "roman" 2)
dbCreatePath(cv list("M3" "drawing") list(list(260.2 109.875) list(260.2 109.24)) 0.26)
dbCreatePath(cv list("M3" "drawing") list(list(251.725 109.875) list(251.725 109.24)) 0.26)
dbCreatePath(cv list("M3" "drawing") list(list(255.9 109.875) list(255.9 110.5)) 0.26)
dbCreateLabel(cv list("M4" "pin") list(264.33 109.875) "D2_CORE" "centerLeft" "R90" "roman" 2)
dbCreatePath(cv list("M3" "drawing") list(list(320.2 109.875) list(320.2 109.24)) 0.26)
dbCreatePath(cv list("M3" "drawing") list(list(311.725 109.875) list(311.725 109.24)) 0.26)
dbCreatePath(cv list("M3" "drawing") list(list(315.9 109.875) list(315.9 110.5)) 0.26)
dbCreateLabel(cv list("M4" "pin") list(324.33 109.875) "D3_CORE" "centerLeft" "R90" "roman" 2)
dbCreatePath(cv list("M3" "drawing") list(list(380.2 109.875) list(380.2 109.24)) 0.26)
dbCreatePath(cv list("M3" "drawing") list(list(371.725 109.875) list(371.725 109.24)) 0.26)
dbCreatePath(cv list("M3" "drawing") list(list(375.9 109.875) list(375.9 110.5)) 0.26)
dbCreateLabel(cv list("M4" "pin") list(384.33 109.875) "D4_CORE" "centerLeft" "R90" "roman" 2)
dbCreatePath(cv list("M3" "drawing") list(list(440.2 109.875) list(440.2 109.24)) 0.26)
dbCreatePath(cv list("M3" "drawing") list(list(431.725 109.875) list(431.725 109.24)) 0.26)
dbCreatePath(cv list("M3" "drawing") list(list(435.9 109.875) list(435.9 110.5)) 0.26)
dbCreateLabel(cv list("M4" "pin") list(444.33 109.875) "D5_CORE" "centerLeft" "R90" "roman" 2)
dbCreatePath(cv list("M3" "drawing") list(list(500.2 109.875) list(500.2 109.24)) 0.26)
dbCreatePath(cv list("M3" "drawing") list(list(491.725 109.875) list(491.725 109.24)) 0.26)
dbCreatePath(cv list("M3" "drawing") list(list(495.9 109.875) list(495.9 110.5)) 0.26)
dbCreateLabel(cv list("M4" "pin") list(504.33 109.875) "D6_CORE" "centerLeft" "R90" "roman" 2)
dbCreatePath(cv list("M3" "drawing") list(list(560.2 109.875) list(560.2 109.24)) 0.26)
dbCreatePath(cv list("M3" "drawing") list(list(551.725 109.875) list(551.725 109.24)) 0.26)
dbCreatePath(cv list("M3" "drawing") list(list(555.9 109.875) list(555.9 110.5)) 0.26)
dbCreateLabel(cv list("M4" "pin") list(564.33 109.875) "D7_CORE" "centerLeft" "R90" "roman" 2)
dbCreatePath(cv list("M3" "drawing") list(list(590.76 140.2) list(590.125 140.2)) 0.26)
dbCreatePath(cv list("M3" "drawing") list(list(590.76 131.725) list(590.125 131.725)) 0.26)
dbCreatePath(cv list("M3" "drawing") list(list(589.5 135.9) list(590.125 135.9)) 0.26)
dbCreateLabel(cv list("M4" "pin") list(590.125 144.33) "D8_CORE" "centerRight" "R0" "roman" 2)
dbCreatePath(cv list("M3" "drawing") list(list(590.76 200.2) list(590.125 200.2)) 0.26)
dbCreatePath(cv list("M3" "drawing") list(list(590.76 191.725) list(590.125 191.725)) 0.26)
dbCreatePath(cv list("M3" "drawing") list(list(589.5 195.9) list(590.125 195.9)) 0.26)
dbCreateLabel(cv list("M4" "pin") list(590.125 204.33) "D9_CORE" "centerRight" "R0" "roman" 2)
dbCreatePath(cv list("M3" "drawing") list(list(590.76 260.2) list(590.125 260.2)) 0.26)
dbCreatePath(cv list("M3" "drawing") list(list(590.76 251.725) list(590.125 251.725)) 0.26)
dbCreatePath(cv list("M3" "drawing") list(list(589.5 255.9) list(590.125 255.9)) 0.26)
dbCreateLabel(cv list("M4" "pin") list(590.125 264.33) "D10_CORE" "centerRight" "R0" "roman" 2)
dbCreatePath(cv list("M3" "drawing") list(list(590.76 320.2) list(590.125 320.2)) 0.26)
dbCreatePath(cv list("M3" "drawing") list(list(590.76 311.725) list(590.125 311.725)) 0.26)
dbCreatePath(cv list("M3" "drawing") list(list(589.5 315.9) list(590.125 315.9)) 0.26)
dbCreateLabel(cv list("M4" "pin") list(590.125 324.33) "D11_CORE" "centerRight" "R0" "roman" 2)
dbCreatePath(cv list("M3" "drawing") list(list(590.76 380.2) list(590.125 380.2)) 0.26)
dbCreatePath(cv list("M3" "drawing") list(list(590.76 371.725) list(590.125 371.725)) 0.26)
dbCreatePath(cv list("M3" "drawing") list(list(589.5 375.9) list(590.125 375.9)) 0.26)
dbCreateLabel(cv list("M4" "pin") list(590.125 384.33) "D12_CORE" "centerRight" "R0" "roman" 2)
dbCreatePath(cv list("M3" "drawing") list(list(590.76 440.2) list(590.125 440.2)) 0.26)
dbCreatePath(cv list("M3" "drawing") list(list(590.76 431.725) list(590.125 431.725)) 0.26)
dbCreatePath(cv list("M3" "drawing") list(list(589.5 435.9) list(590.125 435.9)) 0.26)
dbCreateLabel(cv list("M4" "pin") list(590.125 444.33) "D13_CORE" "centerRight" "R0" "roman" 2)
dbCreatePath(cv list("M3" "drawing") list(list(590.76 500.2) list(590.125 500.2)) 0.26)
dbCreatePath(cv list("M3" "drawing") list(list(590.76 491.725) list(590.125 491.725)) 0.26)
dbCreatePath(cv list("M3" "drawing") list(list(589.5 495.9) list(590.125 495.9)) 0.26)
dbCreateLabel(cv list("M4" "pin") list(590.125 504.33) "D14_CORE" "centerRight" "R0" "roman" 2)
dbCreatePath(cv list("M3" "drawing") list(list(590.76 560.2) list(590.125 560.2)) 0.26)
dbCreatePath(cv list("M3" "drawing") list(list(590.76 551.725) list(590.125 551.725)) 0.26)
dbCreatePath(cv list("M3" "drawing") list(list(589.5 555.9) list(590.125 555.9)) 0.26)
dbCreateLabel(cv list("M4" "pin") list(590.125 564.33) "D15_CORE" "centerRight" "R0" "roman" 2)
dbCreatePath(cv list("M3" "drawing") list(list(559.8 590.125) list(559.8 590.76)) 0.26)
dbCreatePath(cv list("M3" "drawing") list(list(568.275 590.125) list(568.275 590.76)) 0.26)
dbCreatePath(cv list("M3" "drawing") list(list(564.1 590.125) list(564.1 589.5)) 0.26)
dbCreateLabel(cv list("M4" "pin") list(555.67 590.125) "D16_CORE" "centerRight" "R90" "roman" 2)
dbCreatePath(cv list("M3" "drawing") list(list(499.8 590.125) list(499.8 590.76)) 0.26)
dbCreatePath(cv list("M3" "drawing") list(list(508.275 590.125) list(508.275 590.76)) 0.26)
dbCreatePath(cv list("M3" "drawing") list(list(504.1 590.125) list(504.1 589.5)) 0.26)
dbCreateLabel(cv list("M4" "pin") list(495.67 590.125) "D17_CORE" "centerRight" "R90" "roman" 2)
dbCreatePath(cv list("M3" "drawing") list(list(439.8 590.125) list(439.8 590.76)) 0.26)
dbCreatePath(cv list("M3" "drawing") list(list(448.275 590.125) list(448.275 590.76)) 0.26)
dbCreatePath(cv list("M3" "drawing") list(list(444.1 590.125) list(444.1 589.5)) 0.26)
dbCreateLabel(cv list("M4" "pin") list(435.67 590.125) "D18_CORE" "centerRight" "R90" "roman" 2)
dbCreatePath(cv list("M3" "drawing") list(list(379.8 590.125) list(379.8 590.76)) 0.26)
dbCreatePath(cv list("M3" "drawing") list(list(388.275 590.125) list(388.275 590.76)) 0.26)
dbCreatePath(cv list("M3" "drawing") list(list(384.1 590.125) list(384.1 589.5)) 0.26)
dbCreateLabel(cv list("M4" "pin") list(375.67 590.125) "D19_CORE" "centerRight" "R90" "roman" 2)
dbCreatePath(cv list("M3" "drawing") list(list(590.76 530.2) list(590.125 530.2)) 0.26)
dbCreatePath(cv list("M3" "drawing") list(list(590.76 521.725) list(590.125 521.725)) 0.26)
dbCreatePath(cv list("M3" "drawing") list(list(589.5 525.9) list(590.125 525.9)) 0.26)
dbCreateLabel(cv list("M4" "pin") list(590.125 534.33) "D24_CORE" "centerRight" "R0" "roman" 2)

; ==================== Pin Labels (with Inner Pad Support) ====================
dbCreateLabel(cv list("AP" "pin") list(-11 560) "VINP" "centerRight" "R0" "roman" 10)
dbCreateLabel(cv list("AP" "pin") list(-11 500) "VINN" "centerRight" "R0" "roman" 10)
dbCreateLabel(cv list("AP" "pin") list(-11 440) "VIP" "centerRight" "R0" "roman" 10)
dbCreateLabel(cv list("AP" "pin") list(-11 380) "VIM" "centerRight" "R0" "roman" 10)
dbCreateLabel(cv list("AP" "pin") list(-11 320) "VCM" "centerRight" "R0" "roman" 10)
dbCreateLabel(cv list("AP" "pin") list(-11 260) "VREF" "centerRight" "R0" "roman" 10)
dbCreateLabel(cv list("AP" "pin") list(-11 200) "AVDD" "centerRight" "R0" "roman" 10)
dbCreateLabel(cv list("M2" "pin") list(109.9 200) "AVDD_CORE" "centerLeft" "R0" "roman" 2)
dbCreateLabel(cv list("AP" "pin") list(-11 140) "AVSS" "centerRight" "R0" "roman" 10)
dbCreateLabel(cv list("M2" "pin") list(109.9 140) "AVSS_CORE" "centerLeft" "R0" "roman" 2)
dbCreateLabel(cv list("AP" "pin") list(140 -11) "D0" "centerRight" "R90" "roman" 10)
dbCreateLabel(cv list("AP" "pin") list(200 -11) "D1" "centerRight" "R90" "roman" 10)
dbCreateLabel(cv list("AP" "pin") list(260 -11) "D2" "centerRight" "R90" "roman" 10)
dbCreateLabel(cv list("AP" "pin") list(320 -11) "D3" "centerRight" "R90" "roman" 10)
dbCreateLabel(cv list("AP" "pin") list(380 -11) "D4" "centerRight" "R90" "roman" 10)
dbCreateLabel(cv list("AP" "pin") list(440 -11) "D5" "centerRight" "R90" "roman" 10)
dbCreateLabel(cv list("AP" "pin") list(500 -11) "D6" "centerRight" "R90" "roman" 10)
dbCreateLabel(cv list("AP" "pin") list(560 -11) "D7" "centerRight" "R90" "roman" 10)
dbCreateLabel(cv list("AP" "pin") list(711 140) "D8" "centerLeft" "R0" "roman" 10)
dbCreateLabel(cv list("AP" "pin") list(711 200) "D9" "centerLeft" "R0" "roman" 10)
dbCreateLabel(cv list("AP" "pin") list(711 260) "D10" "centerLeft" "R0" "roman" 10)
dbCreateLabel(cv list("AP" "pin") list(711 320) "D11" "centerLeft" "R0" "roman" 10)
dbCreateLabel(cv list("AP" "pin") list(711 380) "D12" "centerLeft" "R0" "roman" 10)
dbCreateLabel(cv list("AP" "pin") list(711 440) "D13" "centerLeft" "R0" "roman" 10)
dbCreateLabel(cv list("AP" "pin") list(711 500) "D14" "centerLeft" "R0" "roman" 10)
dbCreateLabel(cv list("AP" "pin") list(711 560) "D15" "centerLeft" "R0" "roman" 10)
dbCreateLabel(cv list("AP" "pin") list(560 711) "D16" "centerLeft" "R90" "roman" 10)
dbCreateLabel(cv list("AP" "pin") list(500 711) "D17" "centerLeft" "R90" "roman" 10)
dbCreateLabel(cv list("AP" "pin") list(440 711) "D18" "centerLeft" "R90" "roman" 10)
dbCreateLabel(cv list("AP" "pin") list(380 711) "D19" "centerLeft" "R90" "roman" 10)
dbCreateLabel(cv list("AP" "pin") list(320 711) "VIOL" "centerLeft" "R90" "roman" 10)
dbCreateLabel(cv list("AP" "pin") list(260 711) "GIOL" "centerLeft" "R90" "roman" 10)
dbCreateLabel(cv list("AP" "pin") list(200 711) "VIOH" "centerLeft" "R90" "roman" 10)
dbCreateLabel(cv list("AP" "pin") list(140 711) "GIOH" "centerLeft" "R90" "roman" 10)
dbCreateLabel(cv list("AP" "pin") list(152 290) "VREF_CORE" "centerLeft" "R0" "roman" 10)
dbCreateLabel(cv list("AP" "pin") list(548 530) "D24" "centerRight" "R0" "roman" 10)
dbCreateLabel(cv list("AP" "pin") list(152 530) "VAMP_CORE" "centerLeft" "R0" "roman" 10)

dbSave(cv)
t
