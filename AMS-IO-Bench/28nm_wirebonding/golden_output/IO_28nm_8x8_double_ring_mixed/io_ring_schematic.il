pdb3ac_h_gMaster = dbOpenCellView("tphn28hpcpgv18" "PDB3AC_H_G" "symbol")
dbCreateInst(cv pdb3ac_h_gMaster "VINP_left0" '(0 16.8125) "R270")
schCreateWire(cv "route" "full" '((0.000 17.000) (-0.750 17.000)) 0 0 0 nil nil)
schCreateWireLabel(cv nil '(-0.250 17.000) "VINP" "lowerRight" "R0" "stick" 0.0625 nil)
schCreatePin(cv nil "VINP" "inputOutput" nil '(-0.750 17.000) "R0")
schCreateWire(cv "route" "full" '((0.875 17.062) (1.625 17.062)) 0 0 0 nil nil)
schCreateWireLabel(cv nil '(1.125 17.062) "AVSS" "lowerLeft" "R0" "stick" 0.0625 nil)
schCreateWire(cv "route" "full" '((0.875 16.688) (1.625 16.688)) 0 0 0 nil nil)
schCreateWireLabel(cv nil '(1.125 16.688) "GIOL" "lowerLeft" "R0" "stick" 0.0625 nil)
schCreateWire(cv "route" "full" '((0.875 17.438) (1.625 17.438)) 0 0 0 nil nil)
schCreateWireLabel(cv nil '(1.125 17.438) "AVDD" "lowerLeft" "R0" "stick" 0.0625 nil)
dbCreateInst(cv pdb3ac_h_gMaster "VINN_left1" '(0 14.8125) "R270")
schCreateWire(cv "route" "full" '((0.000 15.001) (-0.750 15.001)) 0 0 0 nil nil)
schCreateWireLabel(cv nil '(-0.250 15.001) "VINN" "lowerRight" "R0" "stick" 0.0625 nil)
schCreatePin(cv nil "VINN" "inputOutput" nil '(-0.750 15.001) "R0")
schCreateWire(cv "route" "full" '((0.875 15.062) (1.625 15.062)) 0 0 0 nil nil)
schCreateWireLabel(cv nil '(1.125 15.062) "AVSS" "lowerLeft" "R0" "stick" 0.0625 nil)
schCreateWire(cv "route" "full" '((0.875 14.688) (1.625 14.688)) 0 0 0 nil nil)
schCreateWireLabel(cv nil '(1.125 14.688) "GIOL" "lowerLeft" "R0" "stick" 0.0625 nil)
schCreateWire(cv "route" "full" '((0.875 15.438) (1.625 15.438)) 0 0 0 nil nil)
schCreateWireLabel(cv nil '(1.125 15.438) "AVDD" "lowerLeft" "R0" "stick" 0.0625 nil)
dbCreateInst(cv pdb3ac_h_gMaster "VIP_left2" '(0 12.8125) "R270")
schCreateWire(cv "route" "full" '((0.000 13.001) (-0.750 13.001)) 0 0 0 nil nil)
schCreateWireLabel(cv nil '(-0.250 13.001) "VIP" "lowerRight" "R0" "stick" 0.0625 nil)
schCreatePin(cv nil "VIP" "inputOutput" nil '(-0.750 13.001) "R0")
schCreateWire(cv "route" "full" '((0.875 13.062) (1.625 13.062)) 0 0 0 nil nil)
schCreateWireLabel(cv nil '(1.125 13.062) "AVSS" "lowerLeft" "R0" "stick" 0.0625 nil)
schCreateWire(cv "route" "full" '((0.875 12.688) (1.625 12.688)) 0 0 0 nil nil)
schCreateWireLabel(cv nil '(1.125 12.688) "GIOL" "lowerLeft" "R0" "stick" 0.0625 nil)
schCreateWire(cv "route" "full" '((0.875 13.438) (1.625 13.438)) 0 0 0 nil nil)
schCreateWireLabel(cv nil '(1.125 13.438) "AVDD" "lowerLeft" "R0" "stick" 0.0625 nil)
dbCreateInst(cv pdb3ac_h_gMaster "VIM_left3" '(0 10.8125) "R270")
schCreateWire(cv "route" "full" '((0.000 11.001) (-0.750 11.001)) 0 0 0 nil nil)
schCreateWireLabel(cv nil '(-0.250 11.001) "VIM" "lowerRight" "R0" "stick" 0.0625 nil)
schCreatePin(cv nil "VIM" "inputOutput" nil '(-0.750 11.001) "R0")
schCreateWire(cv "route" "full" '((0.875 11.062) (1.625 11.062)) 0 0 0 nil nil)
schCreateWireLabel(cv nil '(1.125 11.062) "AVSS" "lowerLeft" "R0" "stick" 0.0625 nil)
schCreateWire(cv "route" "full" '((0.875 10.688) (1.625 10.688)) 0 0 0 nil nil)
schCreateWireLabel(cv nil '(1.125 10.688) "GIOL" "lowerLeft" "R0" "stick" 0.0625 nil)
schCreateWire(cv "route" "full" '((0.875 11.438) (1.625 11.438)) 0 0 0 nil nil)
schCreateWireLabel(cv nil '(1.125 11.438) "AVDD" "lowerLeft" "R0" "stick" 0.0625 nil)
dbCreateInst(cv pdb3ac_h_gMaster "VCM_left4" '(0 8.8125) "R270")
schCreateWire(cv "route" "full" '((0.000 9.001) (-0.750 9.001)) 0 0 0 nil nil)
schCreateWireLabel(cv nil '(-0.250 9.001) "VCM" "lowerRight" "R0" "stick" 0.0625 nil)
schCreatePin(cv nil "VCM" "inputOutput" nil '(-0.750 9.001) "R0")
schCreateWire(cv "route" "full" '((0.875 9.062) (1.625 9.062)) 0 0 0 nil nil)
schCreateWireLabel(cv nil '(1.125 9.062) "AVSS" "lowerLeft" "R0" "stick" 0.0625 nil)
schCreateWire(cv "route" "full" '((0.875 8.688) (1.625 8.688)) 0 0 0 nil nil)
schCreateWireLabel(cv nil '(1.125 8.688) "GIOL" "lowerLeft" "R0" "stick" 0.0625 nil)
schCreateWire(cv "route" "full" '((0.875 9.438) (1.625 9.438)) 0 0 0 nil nil)
schCreateWireLabel(cv nil '(1.125 9.438) "AVDD" "lowerLeft" "R0" "stick" 0.0625 nil)
dbCreateInst(cv pdb3ac_h_gMaster "VREF_left5" '(0 6.8125) "R270")
schCreateWire(cv "route" "full" '((0.000 7.000) (-0.750 7.000)) 0 0 0 nil nil)
schCreateWireLabel(cv nil '(-0.250 7.000) "VREF" "lowerRight" "R0" "stick" 0.0625 nil)
schCreatePin(cv nil "VREF" "inputOutput" nil '(-0.750 7.000) "R0")
schCreateWire(cv "route" "full" '((0.875 7.062) (1.625 7.062)) 0 0 0 nil nil)
schCreateWireLabel(cv nil '(1.125 7.062) "AVSS" "lowerLeft" "R0" "stick" 0.0625 nil)
schCreateWire(cv "route" "full" '((0.875 6.688) (1.625 6.688)) 0 0 0 nil nil)
schCreateWireLabel(cv nil '(1.125 6.688) "GIOL" "lowerLeft" "R0" "stick" 0.0625 nil)
schCreateWire(cv "route" "full" '((0.875 7.438) (1.625 7.438)) 0 0 0 nil nil)
schCreateWireLabel(cv nil '(1.125 7.438) "AVDD" "lowerLeft" "R0" "stick" 0.0625 nil)
pvdd3ac_h_gMaster = dbOpenCellView("tphn28hpcpgv18" "PVDD3AC_H_G" "symbol")
dbCreateInst(cv pvdd3ac_h_gMaster "AVDD_left6" '(0 4.8125) "R270")
schCreateWire(cv "route" "full" '((0.875 5.438) (1.625 5.438)) 0 0 0 nil nil)
schCreateWireLabel(cv nil '(1.125 5.438) "AVDD_CORE" "lowerLeft" "R0" "stick" 0.0625 nil)
schCreatePin(cv nil "AVDD_CORE" "inputOutput" nil '(1.625 5.438) "R180")
schCreateWire(cv "route" "full" '((0.875 5.062) (1.625 5.062)) 0 0 0 nil nil)
schCreateWireLabel(cv nil '(1.125 5.062) "AVSS" "lowerLeft" "R0" "stick" 0.0625 nil)
schCreateWire(cv "route" "full" '((0.875 4.688) (1.625 4.688)) 0 0 0 nil nil)
schCreateWireLabel(cv nil '(1.125 4.688) "GIOL" "lowerLeft" "R0" "stick" 0.0625 nil)
schCreateWire(cv "route" "full" '((0.000 5.000) (-0.750 5.000)) 0 0 0 nil nil)
schCreateWireLabel(cv nil '(-0.250 5.000) "AVDD" "lowerRight" "R0" "stick" 0.0625 nil)
schCreatePin(cv nil "AVDD" "inputOutput" nil '(-0.750 5.000) "R0")
pvss3ac_h_gMaster = dbOpenCellView("tphn28hpcpgv18" "PVSS3AC_H_G" "symbol")
dbCreateInst(cv pvss3ac_h_gMaster "AVSS_left7" '(0 2.8125) "R270")
schCreateWire(cv "route" "full" '((0.000 3.001) (-0.750 3.001)) 0 0 0 nil nil)
schCreateWireLabel(cv nil '(-0.250 3.001) "AVSS" "lowerRight" "R0" "stick" 0.0625 nil)
schCreatePin(cv nil "AVSS" "inputOutput" nil '(-0.750 3.001) "R0")
schCreateWire(cv "route" "full" '((0.875 2.688) (1.625 2.688)) 0 0 0 nil nil)
schCreateWireLabel(cv nil '(1.125 2.688) "GIOL" "lowerLeft" "R0" "stick" 0.0625 nil)
schCreateWire(cv "route" "full" '((0.875 3.438) (1.625 3.438)) 0 0 0 nil nil)
schCreateWireLabel(cv nil '(1.125 3.438) "AVSS_CORE" "lowerLeft" "R0" "stick" 0.0625 nil)
schCreatePin(cv nil "AVSS_CORE" "inputOutput" nil '(1.625 3.438) "R180")
schCreateWire(cv "route" "full" '((0.875 3.062) (1.625 3.062)) 0 0 0 nil nil)
schCreateWireLabel(cv nil '(1.125 3.062) "AVDD" "lowerLeft" "R0" "stick" 0.0625 nil)
pddw16sdgz_v_gMaster = dbOpenCellView("tphn28hpcpgv18" "PDDW16SDGZ_V_G" "symbol")
dbCreateInst(cv pddw16sdgz_v_gMaster "D0_bottom0" '(2.3125 0) "R0")
schCreateWire(cv "route" "full" '((2.438 1.000) (2.438 1.750)) 0 0 0 nil nil)
schCreateWireLabel(cv nil '(2.438 1.250) "GIOL" "lowerLeft" "R90" "stick" 0.0625 nil)
schCreateWire(cv "route" "full" '((2.562 1.000) (2.562 1.750)) 0 0 0 nil nil)
schCreateWireLabel(cv nil '(2.562 1.250) "D0_CORE" "lowerLeft" "R90" "stick" 0.0625 nil)
schCreatePin(cv nil "D0_CORE" "inputOutput" nil '(2.562 1.750) "R270")
schCreateWire(cv "route" "full" '((2.188 1.000) (2.188 1.750)) 0 0 0 nil nil)
schCreateWireLabel(cv nil '(2.188 1.250) "VIOL" "lowerLeft" "R90" "stick" 0.0625 nil)
schCreateWire(cv "route" "full" '((2.062 1.000) (2.062 1.750)) 0 0 0 nil nil)
schCreateWireLabel(cv nil '(2.062 1.250) "GIOL" "lowerLeft" "R90" "stick" 0.0625 nil)
schCreateWire(cv "route" "full" '((3.000 0.000) (3.000 -0.750)) 0 0 0 nil nil)
schCreateWireLabel(cv nil '(3.000 -0.250) "D0" "lowerRight" "R90" "stick" 0.0625 nil)
schCreatePin(cv nil "D0" "inputOutput" nil '(3.000 -0.750) "R90")
schCreateWire(cv "route" "full" '((2.688 1.000) (2.688 1.750)) 0 0 0 nil nil)
schCreateWireLabel(cv nil '(2.688 1.250) "POC" "lowerLeft" "R90" "stick" 0.0625 nil)
schCreateWire(cv "route" "full" '((2.875 1.000) (2.875 1.750)) 0 0 0 nil nil)
schCreateWireLabel(cv nil '(2.875 1.250) "VIOL" "lowerLeft" "R90" "stick" 0.0625 nil)
schCreateWire(cv "route" "full" '((3.062 1.000) (3.062 1.750)) 0 0 0 nil nil)
schCreateWireLabel(cv nil '(3.062 1.250) "GIOL" "lowerLeft" "R90" "stick" 0.0625 nil)
schCreateWire(cv "route" "full" '((3.250 1.000) (3.250 1.750)) 0 0 0 nil nil)
schCreateWireLabel(cv nil '(3.250 1.250) "VIOH" "lowerLeft" "R90" "stick" 0.0625 nil)
schCreateWire(cv "route" "full" '((3.625 1.000) (3.625 1.750)) 0 0 0 nil nil)
schCreateWireLabel(cv nil '(3.625 1.250) "GIOH" "lowerLeft" "R90" "stick" 0.0625 nil)
dbCreateInst(cv pddw16sdgz_v_gMaster "D1_bottom1" '(4.3125 0) "R0")
schCreateWire(cv "route" "full" '((4.438 1.000) (4.438 1.750)) 0 0 0 nil nil)
schCreateWireLabel(cv nil '(4.438 1.250) "GIOL" "lowerLeft" "R90" "stick" 0.0625 nil)
schCreateWire(cv "route" "full" '((4.562 1.000) (4.562 1.750)) 0 0 0 nil nil)
schCreateWireLabel(cv nil '(4.562 1.250) "D1_CORE" "lowerLeft" "R90" "stick" 0.0625 nil)
schCreatePin(cv nil "D1_CORE" "inputOutput" nil '(4.562 1.750) "R270")
schCreateWire(cv "route" "full" '((4.188 1.000) (4.188 1.750)) 0 0 0 nil nil)
schCreateWireLabel(cv nil '(4.188 1.250) "VIOL" "lowerLeft" "R90" "stick" 0.0625 nil)
schCreateWire(cv "route" "full" '((4.062 1.000) (4.062 1.750)) 0 0 0 nil nil)
schCreateWireLabel(cv nil '(4.062 1.250) "GIOL" "lowerLeft" "R90" "stick" 0.0625 nil)
schCreateWire(cv "route" "full" '((5.000 0.000) (5.000 -0.750)) 0 0 0 nil nil)
schCreateWireLabel(cv nil '(5.000 -0.250) "D1" "lowerRight" "R90" "stick" 0.0625 nil)
schCreatePin(cv nil "D1" "inputOutput" nil '(5.000 -0.750) "R90")
schCreateWire(cv "route" "full" '((4.688 1.000) (4.688 1.750)) 0 0 0 nil nil)
schCreateWireLabel(cv nil '(4.688 1.250) "POC" "lowerLeft" "R90" "stick" 0.0625 nil)
schCreateWire(cv "route" "full" '((4.875 1.000) (4.875 1.750)) 0 0 0 nil nil)
schCreateWireLabel(cv nil '(4.875 1.250) "VIOL" "lowerLeft" "R90" "stick" 0.0625 nil)
schCreateWire(cv "route" "full" '((5.062 1.000) (5.062 1.750)) 0 0 0 nil nil)
schCreateWireLabel(cv nil '(5.062 1.250) "GIOL" "lowerLeft" "R90" "stick" 0.0625 nil)
schCreateWire(cv "route" "full" '((5.250 1.000) (5.250 1.750)) 0 0 0 nil nil)
schCreateWireLabel(cv nil '(5.250 1.250) "VIOH" "lowerLeft" "R90" "stick" 0.0625 nil)
schCreateWire(cv "route" "full" '((5.625 1.000) (5.625 1.750)) 0 0 0 nil nil)
schCreateWireLabel(cv nil '(5.625 1.250) "GIOH" "lowerLeft" "R90" "stick" 0.0625 nil)
dbCreateInst(cv pddw16sdgz_v_gMaster "D2_bottom2" '(6.3125 0) "R0")
schCreateWire(cv "route" "full" '((6.438 1.000) (6.438 1.750)) 0 0 0 nil nil)
schCreateWireLabel(cv nil '(6.438 1.250) "GIOL" "lowerLeft" "R90" "stick" 0.0625 nil)
schCreateWire(cv "route" "full" '((6.562 1.000) (6.562 1.750)) 0 0 0 nil nil)
schCreateWireLabel(cv nil '(6.562 1.250) "D2_CORE" "lowerLeft" "R90" "stick" 0.0625 nil)
schCreatePin(cv nil "D2_CORE" "inputOutput" nil '(6.562 1.750) "R270")
schCreateWire(cv "route" "full" '((6.188 1.000) (6.188 1.750)) 0 0 0 nil nil)
schCreateWireLabel(cv nil '(6.188 1.250) "VIOL" "lowerLeft" "R90" "stick" 0.0625 nil)
schCreateWire(cv "route" "full" '((6.062 1.000) (6.062 1.750)) 0 0 0 nil nil)
schCreateWireLabel(cv nil '(6.062 1.250) "GIOL" "lowerLeft" "R90" "stick" 0.0625 nil)
schCreateWire(cv "route" "full" '((7.000 0.000) (7.000 -0.750)) 0 0 0 nil nil)
schCreateWireLabel(cv nil '(7.000 -0.250) "D2" "lowerRight" "R90" "stick" 0.0625 nil)
schCreatePin(cv nil "D2" "inputOutput" nil '(7.000 -0.750) "R90")
schCreateWire(cv "route" "full" '((6.688 1.000) (6.688 1.750)) 0 0 0 nil nil)
schCreateWireLabel(cv nil '(6.688 1.250) "POC" "lowerLeft" "R90" "stick" 0.0625 nil)
schCreateWire(cv "route" "full" '((6.875 1.000) (6.875 1.750)) 0 0 0 nil nil)
schCreateWireLabel(cv nil '(6.875 1.250) "VIOL" "lowerLeft" "R90" "stick" 0.0625 nil)
schCreateWire(cv "route" "full" '((7.062 1.000) (7.062 1.750)) 0 0 0 nil nil)
schCreateWireLabel(cv nil '(7.062 1.250) "GIOL" "lowerLeft" "R90" "stick" 0.0625 nil)
schCreateWire(cv "route" "full" '((7.250 1.000) (7.250 1.750)) 0 0 0 nil nil)
schCreateWireLabel(cv nil '(7.250 1.250) "VIOH" "lowerLeft" "R90" "stick" 0.0625 nil)
schCreateWire(cv "route" "full" '((7.625 1.000) (7.625 1.750)) 0 0 0 nil nil)
schCreateWireLabel(cv nil '(7.625 1.250) "GIOH" "lowerLeft" "R90" "stick" 0.0625 nil)
dbCreateInst(cv pddw16sdgz_v_gMaster "D3_bottom3" '(8.3125 0) "R0")
schCreateWire(cv "route" "full" '((8.438 1.000) (8.438 1.750)) 0 0 0 nil nil)
schCreateWireLabel(cv nil '(8.438 1.250) "GIOL" "lowerLeft" "R90" "stick" 0.0625 nil)
schCreateWire(cv "route" "full" '((8.562 1.000) (8.562 1.750)) 0 0 0 nil nil)
schCreateWireLabel(cv nil '(8.562 1.250) "D3_CORE" "lowerLeft" "R90" "stick" 0.0625 nil)
schCreatePin(cv nil "D3_CORE" "inputOutput" nil '(8.562 1.750) "R270")
schCreateWire(cv "route" "full" '((8.188 1.000) (8.188 1.750)) 0 0 0 nil nil)
schCreateWireLabel(cv nil '(8.188 1.250) "VIOL" "lowerLeft" "R90" "stick" 0.0625 nil)
schCreateWire(cv "route" "full" '((8.062 1.000) (8.062 1.750)) 0 0 0 nil nil)
schCreateWireLabel(cv nil '(8.062 1.250) "GIOL" "lowerLeft" "R90" "stick" 0.0625 nil)
schCreateWire(cv "route" "full" '((9.001 0.000) (9.001 -0.750)) 0 0 0 nil nil)
schCreateWireLabel(cv nil '(9.001 -0.250) "D3" "lowerRight" "R90" "stick" 0.0625 nil)
schCreatePin(cv nil "D3" "inputOutput" nil '(9.001 -0.750) "R90")
schCreateWire(cv "route" "full" '((8.688 1.000) (8.688 1.750)) 0 0 0 nil nil)
schCreateWireLabel(cv nil '(8.688 1.250) "POC" "lowerLeft" "R90" "stick" 0.0625 nil)
schCreateWire(cv "route" "full" '((8.874 1.000) (8.874 1.750)) 0 0 0 nil nil)
schCreateWireLabel(cv nil '(8.874 1.250) "VIOL" "lowerLeft" "R90" "stick" 0.0625 nil)
schCreateWire(cv "route" "full" '((9.062 1.000) (9.062 1.750)) 0 0 0 nil nil)
schCreateWireLabel(cv nil '(9.062 1.250) "GIOL" "lowerLeft" "R90" "stick" 0.0625 nil)
schCreateWire(cv "route" "full" '((9.251 1.000) (9.251 1.750)) 0 0 0 nil nil)
schCreateWireLabel(cv nil '(9.251 1.250) "VIOH" "lowerLeft" "R90" "stick" 0.0625 nil)
schCreateWire(cv "route" "full" '((9.624 1.000) (9.624 1.750)) 0 0 0 nil nil)
schCreateWireLabel(cv nil '(9.624 1.250) "GIOH" "lowerLeft" "R90" "stick" 0.0625 nil)
dbCreateInst(cv pddw16sdgz_v_gMaster "D4_bottom4" '(10.3125 0) "R0")
schCreateWire(cv "route" "full" '((10.438 1.000) (10.438 1.750)) 0 0 0 nil nil)
schCreateWireLabel(cv nil '(10.438 1.250) "GIOL" "lowerLeft" "R90" "stick" 0.0625 nil)
schCreateWire(cv "route" "full" '((10.562 1.000) (10.562 1.750)) 0 0 0 nil nil)
schCreateWireLabel(cv nil '(10.562 1.250) "D4_CORE" "lowerLeft" "R90" "stick" 0.0625 nil)
schCreatePin(cv nil "D4_CORE" "inputOutput" nil '(10.562 1.750) "R270")
schCreateWire(cv "route" "full" '((10.188 1.000) (10.188 1.750)) 0 0 0 nil nil)
schCreateWireLabel(cv nil '(10.188 1.250) "VIOL" "lowerLeft" "R90" "stick" 0.0625 nil)
schCreateWire(cv "route" "full" '((10.062 1.000) (10.062 1.750)) 0 0 0 nil nil)
schCreateWireLabel(cv nil '(10.062 1.250) "GIOL" "lowerLeft" "R90" "stick" 0.0625 nil)
schCreateWire(cv "route" "full" '((11.001 0.000) (11.001 -0.750)) 0 0 0 nil nil)
schCreateWireLabel(cv nil '(11.001 -0.250) "D4" "lowerRight" "R90" "stick" 0.0625 nil)
schCreatePin(cv nil "D4" "inputOutput" nil '(11.001 -0.750) "R90")
schCreateWire(cv "route" "full" '((10.688 1.000) (10.688 1.750)) 0 0 0 nil nil)
schCreateWireLabel(cv nil '(10.688 1.250) "POC" "lowerLeft" "R90" "stick" 0.0625 nil)
schCreateWire(cv "route" "full" '((10.874 1.000) (10.874 1.750)) 0 0 0 nil nil)
schCreateWireLabel(cv nil '(10.874 1.250) "VIOL" "lowerLeft" "R90" "stick" 0.0625 nil)
schCreateWire(cv "route" "full" '((11.062 1.000) (11.062 1.750)) 0 0 0 nil nil)
schCreateWireLabel(cv nil '(11.062 1.250) "GIOL" "lowerLeft" "R90" "stick" 0.0625 nil)
schCreateWire(cv "route" "full" '((11.251 1.000) (11.251 1.750)) 0 0 0 nil nil)
schCreateWireLabel(cv nil '(11.251 1.250) "VIOH" "lowerLeft" "R90" "stick" 0.0625 nil)
schCreateWire(cv "route" "full" '((11.624 1.000) (11.624 1.750)) 0 0 0 nil nil)
schCreateWireLabel(cv nil '(11.624 1.250) "GIOH" "lowerLeft" "R90" "stick" 0.0625 nil)
dbCreateInst(cv pddw16sdgz_v_gMaster "D5_bottom5" '(12.3125 0) "R0")
schCreateWire(cv "route" "full" '((12.438 1.000) (12.438 1.750)) 0 0 0 nil nil)
schCreateWireLabel(cv nil '(12.438 1.250) "GIOL" "lowerLeft" "R90" "stick" 0.0625 nil)
schCreateWire(cv "route" "full" '((12.562 1.000) (12.562 1.750)) 0 0 0 nil nil)
schCreateWireLabel(cv nil '(12.562 1.250) "D5_CORE" "lowerLeft" "R90" "stick" 0.0625 nil)
schCreatePin(cv nil "D5_CORE" "inputOutput" nil '(12.562 1.750) "R270")
schCreateWire(cv "route" "full" '((12.188 1.000) (12.188 1.750)) 0 0 0 nil nil)
schCreateWireLabel(cv nil '(12.188 1.250) "VIOL" "lowerLeft" "R90" "stick" 0.0625 nil)
schCreateWire(cv "route" "full" '((12.062 1.000) (12.062 1.750)) 0 0 0 nil nil)
schCreateWireLabel(cv nil '(12.062 1.250) "GIOL" "lowerLeft" "R90" "stick" 0.0625 nil)
schCreateWire(cv "route" "full" '((13.001 0.000) (13.001 -0.750)) 0 0 0 nil nil)
schCreateWireLabel(cv nil '(13.001 -0.250) "D5" "lowerRight" "R90" "stick" 0.0625 nil)
schCreatePin(cv nil "D5" "inputOutput" nil '(13.001 -0.750) "R90")
schCreateWire(cv "route" "full" '((12.688 1.000) (12.688 1.750)) 0 0 0 nil nil)
schCreateWireLabel(cv nil '(12.688 1.250) "POC" "lowerLeft" "R90" "stick" 0.0625 nil)
schCreateWire(cv "route" "full" '((12.874 1.000) (12.874 1.750)) 0 0 0 nil nil)
schCreateWireLabel(cv nil '(12.874 1.250) "VIOL" "lowerLeft" "R90" "stick" 0.0625 nil)
schCreateWire(cv "route" "full" '((13.062 1.000) (13.062 1.750)) 0 0 0 nil nil)
schCreateWireLabel(cv nil '(13.062 1.250) "GIOL" "lowerLeft" "R90" "stick" 0.0625 nil)
schCreateWire(cv "route" "full" '((13.251 1.000) (13.251 1.750)) 0 0 0 nil nil)
schCreateWireLabel(cv nil '(13.251 1.250) "VIOH" "lowerLeft" "R90" "stick" 0.0625 nil)
schCreateWire(cv "route" "full" '((13.624 1.000) (13.624 1.750)) 0 0 0 nil nil)
schCreateWireLabel(cv nil '(13.624 1.250) "GIOH" "lowerLeft" "R90" "stick" 0.0625 nil)
dbCreateInst(cv pddw16sdgz_v_gMaster "D6_bottom6" '(14.3125 0) "R0")
schCreateWire(cv "route" "full" '((14.438 1.000) (14.438 1.750)) 0 0 0 nil nil)
schCreateWireLabel(cv nil '(14.438 1.250) "GIOL" "lowerLeft" "R90" "stick" 0.0625 nil)
schCreateWire(cv "route" "full" '((14.562 1.000) (14.562 1.750)) 0 0 0 nil nil)
schCreateWireLabel(cv nil '(14.562 1.250) "D6_CORE" "lowerLeft" "R90" "stick" 0.0625 nil)
schCreatePin(cv nil "D6_CORE" "inputOutput" nil '(14.562 1.750) "R270")
schCreateWire(cv "route" "full" '((14.188 1.000) (14.188 1.750)) 0 0 0 nil nil)
schCreateWireLabel(cv nil '(14.188 1.250) "VIOL" "lowerLeft" "R90" "stick" 0.0625 nil)
schCreateWire(cv "route" "full" '((14.062 1.000) (14.062 1.750)) 0 0 0 nil nil)
schCreateWireLabel(cv nil '(14.062 1.250) "GIOL" "lowerLeft" "R90" "stick" 0.0625 nil)
schCreateWire(cv "route" "full" '((15.001 0.000) (15.001 -0.750)) 0 0 0 nil nil)
schCreateWireLabel(cv nil '(15.001 -0.250) "D6" "lowerRight" "R90" "stick" 0.0625 nil)
schCreatePin(cv nil "D6" "inputOutput" nil '(15.001 -0.750) "R90")
schCreateWire(cv "route" "full" '((14.688 1.000) (14.688 1.750)) 0 0 0 nil nil)
schCreateWireLabel(cv nil '(14.688 1.250) "POC" "lowerLeft" "R90" "stick" 0.0625 nil)
schCreateWire(cv "route" "full" '((14.874 1.000) (14.874 1.750)) 0 0 0 nil nil)
schCreateWireLabel(cv nil '(14.874 1.250) "VIOL" "lowerLeft" "R90" "stick" 0.0625 nil)
schCreateWire(cv "route" "full" '((15.062 1.000) (15.062 1.750)) 0 0 0 nil nil)
schCreateWireLabel(cv nil '(15.062 1.250) "GIOL" "lowerLeft" "R90" "stick" 0.0625 nil)
schCreateWire(cv "route" "full" '((15.251 1.000) (15.251 1.750)) 0 0 0 nil nil)
schCreateWireLabel(cv nil '(15.251 1.250) "VIOH" "lowerLeft" "R90" "stick" 0.0625 nil)
schCreateWire(cv "route" "full" '((15.624 1.000) (15.624 1.750)) 0 0 0 nil nil)
schCreateWireLabel(cv nil '(15.624 1.250) "GIOH" "lowerLeft" "R90" "stick" 0.0625 nil)
dbCreateInst(cv pddw16sdgz_v_gMaster "D7_bottom7" '(16.3125 0) "R0")
schCreateWire(cv "route" "full" '((16.438 1.000) (16.438 1.750)) 0 0 0 nil nil)
schCreateWireLabel(cv nil '(16.438 1.250) "GIOL" "lowerLeft" "R90" "stick" 0.0625 nil)
schCreateWire(cv "route" "full" '((16.562 1.000) (16.562 1.750)) 0 0 0 nil nil)
schCreateWireLabel(cv nil '(16.562 1.250) "D7_CORE" "lowerLeft" "R90" "stick" 0.0625 nil)
schCreatePin(cv nil "D7_CORE" "inputOutput" nil '(16.562 1.750) "R270")
schCreateWire(cv "route" "full" '((16.188 1.000) (16.188 1.750)) 0 0 0 nil nil)
schCreateWireLabel(cv nil '(16.188 1.250) "VIOL" "lowerLeft" "R90" "stick" 0.0625 nil)
schCreateWire(cv "route" "full" '((16.062 1.000) (16.062 1.750)) 0 0 0 nil nil)
schCreateWireLabel(cv nil '(16.062 1.250) "GIOL" "lowerLeft" "R90" "stick" 0.0625 nil)
schCreateWire(cv "route" "full" '((17.000 0.000) (17.000 -0.750)) 0 0 0 nil nil)
schCreateWireLabel(cv nil '(17.000 -0.250) "D7" "lowerRight" "R90" "stick" 0.0625 nil)
schCreatePin(cv nil "D7" "inputOutput" nil '(17.000 -0.750) "R90")
schCreateWire(cv "route" "full" '((16.688 1.000) (16.688 1.750)) 0 0 0 nil nil)
schCreateWireLabel(cv nil '(16.688 1.250) "POC" "lowerLeft" "R90" "stick" 0.0625 nil)
schCreateWire(cv "route" "full" '((16.875 1.000) (16.875 1.750)) 0 0 0 nil nil)
schCreateWireLabel(cv nil '(16.875 1.250) "VIOL" "lowerLeft" "R90" "stick" 0.0625 nil)
schCreateWire(cv "route" "full" '((17.062 1.000) (17.062 1.750)) 0 0 0 nil nil)
schCreateWireLabel(cv nil '(17.062 1.250) "GIOL" "lowerLeft" "R90" "stick" 0.0625 nil)
schCreateWire(cv "route" "full" '((17.250 1.000) (17.250 1.750)) 0 0 0 nil nil)
schCreateWireLabel(cv nil '(17.250 1.250) "VIOH" "lowerLeft" "R90" "stick" 0.0625 nil)
schCreateWire(cv "route" "full" '((17.625 1.000) (17.625 1.750)) 0 0 0 nil nil)
schCreateWireLabel(cv nil '(17.625 1.250) "GIOH" "lowerLeft" "R90" "stick" 0.0625 nil)
pddw16sdgz_h_gMaster = dbOpenCellView("tphn28hpcpgv18" "PDDW16SDGZ_H_G" "symbol")
dbCreateInst(cv pddw16sdgz_h_gMaster "D8_right0" '(20.0 2.3125) "R90")
schCreateWire(cv "route" "full" '((19.000 2.438) (18.250 2.438)) 0 0 0 nil nil)
schCreateWireLabel(cv nil '(18.750 2.438) "GIOL" "lowerRight" "R0" "stick" 0.0625 nil)
schCreateWire(cv "route" "full" '((19.000 2.562) (18.250 2.562)) 0 0 0 nil nil)
schCreateWireLabel(cv nil '(18.750 2.562) "D8_CORE" "lowerRight" "R0" "stick" 0.0625 nil)
schCreatePin(cv nil "D8_CORE" "inputOutput" nil '(18.250 2.562) "R0")
schCreateWire(cv "route" "full" '((19.000 2.188) (18.250 2.188)) 0 0 0 nil nil)
schCreateWireLabel(cv nil '(18.750 2.188) "VIOL" "lowerRight" "R0" "stick" 0.0625 nil)
schCreateWire(cv "route" "full" '((19.000 2.062) (18.250 2.062)) 0 0 0 nil nil)
schCreateWireLabel(cv nil '(18.750 2.062) "GIOL" "lowerRight" "R0" "stick" 0.0625 nil)
schCreateWire(cv "route" "full" '((20.000 3.000) (20.750 3.000)) 0 0 0 nil nil)
schCreateWireLabel(cv nil '(20.250 3.000) "D8" "lowerLeft" "R0" "stick" 0.0625 nil)
schCreatePin(cv nil "D8" "inputOutput" nil '(20.750 3.000) "R180")
schCreateWire(cv "route" "full" '((19.000 2.688) (18.250 2.688)) 0 0 0 nil nil)
schCreateWireLabel(cv nil '(18.750 2.688) "POC" "lowerRight" "R0" "stick" 0.0625 nil)
schCreateWire(cv "route" "full" '((19.000 2.875) (18.250 2.875)) 0 0 0 nil nil)
schCreateWireLabel(cv nil '(18.750 2.875) "VIOL" "lowerRight" "R0" "stick" 0.0625 nil)
schCreateWire(cv "route" "full" '((19.000 3.062) (18.250 3.062)) 0 0 0 nil nil)
schCreateWireLabel(cv nil '(18.750 3.062) "GIOL" "lowerRight" "R0" "stick" 0.0625 nil)
schCreateWire(cv "route" "full" '((19.000 3.250) (18.250 3.250)) 0 0 0 nil nil)
schCreateWireLabel(cv nil '(18.750 3.250) "VIOH" "lowerRight" "R0" "stick" 0.0625 nil)
schCreateWire(cv "route" "full" '((19.000 3.625) (18.250 3.625)) 0 0 0 nil nil)
schCreateWireLabel(cv nil '(18.750 3.625) "GIOH" "lowerRight" "R0" "stick" 0.0625 nil)
dbCreateInst(cv pddw16sdgz_h_gMaster "D9_right1" '(20.0 4.3125) "R90")
schCreateWire(cv "route" "full" '((19.000 4.438) (18.250 4.438)) 0 0 0 nil nil)
schCreateWireLabel(cv nil '(18.750 4.438) "GIOL" "lowerRight" "R0" "stick" 0.0625 nil)
schCreateWire(cv "route" "full" '((19.000 4.562) (18.250 4.562)) 0 0 0 nil nil)
schCreateWireLabel(cv nil '(18.750 4.562) "D9_CORE" "lowerRight" "R0" "stick" 0.0625 nil)
schCreatePin(cv nil "D9_CORE" "inputOutput" nil '(18.250 4.562) "R0")
schCreateWire(cv "route" "full" '((19.000 4.188) (18.250 4.188)) 0 0 0 nil nil)
schCreateWireLabel(cv nil '(18.750 4.188) "VIOL" "lowerRight" "R0" "stick" 0.0625 nil)
schCreateWire(cv "route" "full" '((19.000 4.062) (18.250 4.062)) 0 0 0 nil nil)
schCreateWireLabel(cv nil '(18.750 4.062) "GIOL" "lowerRight" "R0" "stick" 0.0625 nil)
schCreateWire(cv "route" "full" '((20.000 5.000) (20.750 5.000)) 0 0 0 nil nil)
schCreateWireLabel(cv nil '(20.250 5.000) "D9" "lowerLeft" "R0" "stick" 0.0625 nil)
schCreatePin(cv nil "D9" "inputOutput" nil '(20.750 5.000) "R180")
schCreateWire(cv "route" "full" '((19.000 4.688) (18.250 4.688)) 0 0 0 nil nil)
schCreateWireLabel(cv nil '(18.750 4.688) "POC" "lowerRight" "R0" "stick" 0.0625 nil)
schCreateWire(cv "route" "full" '((19.000 4.875) (18.250 4.875)) 0 0 0 nil nil)
schCreateWireLabel(cv nil '(18.750 4.875) "VIOL" "lowerRight" "R0" "stick" 0.0625 nil)
schCreateWire(cv "route" "full" '((19.000 5.062) (18.250 5.062)) 0 0 0 nil nil)
schCreateWireLabel(cv nil '(18.750 5.062) "GIOL" "lowerRight" "R0" "stick" 0.0625 nil)
schCreateWire(cv "route" "full" '((19.000 5.250) (18.250 5.250)) 0 0 0 nil nil)
schCreateWireLabel(cv nil '(18.750 5.250) "VIOH" "lowerRight" "R0" "stick" 0.0625 nil)
schCreateWire(cv "route" "full" '((19.000 5.625) (18.250 5.625)) 0 0 0 nil nil)
schCreateWireLabel(cv nil '(18.750 5.625) "GIOH" "lowerRight" "R0" "stick" 0.0625 nil)
dbCreateInst(cv pddw16sdgz_h_gMaster "D10_right2" '(20.0 6.3125) "R90")
schCreateWire(cv "route" "full" '((19.000 6.438) (18.250 6.438)) 0 0 0 nil nil)
schCreateWireLabel(cv nil '(18.750 6.438) "GIOL" "lowerRight" "R0" "stick" 0.0625 nil)
schCreateWire(cv "route" "full" '((19.000 6.562) (18.250 6.562)) 0 0 0 nil nil)
schCreateWireLabel(cv nil '(18.750 6.562) "D10_CORE" "lowerRight" "R0" "stick" 0.0625 nil)
schCreatePin(cv nil "D10_CORE" "inputOutput" nil '(18.250 6.562) "R0")
schCreateWire(cv "route" "full" '((19.000 6.188) (18.250 6.188)) 0 0 0 nil nil)
schCreateWireLabel(cv nil '(18.750 6.188) "VIOL" "lowerRight" "R0" "stick" 0.0625 nil)
schCreateWire(cv "route" "full" '((19.000 6.062) (18.250 6.062)) 0 0 0 nil nil)
schCreateWireLabel(cv nil '(18.750 6.062) "GIOL" "lowerRight" "R0" "stick" 0.0625 nil)
schCreateWire(cv "route" "full" '((20.000 7.000) (20.750 7.000)) 0 0 0 nil nil)
schCreateWireLabel(cv nil '(20.250 7.000) "D10" "lowerLeft" "R0" "stick" 0.0625 nil)
schCreatePin(cv nil "D10" "inputOutput" nil '(20.750 7.000) "R180")
schCreateWire(cv "route" "full" '((19.000 6.688) (18.250 6.688)) 0 0 0 nil nil)
schCreateWireLabel(cv nil '(18.750 6.688) "POC" "lowerRight" "R0" "stick" 0.0625 nil)
schCreateWire(cv "route" "full" '((19.000 6.875) (18.250 6.875)) 0 0 0 nil nil)
schCreateWireLabel(cv nil '(18.750 6.875) "VIOL" "lowerRight" "R0" "stick" 0.0625 nil)
schCreateWire(cv "route" "full" '((19.000 7.062) (18.250 7.062)) 0 0 0 nil nil)
schCreateWireLabel(cv nil '(18.750 7.062) "GIOL" "lowerRight" "R0" "stick" 0.0625 nil)
schCreateWire(cv "route" "full" '((19.000 7.250) (18.250 7.250)) 0 0 0 nil nil)
schCreateWireLabel(cv nil '(18.750 7.250) "VIOH" "lowerRight" "R0" "stick" 0.0625 nil)
schCreateWire(cv "route" "full" '((19.000 7.625) (18.250 7.625)) 0 0 0 nil nil)
schCreateWireLabel(cv nil '(18.750 7.625) "GIOH" "lowerRight" "R0" "stick" 0.0625 nil)
dbCreateInst(cv pddw16sdgz_h_gMaster "D11_right3" '(20.0 8.3125) "R90")
schCreateWire(cv "route" "full" '((19.000 8.438) (18.250 8.438)) 0 0 0 nil nil)
schCreateWireLabel(cv nil '(18.750 8.438) "GIOL" "lowerRight" "R0" "stick" 0.0625 nil)
schCreateWire(cv "route" "full" '((19.000 8.562) (18.250 8.562)) 0 0 0 nil nil)
schCreateWireLabel(cv nil '(18.750 8.562) "D11_CORE" "lowerRight" "R0" "stick" 0.0625 nil)
schCreatePin(cv nil "D11_CORE" "inputOutput" nil '(18.250 8.562) "R0")
schCreateWire(cv "route" "full" '((19.000 8.188) (18.250 8.188)) 0 0 0 nil nil)
schCreateWireLabel(cv nil '(18.750 8.188) "VIOL" "lowerRight" "R0" "stick" 0.0625 nil)
schCreateWire(cv "route" "full" '((19.000 8.062) (18.250 8.062)) 0 0 0 nil nil)
schCreateWireLabel(cv nil '(18.750 8.062) "GIOL" "lowerRight" "R0" "stick" 0.0625 nil)
schCreateWire(cv "route" "full" '((20.000 9.001) (20.750 9.001)) 0 0 0 nil nil)
schCreateWireLabel(cv nil '(20.250 9.001) "D11" "lowerLeft" "R0" "stick" 0.0625 nil)
schCreatePin(cv nil "D11" "inputOutput" nil '(20.750 9.001) "R180")
schCreateWire(cv "route" "full" '((19.000 8.688) (18.250 8.688)) 0 0 0 nil nil)
schCreateWireLabel(cv nil '(18.750 8.688) "POC" "lowerRight" "R0" "stick" 0.0625 nil)
schCreateWire(cv "route" "full" '((19.000 8.874) (18.250 8.874)) 0 0 0 nil nil)
schCreateWireLabel(cv nil '(18.750 8.874) "VIOL" "lowerRight" "R0" "stick" 0.0625 nil)
schCreateWire(cv "route" "full" '((19.000 9.062) (18.250 9.062)) 0 0 0 nil nil)
schCreateWireLabel(cv nil '(18.750 9.062) "GIOL" "lowerRight" "R0" "stick" 0.0625 nil)
schCreateWire(cv "route" "full" '((19.000 9.251) (18.250 9.251)) 0 0 0 nil nil)
schCreateWireLabel(cv nil '(18.750 9.251) "VIOH" "lowerRight" "R0" "stick" 0.0625 nil)
schCreateWire(cv "route" "full" '((19.000 9.624) (18.250 9.624)) 0 0 0 nil nil)
schCreateWireLabel(cv nil '(18.750 9.624) "GIOH" "lowerRight" "R0" "stick" 0.0625 nil)
dbCreateInst(cv pddw16sdgz_h_gMaster "D12_right4" '(20.0 10.3125) "R90")
schCreateWire(cv "route" "full" '((19.000 10.438) (18.250 10.438)) 0 0 0 nil nil)
schCreateWireLabel(cv nil '(18.750 10.438) "GIOL" "lowerRight" "R0" "stick" 0.0625 nil)
schCreateWire(cv "route" "full" '((19.000 10.562) (18.250 10.562)) 0 0 0 nil nil)
schCreateWireLabel(cv nil '(18.750 10.562) "D12_CORE" "lowerRight" "R0" "stick" 0.0625 nil)
schCreatePin(cv nil "D12_CORE" "inputOutput" nil '(18.250 10.562) "R0")
schCreateWire(cv "route" "full" '((19.000 10.188) (18.250 10.188)) 0 0 0 nil nil)
schCreateWireLabel(cv nil '(18.750 10.188) "VIOL" "lowerRight" "R0" "stick" 0.0625 nil)
schCreateWire(cv "route" "full" '((19.000 10.062) (18.250 10.062)) 0 0 0 nil nil)
schCreateWireLabel(cv nil '(18.750 10.062) "GIOL" "lowerRight" "R0" "stick" 0.0625 nil)
schCreateWire(cv "route" "full" '((20.000 11.001) (20.750 11.001)) 0 0 0 nil nil)
schCreateWireLabel(cv nil '(20.250 11.001) "D12" "lowerLeft" "R0" "stick" 0.0625 nil)
schCreatePin(cv nil "D12" "inputOutput" nil '(20.750 11.001) "R180")
schCreateWire(cv "route" "full" '((19.000 10.688) (18.250 10.688)) 0 0 0 nil nil)
schCreateWireLabel(cv nil '(18.750 10.688) "POC" "lowerRight" "R0" "stick" 0.0625 nil)
schCreateWire(cv "route" "full" '((19.000 10.874) (18.250 10.874)) 0 0 0 nil nil)
schCreateWireLabel(cv nil '(18.750 10.874) "VIOL" "lowerRight" "R0" "stick" 0.0625 nil)
schCreateWire(cv "route" "full" '((19.000 11.062) (18.250 11.062)) 0 0 0 nil nil)
schCreateWireLabel(cv nil '(18.750 11.062) "GIOL" "lowerRight" "R0" "stick" 0.0625 nil)
schCreateWire(cv "route" "full" '((19.000 11.251) (18.250 11.251)) 0 0 0 nil nil)
schCreateWireLabel(cv nil '(18.750 11.251) "VIOH" "lowerRight" "R0" "stick" 0.0625 nil)
schCreateWire(cv "route" "full" '((19.000 11.624) (18.250 11.624)) 0 0 0 nil nil)
schCreateWireLabel(cv nil '(18.750 11.624) "GIOH" "lowerRight" "R0" "stick" 0.0625 nil)
dbCreateInst(cv pddw16sdgz_h_gMaster "D13_right5" '(20.0 12.3125) "R90")
schCreateWire(cv "route" "full" '((19.000 12.438) (18.250 12.438)) 0 0 0 nil nil)
schCreateWireLabel(cv nil '(18.750 12.438) "GIOL" "lowerRight" "R0" "stick" 0.0625 nil)
schCreateWire(cv "route" "full" '((19.000 12.562) (18.250 12.562)) 0 0 0 nil nil)
schCreateWireLabel(cv nil '(18.750 12.562) "D13_CORE" "lowerRight" "R0" "stick" 0.0625 nil)
schCreatePin(cv nil "D13_CORE" "inputOutput" nil '(18.250 12.562) "R0")
schCreateWire(cv "route" "full" '((19.000 12.188) (18.250 12.188)) 0 0 0 nil nil)
schCreateWireLabel(cv nil '(18.750 12.188) "VIOL" "lowerRight" "R0" "stick" 0.0625 nil)
schCreateWire(cv "route" "full" '((19.000 12.062) (18.250 12.062)) 0 0 0 nil nil)
schCreateWireLabel(cv nil '(18.750 12.062) "GIOL" "lowerRight" "R0" "stick" 0.0625 nil)
schCreateWire(cv "route" "full" '((20.000 13.001) (20.750 13.001)) 0 0 0 nil nil)
schCreateWireLabel(cv nil '(20.250 13.001) "D13" "lowerLeft" "R0" "stick" 0.0625 nil)
schCreatePin(cv nil "D13" "inputOutput" nil '(20.750 13.001) "R180")
schCreateWire(cv "route" "full" '((19.000 12.688) (18.250 12.688)) 0 0 0 nil nil)
schCreateWireLabel(cv nil '(18.750 12.688) "POC" "lowerRight" "R0" "stick" 0.0625 nil)
schCreateWire(cv "route" "full" '((19.000 12.874) (18.250 12.874)) 0 0 0 nil nil)
schCreateWireLabel(cv nil '(18.750 12.874) "VIOL" "lowerRight" "R0" "stick" 0.0625 nil)
schCreateWire(cv "route" "full" '((19.000 13.062) (18.250 13.062)) 0 0 0 nil nil)
schCreateWireLabel(cv nil '(18.750 13.062) "GIOL" "lowerRight" "R0" "stick" 0.0625 nil)
schCreateWire(cv "route" "full" '((19.000 13.251) (18.250 13.251)) 0 0 0 nil nil)
schCreateWireLabel(cv nil '(18.750 13.251) "VIOH" "lowerRight" "R0" "stick" 0.0625 nil)
schCreateWire(cv "route" "full" '((19.000 13.624) (18.250 13.624)) 0 0 0 nil nil)
schCreateWireLabel(cv nil '(18.750 13.624) "GIOH" "lowerRight" "R0" "stick" 0.0625 nil)
dbCreateInst(cv pddw16sdgz_h_gMaster "D14_right6" '(20.0 14.3125) "R90")
schCreateWire(cv "route" "full" '((19.000 14.438) (18.250 14.438)) 0 0 0 nil nil)
schCreateWireLabel(cv nil '(18.750 14.438) "GIOL" "lowerRight" "R0" "stick" 0.0625 nil)
schCreateWire(cv "route" "full" '((19.000 14.562) (18.250 14.562)) 0 0 0 nil nil)
schCreateWireLabel(cv nil '(18.750 14.562) "D14_CORE" "lowerRight" "R0" "stick" 0.0625 nil)
schCreatePin(cv nil "D14_CORE" "inputOutput" nil '(18.250 14.562) "R0")
schCreateWire(cv "route" "full" '((19.000 14.188) (18.250 14.188)) 0 0 0 nil nil)
schCreateWireLabel(cv nil '(18.750 14.188) "VIOL" "lowerRight" "R0" "stick" 0.0625 nil)
schCreateWire(cv "route" "full" '((19.000 14.062) (18.250 14.062)) 0 0 0 nil nil)
schCreateWireLabel(cv nil '(18.750 14.062) "GIOL" "lowerRight" "R0" "stick" 0.0625 nil)
schCreateWire(cv "route" "full" '((20.000 15.001) (20.750 15.001)) 0 0 0 nil nil)
schCreateWireLabel(cv nil '(20.250 15.001) "D14" "lowerLeft" "R0" "stick" 0.0625 nil)
schCreatePin(cv nil "D14" "inputOutput" nil '(20.750 15.001) "R180")
schCreateWire(cv "route" "full" '((19.000 14.688) (18.250 14.688)) 0 0 0 nil nil)
schCreateWireLabel(cv nil '(18.750 14.688) "POC" "lowerRight" "R0" "stick" 0.0625 nil)
schCreateWire(cv "route" "full" '((19.000 14.874) (18.250 14.874)) 0 0 0 nil nil)
schCreateWireLabel(cv nil '(18.750 14.874) "VIOL" "lowerRight" "R0" "stick" 0.0625 nil)
schCreateWire(cv "route" "full" '((19.000 15.062) (18.250 15.062)) 0 0 0 nil nil)
schCreateWireLabel(cv nil '(18.750 15.062) "GIOL" "lowerRight" "R0" "stick" 0.0625 nil)
schCreateWire(cv "route" "full" '((19.000 15.251) (18.250 15.251)) 0 0 0 nil nil)
schCreateWireLabel(cv nil '(18.750 15.251) "VIOH" "lowerRight" "R0" "stick" 0.0625 nil)
schCreateWire(cv "route" "full" '((19.000 15.624) (18.250 15.624)) 0 0 0 nil nil)
schCreateWireLabel(cv nil '(18.750 15.624) "GIOH" "lowerRight" "R0" "stick" 0.0625 nil)
dbCreateInst(cv pddw16sdgz_h_gMaster "D15_right7" '(20.0 16.3125) "R90")
schCreateWire(cv "route" "full" '((19.000 16.438) (18.250 16.438)) 0 0 0 nil nil)
schCreateWireLabel(cv nil '(18.750 16.438) "GIOL" "lowerRight" "R0" "stick" 0.0625 nil)
schCreateWire(cv "route" "full" '((19.000 16.562) (18.250 16.562)) 0 0 0 nil nil)
schCreateWireLabel(cv nil '(18.750 16.562) "D15_CORE" "lowerRight" "R0" "stick" 0.0625 nil)
schCreatePin(cv nil "D15_CORE" "inputOutput" nil '(18.250 16.562) "R0")
schCreateWire(cv "route" "full" '((19.000 16.188) (18.250 16.188)) 0 0 0 nil nil)
schCreateWireLabel(cv nil '(18.750 16.188) "VIOL" "lowerRight" "R0" "stick" 0.0625 nil)
schCreateWire(cv "route" "full" '((19.000 16.062) (18.250 16.062)) 0 0 0 nil nil)
schCreateWireLabel(cv nil '(18.750 16.062) "GIOL" "lowerRight" "R0" "stick" 0.0625 nil)
schCreateWire(cv "route" "full" '((20.000 17.000) (20.750 17.000)) 0 0 0 nil nil)
schCreateWireLabel(cv nil '(20.250 17.000) "D15" "lowerLeft" "R0" "stick" 0.0625 nil)
schCreatePin(cv nil "D15" "inputOutput" nil '(20.750 17.000) "R180")
schCreateWire(cv "route" "full" '((19.000 16.688) (18.250 16.688)) 0 0 0 nil nil)
schCreateWireLabel(cv nil '(18.750 16.688) "POC" "lowerRight" "R0" "stick" 0.0625 nil)
schCreateWire(cv "route" "full" '((19.000 16.875) (18.250 16.875)) 0 0 0 nil nil)
schCreateWireLabel(cv nil '(18.750 16.875) "VIOL" "lowerRight" "R0" "stick" 0.0625 nil)
schCreateWire(cv "route" "full" '((19.000 17.062) (18.250 17.062)) 0 0 0 nil nil)
schCreateWireLabel(cv nil '(18.750 17.062) "GIOL" "lowerRight" "R0" "stick" 0.0625 nil)
schCreateWire(cv "route" "full" '((19.000 17.250) (18.250 17.250)) 0 0 0 nil nil)
schCreateWireLabel(cv nil '(18.750 17.250) "VIOH" "lowerRight" "R0" "stick" 0.0625 nil)
schCreateWire(cv "route" "full" '((19.000 17.625) (18.250 17.625)) 0 0 0 nil nil)
schCreateWireLabel(cv nil '(18.750 17.625) "GIOH" "lowerRight" "R0" "stick" 0.0625 nil)
dbCreateInst(cv pddw16sdgz_v_gMaster "D16_top0" '(17.6875 20.0) "R180")
schCreateWire(cv "route" "full" '((17.562 19.000) (17.562 18.250)) 0 0 0 nil nil)
schCreateWireLabel(cv nil '(17.562 18.750) "GIOL" "lowerRight" "R90" "stick" 0.0625 nil)
schCreateWire(cv "route" "full" '((17.438 19.000) (17.438 18.250)) 0 0 0 nil nil)
schCreateWireLabel(cv nil '(17.438 18.750) "D16_CORE" "lowerRight" "R90" "stick" 0.0625 nil)
schCreatePin(cv nil "D16_CORE" "inputOutput" nil '(17.438 18.250) "R90")
schCreateWire(cv "route" "full" '((17.812 19.000) (17.812 18.250)) 0 0 0 nil nil)
schCreateWireLabel(cv nil '(17.812 18.750) "VIOL" "lowerRight" "R90" "stick" 0.0625 nil)
schCreateWire(cv "route" "full" '((17.938 19.000) (17.938 18.250)) 0 0 0 nil nil)
schCreateWireLabel(cv nil '(17.938 18.750) "GIOL" "lowerRight" "R90" "stick" 0.0625 nil)
schCreateWire(cv "route" "full" '((17.000 20.000) (17.000 20.750)) 0 0 0 nil nil)
schCreateWireLabel(cv nil '(17.000 20.250) "D16" "lowerLeft" "R90" "stick" 0.0625 nil)
schCreatePin(cv nil "D16" "inputOutput" nil '(17.000 20.750) "R270")
schCreateWire(cv "route" "full" '((17.312 19.000) (17.312 18.250)) 0 0 0 nil nil)
schCreateWireLabel(cv nil '(17.312 18.750) "POC" "lowerRight" "R90" "stick" 0.0625 nil)
schCreateWire(cv "route" "full" '((17.125 19.000) (17.125 18.250)) 0 0 0 nil nil)
schCreateWireLabel(cv nil '(17.125 18.750) "VIOL" "lowerRight" "R90" "stick" 0.0625 nil)
schCreateWire(cv "route" "full" '((16.938 19.000) (16.938 18.250)) 0 0 0 nil nil)
schCreateWireLabel(cv nil '(16.938 18.750) "GIOL" "lowerRight" "R90" "stick" 0.0625 nil)
schCreateWire(cv "route" "full" '((16.750 19.000) (16.750 18.250)) 0 0 0 nil nil)
schCreateWireLabel(cv nil '(16.750 18.750) "VIOH" "lowerRight" "R90" "stick" 0.0625 nil)
schCreateWire(cv "route" "full" '((16.375 19.000) (16.375 18.250)) 0 0 0 nil nil)
schCreateWireLabel(cv nil '(16.375 18.750) "GIOH" "lowerRight" "R90" "stick" 0.0625 nil)
dbCreateInst(cv pddw16sdgz_v_gMaster "D17_top1" '(15.6875 20.0) "R180")
schCreateWire(cv "route" "full" '((15.562 19.000) (15.562 18.250)) 0 0 0 nil nil)
schCreateWireLabel(cv nil '(15.562 18.750) "GIOL" "lowerRight" "R90" "stick" 0.0625 nil)
schCreateWire(cv "route" "full" '((15.438 19.000) (15.438 18.250)) 0 0 0 nil nil)
schCreateWireLabel(cv nil '(15.438 18.750) "D17_CORE" "lowerRight" "R90" "stick" 0.0625 nil)
schCreatePin(cv nil "D17_CORE" "inputOutput" nil '(15.438 18.250) "R90")
schCreateWire(cv "route" "full" '((15.812 19.000) (15.812 18.250)) 0 0 0 nil nil)
schCreateWireLabel(cv nil '(15.812 18.750) "VIOL" "lowerRight" "R90" "stick" 0.0625 nil)
schCreateWire(cv "route" "full" '((15.938 19.000) (15.938 18.250)) 0 0 0 nil nil)
schCreateWireLabel(cv nil '(15.938 18.750) "GIOL" "lowerRight" "R90" "stick" 0.0625 nil)
schCreateWire(cv "route" "full" '((14.999 20.000) (14.999 20.750)) 0 0 0 nil nil)
schCreateWireLabel(cv nil '(14.999 20.250) "D17" "lowerLeft" "R90" "stick" 0.0625 nil)
schCreatePin(cv nil "D17" "inputOutput" nil '(14.999 20.750) "R270")
schCreateWire(cv "route" "full" '((15.312 19.000) (15.312 18.250)) 0 0 0 nil nil)
schCreateWireLabel(cv nil '(15.312 18.750) "POC" "lowerRight" "R90" "stick" 0.0625 nil)
schCreateWire(cv "route" "full" '((15.126 19.000) (15.126 18.250)) 0 0 0 nil nil)
schCreateWireLabel(cv nil '(15.126 18.750) "VIOL" "lowerRight" "R90" "stick" 0.0625 nil)
schCreateWire(cv "route" "full" '((14.938 19.000) (14.938 18.250)) 0 0 0 nil nil)
schCreateWireLabel(cv nil '(14.938 18.750) "GIOL" "lowerRight" "R90" "stick" 0.0625 nil)
schCreateWire(cv "route" "full" '((14.749 19.000) (14.749 18.250)) 0 0 0 nil nil)
schCreateWireLabel(cv nil '(14.749 18.750) "VIOH" "lowerRight" "R90" "stick" 0.0625 nil)
schCreateWire(cv "route" "full" '((14.376 19.000) (14.376 18.250)) 0 0 0 nil nil)
schCreateWireLabel(cv nil '(14.376 18.750) "GIOH" "lowerRight" "R90" "stick" 0.0625 nil)
dbCreateInst(cv pddw16sdgz_v_gMaster "D18_top2" '(13.6875 20.0) "R180")
schCreateWire(cv "route" "full" '((13.562 19.000) (13.562 18.250)) 0 0 0 nil nil)
schCreateWireLabel(cv nil '(13.562 18.750) "GIOL" "lowerRight" "R90" "stick" 0.0625 nil)
schCreateWire(cv "route" "full" '((13.438 19.000) (13.438 18.250)) 0 0 0 nil nil)
schCreateWireLabel(cv nil '(13.438 18.750) "D18_CORE" "lowerRight" "R90" "stick" 0.0625 nil)
schCreatePin(cv nil "D18_CORE" "inputOutput" nil '(13.438 18.250) "R90")
schCreateWire(cv "route" "full" '((13.812 19.000) (13.812 18.250)) 0 0 0 nil nil)
schCreateWireLabel(cv nil '(13.812 18.750) "VIOL" "lowerRight" "R90" "stick" 0.0625 nil)
schCreateWire(cv "route" "full" '((13.938 19.000) (13.938 18.250)) 0 0 0 nil nil)
schCreateWireLabel(cv nil '(13.938 18.750) "GIOL" "lowerRight" "R90" "stick" 0.0625 nil)
schCreateWire(cv "route" "full" '((12.999 20.000) (12.999 20.750)) 0 0 0 nil nil)
schCreateWireLabel(cv nil '(12.999 20.250) "D18" "lowerLeft" "R90" "stick" 0.0625 nil)
schCreatePin(cv nil "D18" "inputOutput" nil '(12.999 20.750) "R270")
schCreateWire(cv "route" "full" '((13.312 19.000) (13.312 18.250)) 0 0 0 nil nil)
schCreateWireLabel(cv nil '(13.312 18.750) "POC" "lowerRight" "R90" "stick" 0.0625 nil)
schCreateWire(cv "route" "full" '((13.126 19.000) (13.126 18.250)) 0 0 0 nil nil)
schCreateWireLabel(cv nil '(13.126 18.750) "VIOL" "lowerRight" "R90" "stick" 0.0625 nil)
schCreateWire(cv "route" "full" '((12.938 19.000) (12.938 18.250)) 0 0 0 nil nil)
schCreateWireLabel(cv nil '(12.938 18.750) "GIOL" "lowerRight" "R90" "stick" 0.0625 nil)
schCreateWire(cv "route" "full" '((12.749 19.000) (12.749 18.250)) 0 0 0 nil nil)
schCreateWireLabel(cv nil '(12.749 18.750) "VIOH" "lowerRight" "R90" "stick" 0.0625 nil)
schCreateWire(cv "route" "full" '((12.376 19.000) (12.376 18.250)) 0 0 0 nil nil)
schCreateWireLabel(cv nil '(12.376 18.750) "GIOH" "lowerRight" "R90" "stick" 0.0625 nil)
dbCreateInst(cv pddw16sdgz_v_gMaster "D19_top3" '(11.6875 20.0) "R180")
schCreateWire(cv "route" "full" '((11.562 19.000) (11.562 18.250)) 0 0 0 nil nil)
schCreateWireLabel(cv nil '(11.562 18.750) "GIOL" "lowerRight" "R90" "stick" 0.0625 nil)
schCreateWire(cv "route" "full" '((11.438 19.000) (11.438 18.250)) 0 0 0 nil nil)
schCreateWireLabel(cv nil '(11.438 18.750) "D19_CORE" "lowerRight" "R90" "stick" 0.0625 nil)
schCreatePin(cv nil "D19_CORE" "inputOutput" nil '(11.438 18.250) "R90")
schCreateWire(cv "route" "full" '((11.812 19.000) (11.812 18.250)) 0 0 0 nil nil)
schCreateWireLabel(cv nil '(11.812 18.750) "VIOL" "lowerRight" "R90" "stick" 0.0625 nil)
schCreateWire(cv "route" "full" '((11.938 19.000) (11.938 18.250)) 0 0 0 nil nil)
schCreateWireLabel(cv nil '(11.938 18.750) "GIOL" "lowerRight" "R90" "stick" 0.0625 nil)
schCreateWire(cv "route" "full" '((10.999 20.000) (10.999 20.750)) 0 0 0 nil nil)
schCreateWireLabel(cv nil '(10.999 20.250) "D19" "lowerLeft" "R90" "stick" 0.0625 nil)
schCreatePin(cv nil "D19" "inputOutput" nil '(10.999 20.750) "R270")
schCreateWire(cv "route" "full" '((11.312 19.000) (11.312 18.250)) 0 0 0 nil nil)
schCreateWireLabel(cv nil '(11.312 18.750) "POC" "lowerRight" "R90" "stick" 0.0625 nil)
schCreateWire(cv "route" "full" '((11.126 19.000) (11.126 18.250)) 0 0 0 nil nil)
schCreateWireLabel(cv nil '(11.126 18.750) "VIOL" "lowerRight" "R90" "stick" 0.0625 nil)
schCreateWire(cv "route" "full" '((10.938 19.000) (10.938 18.250)) 0 0 0 nil nil)
schCreateWireLabel(cv nil '(10.938 18.750) "GIOL" "lowerRight" "R90" "stick" 0.0625 nil)
schCreateWire(cv "route" "full" '((10.749 19.000) (10.749 18.250)) 0 0 0 nil nil)
schCreateWireLabel(cv nil '(10.749 18.750) "VIOH" "lowerRight" "R90" "stick" 0.0625 nil)
schCreateWire(cv "route" "full" '((10.376 19.000) (10.376 18.250)) 0 0 0 nil nil)
schCreateWireLabel(cv nil '(10.376 18.750) "GIOH" "lowerRight" "R90" "stick" 0.0625 nil)
pvdd1dgz_v_gMaster = dbOpenCellView("tphn28hpcpgv18" "PVDD1DGZ_V_G" "symbol")
dbCreateInst(cv pvdd1dgz_v_gMaster "VIOL_top4" '(10.0 20.0) "R180")
schCreateWire(cv "route" "full" '((9.625 19.000) (9.625 18.250)) 0 0 0 nil nil)
schCreateWireLabel(cv nil '(9.625 18.750) "POC" "lowerRight" "R90" "stick" 0.0625 nil)
schCreateWire(cv "route" "full" '((9.000 20.000) (9.000 20.750)) 0 0 0 nil nil)
schCreateWireLabel(cv nil '(9.000 20.250) "VIOL" "lowerLeft" "R90" "stick" 0.0625 nil)
schCreatePin(cv nil "VIOL" "inputOutput" nil '(9.000 20.750) "R270")
schCreateWire(cv "route" "full" '((9.250 19.000) (9.250 18.250)) 0 0 0 nil nil)
schCreateWireLabel(cv nil '(9.250 18.750) "GIOL" "lowerRight" "R90" "stick" 0.0625 nil)
schCreateWire(cv "route" "full" '((9.062 19.000) (9.062 18.250)) 0 0 0 nil nil)
schCreateWireLabel(cv nil '(9.062 18.750) "VIOH" "lowerRight" "R90" "stick" 0.0625 nil)
schCreateWire(cv "route" "full" '((8.688 19.000) (8.688 18.250)) 0 0 0 nil nil)
schCreateWireLabel(cv nil '(8.688 18.750) "GIOH" "lowerRight" "R90" "stick" 0.0625 nil)
pvss1dgz_v_gMaster = dbOpenCellView("tphn28hpcpgv18" "PVSS1DGZ_V_G" "symbol")
dbCreateInst(cv pvss1dgz_v_gMaster "GIOL_top5" '(8.0 20.0) "R180")
schCreateWire(cv "route" "full" '((7.625 19.000) (7.625 18.250)) 0 0 0 nil nil)
schCreateWireLabel(cv nil '(7.625 18.750) "POC" "lowerRight" "R90" "stick" 0.0625 nil)
schCreateWire(cv "route" "full" '((7.438 19.000) (7.438 18.250)) 0 0 0 nil nil)
schCreateWireLabel(cv nil '(7.438 18.750) "VIOL" "lowerRight" "R90" "stick" 0.0625 nil)
schCreateWire(cv "route" "full" '((7.000 20.000) (7.000 20.750)) 0 0 0 nil nil)
schCreateWireLabel(cv nil '(7.000 20.250) "GIOL" "lowerLeft" "R90" "stick" 0.0625 nil)
schCreatePin(cv nil "GIOL" "inputOutput" nil '(7.000 20.750) "R270")
schCreateWire(cv "route" "full" '((7.062 19.000) (7.062 18.250)) 0 0 0 nil nil)
schCreateWireLabel(cv nil '(7.062 18.750) "VIOH" "lowerRight" "R90" "stick" 0.0625 nil)
schCreateWire(cv "route" "full" '((6.688 19.000) (6.688 18.250)) 0 0 0 nil nil)
schCreateWireLabel(cv nil '(6.688 18.750) "GIOH" "lowerRight" "R90" "stick" 0.0625 nil)
pvdd2poc_v_gMaster = dbOpenCellView("tphn28hpcpgv18" "PVDD2POC_V_G" "symbol")
dbCreateInst(cv pvdd2poc_v_gMaster "VIOH_top6" '(6.0 20.0) "R180")
schCreateWire(cv "route" "full" '((5.625 19.000) (5.625 18.250)) 0 0 0 nil nil)
schCreateWireLabel(cv nil '(5.625 18.750) "POC" "lowerRight" "R90" "stick" 0.0625 nil)
schCreateWire(cv "route" "full" '((5.438 19.000) (5.438 18.250)) 0 0 0 nil nil)
schCreateWireLabel(cv nil '(5.438 18.750) "VIOL" "lowerRight" "R90" "stick" 0.0625 nil)
schCreateWire(cv "route" "full" '((5.250 19.000) (5.250 18.250)) 0 0 0 nil nil)
schCreateWireLabel(cv nil '(5.250 18.750) "GIOL" "lowerRight" "R90" "stick" 0.0625 nil)
schCreateWire(cv "route" "full" '((5.000 20.000) (5.000 20.750)) 0 0 0 nil nil)
schCreateWireLabel(cv nil '(5.000 20.250) "VIOH" "lowerLeft" "R90" "stick" 0.0625 nil)
schCreatePin(cv nil "VIOH" "inputOutput" nil '(5.000 20.750) "R270")
schCreateWire(cv "route" "full" '((4.688 19.000) (4.688 18.250)) 0 0 0 nil nil)
schCreateWireLabel(cv nil '(4.688 18.750) "GIOH" "lowerRight" "R90" "stick" 0.0625 nil)
pvss2dgz_v_gMaster = dbOpenCellView("tphn28hpcpgv18" "PVSS2DGZ_V_G" "symbol")
dbCreateInst(cv pvss2dgz_v_gMaster "GIOH_top7" '(4.0 20.0) "R180")
schCreateWire(cv "route" "full" '((3.625 19.000) (3.625 18.250)) 0 0 0 nil nil)
schCreateWireLabel(cv nil '(3.625 18.750) "POC" "lowerRight" "R90" "stick" 0.0625 nil)
schCreateWire(cv "route" "full" '((3.438 19.000) (3.438 18.250)) 0 0 0 nil nil)
schCreateWireLabel(cv nil '(3.438 18.750) "VIOL" "lowerRight" "R90" "stick" 0.0625 nil)
schCreateWire(cv "route" "full" '((3.250 19.000) (3.250 18.250)) 0 0 0 nil nil)
schCreateWireLabel(cv nil '(3.250 18.750) "GIOL" "lowerRight" "R90" "stick" 0.0625 nil)
schCreateWire(cv "route" "full" '((3.062 19.000) (3.062 18.250)) 0 0 0 nil nil)
schCreateWireLabel(cv nil '(3.062 18.750) "VIOH" "lowerRight" "R90" "stick" 0.0625 nil)
schCreateWire(cv "route" "full" '((3.000 20.000) (3.000 20.750)) 0 0 0 nil nil)
schCreateWireLabel(cv nil '(3.000 20.250) "GIOH" "lowerLeft" "R90" "stick" 0.0625 nil)
schCreatePin(cv nil "GIOH" "inputOutput" nil '(3.000 20.750) "R270")
dbCreateInst(cv pdb3ac_h_gMaster "VREF_CORE_left45" '(4.0 7.625) "R270")
schCreateWire(cv "route" "full" '((4.000 7.813) (3.250 7.813)) 0 0 0 nil nil)
schCreateWireLabel(cv nil '(3.750 7.813) "VREF_CORE" "lowerRight" "R0" "stick" 0.0625 nil)
schCreatePin(cv nil "VREF_CORE" "inputOutput" nil '(3.250 7.813) "R0")
schCreateWire(cv "route" "full" '((4.875 7.875) (5.625 7.875)) 0 0 0 nil nil)
schCreateWireLabel(cv nil '(5.125 7.875) "AVSS" "lowerLeft" "R0" "stick" 0.0625 nil)
schCreateWire(cv "route" "full" '((4.875 7.500) (5.625 7.500)) 0 0 0 nil nil)
schCreateWireLabel(cv nil '(5.125 7.500) "GIOL" "lowerLeft" "R0" "stick" 0.0625 nil)
schCreateWire(cv "route" "full" '((4.875 8.250) (5.625 8.250)) 0 0 0 nil nil)
schCreateWireLabel(cv nil '(5.125 8.250) "AVDD" "lowerLeft" "R0" "stick" 0.0625 nil)
dbCreateInst(cv pddw16sdgz_h_gMaster "D24_right67" '(16.0 14.625) "R90")
schCreateWire(cv "route" "full" '((15.000 14.750) (14.250 14.750)) 0 0 0 nil nil)
schCreateWireLabel(cv nil '(14.750 14.750) "GIOL" "lowerRight" "R0" "stick" 0.0625 nil)
schCreateWire(cv "route" "full" '((15.000 14.875) (14.250 14.875)) 0 0 0 nil nil)
schCreateWireLabel(cv nil '(14.750 14.875) "D24_CORE" "lowerRight" "R0" "stick" 0.0625 nil)
schCreatePin(cv nil "D24_CORE" "inputOutput" nil '(14.250 14.875) "R0")
schCreateWire(cv "route" "full" '((15.000 14.500) (14.250 14.500)) 0 0 0 nil nil)
schCreateWireLabel(cv nil '(14.750 14.500) "VIOL" "lowerRight" "R0" "stick" 0.0625 nil)
schCreateWire(cv "route" "full" '((15.000 14.375) (14.250 14.375)) 0 0 0 nil nil)
schCreateWireLabel(cv nil '(14.750 14.375) "GIOL" "lowerRight" "R0" "stick" 0.0625 nil)
schCreateWire(cv "route" "full" '((16.000 15.313) (16.750 15.313)) 0 0 0 nil nil)
schCreateWireLabel(cv nil '(16.250 15.313) "D24" "lowerLeft" "R0" "stick" 0.0625 nil)
schCreatePin(cv nil "D24" "inputOutput" nil '(16.750 15.313) "R180")
schCreateWire(cv "route" "full" '((15.000 15.000) (14.250 15.000)) 0 0 0 nil nil)
schCreateWireLabel(cv nil '(14.750 15.000) "POC" "lowerRight" "R0" "stick" 0.0625 nil)
schCreateWire(cv "route" "full" '((15.000 15.187) (14.250 15.187)) 0 0 0 nil nil)
schCreateWireLabel(cv nil '(14.750 15.187) "VIOL" "lowerRight" "R0" "stick" 0.0625 nil)
schCreateWire(cv "route" "full" '((15.000 15.375) (14.250 15.375)) 0 0 0 nil nil)
schCreateWireLabel(cv nil '(14.750 15.375) "GIOL" "lowerRight" "R0" "stick" 0.0625 nil)
schCreateWire(cv "route" "full" '((15.000 15.563) (14.250 15.563)) 0 0 0 nil nil)
schCreateWireLabel(cv nil '(14.750 15.563) "VIOH" "lowerRight" "R0" "stick" 0.0625 nil)
schCreateWire(cv "route" "full" '((15.000 15.937) (14.250 15.937)) 0 0 0 nil nil)
schCreateWireLabel(cv nil '(14.750 15.937) "GIOH" "lowerRight" "R0" "stick" 0.0625 nil)
dbCreateInst(cv pdb3ac_h_gMaster "VAMP_CORE_left01" '(4.0 15.625) "R270")
schCreateWire(cv "route" "full" '((4.000 15.813) (3.250 15.813)) 0 0 0 nil nil)
schCreateWireLabel(cv nil '(3.750 15.813) "VAMP_CORE" "lowerRight" "R0" "stick" 0.0625 nil)
schCreatePin(cv nil "VAMP_CORE" "inputOutput" nil '(3.250 15.813) "R0")
schCreateWire(cv "route" "full" '((4.875 15.875) (5.625 15.875)) 0 0 0 nil nil)
schCreateWireLabel(cv nil '(5.125 15.875) "AVSS" "lowerLeft" "R0" "stick" 0.0625 nil)
schCreateWire(cv "route" "full" '((4.875 15.500) (5.625 15.500)) 0 0 0 nil nil)
schCreateWireLabel(cv nil '(5.125 15.500) "GIOL" "lowerLeft" "R0" "stick" 0.0625 nil)
schCreateWire(cv "route" "full" '((4.875 16.250) (5.625 16.250)) 0 0 0 nil nil)
schCreateWireLabel(cv nil '(5.125 16.250) "AVDD" "lowerLeft" "R0" "stick" 0.0625 nil)
schCheck(cv)
dbSave(cv)
t
