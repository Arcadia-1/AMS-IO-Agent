pddw16sdgz_h_gMaster = dbOpenCellView("tphn28hpcpgv18" "PDDW16SDGZ_H_G" "symbol")
dbCreateInst(cv pddw16sdgz_h_gMaster "DCLK_left0" '(0 37.6875) "R270")
schCreateWire(cv "route" "full" '((1.000 37.562) (1.750 37.562)) 0 0 0 nil nil)
schCreateWireLabel(cv nil '(1.250 37.562) "VIOL" "lowerLeft" "R0" "stick" 0.0625 nil)
noConnMaster = dbOpenCellView("basic" "noConn" "symbol")
schCreateWire(cv "route" "full" '((1.000 37.438) (1.750 37.438)) 0 0 0 nil nil)
dbCreateInst(cv noConnMaster "noConn_DCLK_left0_C" '(1.750 37.438) "R90")
schCreateWire(cv "route" "full" '((1.000 37.812) (1.750 37.812)) 0 0 0 nil nil)
schCreateWireLabel(cv nil '(1.250 37.812) "GIOL" "lowerLeft" "R0" "stick" 0.0625 nil)
schCreateWire(cv "route" "full" '((1.000 37.938) (1.750 37.938)) 0 0 0 nil nil)
schCreateWireLabel(cv nil '(1.250 37.938) "DCLK_CORE" "lowerLeft" "R0" "stick" 0.0625 nil)
schCreatePin(cv nil "DCLK_CORE" "inputOutput" nil '(1.750 37.938) "R180")
schCreateWire(cv "route" "full" '((0.000 36.999) (-0.750 36.999)) 0 0 0 nil nil)
schCreateWireLabel(cv nil '(-0.250 36.999) "DCLK" "lowerRight" "R0" "stick" 0.0625 nil)
schCreatePin(cv nil "DCLK" "inputOutput" nil '(-0.750 36.999) "R0")
schCreateWire(cv "route" "full" '((1.000 37.312) (1.750 37.312)) 0 0 0 nil nil)
schCreateWireLabel(cv nil '(1.250 37.312) "POC" "lowerLeft" "R0" "stick" 0.0625 nil)
schCreateWire(cv "route" "full" '((1.000 37.126) (1.750 37.126)) 0 0 0 nil nil)
schCreateWireLabel(cv nil '(1.250 37.126) "VIOL" "lowerLeft" "R0" "stick" 0.0625 nil)
schCreateWire(cv "route" "full" '((1.000 36.938) (1.750 36.938)) 0 0 0 nil nil)
schCreateWireLabel(cv nil '(1.250 36.938) "GIOL" "lowerLeft" "R0" "stick" 0.0625 nil)
schCreateWire(cv "route" "full" '((1.000 36.749) (1.750 36.749)) 0 0 0 nil nil)
schCreateWireLabel(cv nil '(1.250 36.749) "VIOH" "lowerLeft" "R0" "stick" 0.0625 nil)
schCreateWire(cv "route" "full" '((1.000 36.376) (1.750 36.376)) 0 0 0 nil nil)
schCreateWireLabel(cv nil '(1.250 36.376) "GIOH" "lowerLeft" "R0" "stick" 0.0625 nil)
dbCreateInst(cv pddw16sdgz_h_gMaster "SYNC_left1" '(0 35.6875) "R270")
schCreateWire(cv "route" "full" '((1.000 35.562) (1.750 35.562)) 0 0 0 nil nil)
schCreateWireLabel(cv nil '(1.250 35.562) "VIOL" "lowerLeft" "R0" "stick" 0.0625 nil)
schCreateWire(cv "route" "full" '((1.000 35.438) (1.750 35.438)) 0 0 0 nil nil)
dbCreateInst(cv noConnMaster "noConn_SYNC_left1_C" '(1.750 35.438) "R90")
schCreateWire(cv "route" "full" '((1.000 35.812) (1.750 35.812)) 0 0 0 nil nil)
schCreateWireLabel(cv nil '(1.250 35.812) "GIOL" "lowerLeft" "R0" "stick" 0.0625 nil)
schCreateWire(cv "route" "full" '((1.000 35.938) (1.750 35.938)) 0 0 0 nil nil)
schCreateWireLabel(cv nil '(1.250 35.938) "SYNC_CORE" "lowerLeft" "R0" "stick" 0.0625 nil)
schCreatePin(cv nil "SYNC_CORE" "inputOutput" nil '(1.750 35.938) "R180")
schCreateWire(cv "route" "full" '((0.000 34.999) (-0.750 34.999)) 0 0 0 nil nil)
schCreateWireLabel(cv nil '(-0.250 34.999) "SYNC" "lowerRight" "R0" "stick" 0.0625 nil)
schCreatePin(cv nil "SYNC" "inputOutput" nil '(-0.750 34.999) "R0")
schCreateWire(cv "route" "full" '((1.000 35.312) (1.750 35.312)) 0 0 0 nil nil)
schCreateWireLabel(cv nil '(1.250 35.312) "POC" "lowerLeft" "R0" "stick" 0.0625 nil)
schCreateWire(cv "route" "full" '((1.000 35.126) (1.750 35.126)) 0 0 0 nil nil)
schCreateWireLabel(cv nil '(1.250 35.126) "VIOL" "lowerLeft" "R0" "stick" 0.0625 nil)
schCreateWire(cv "route" "full" '((1.000 34.938) (1.750 34.938)) 0 0 0 nil nil)
schCreateWireLabel(cv nil '(1.250 34.938) "GIOL" "lowerLeft" "R0" "stick" 0.0625 nil)
schCreateWire(cv "route" "full" '((1.000 34.749) (1.750 34.749)) 0 0 0 nil nil)
schCreateWireLabel(cv nil '(1.250 34.749) "VIOH" "lowerLeft" "R0" "stick" 0.0625 nil)
schCreateWire(cv "route" "full" '((1.000 34.376) (1.750 34.376)) 0 0 0 nil nil)
schCreateWireLabel(cv nil '(1.250 34.376) "GIOH" "lowerLeft" "R0" "stick" 0.0625 nil)
pvdd1dgz_h_gMaster = dbOpenCellView("tphn28hpcpgv18" "PVDD1DGZ_H_G" "symbol")
dbCreateInst(cv pvdd1dgz_h_gMaster "VIOL_left2" '(0 34.0) "R270")
schCreateWire(cv "route" "full" '((1.000 33.625) (1.750 33.625)) 0 0 0 nil nil)
schCreateWireLabel(cv nil '(1.250 33.625) "POC" "lowerLeft" "R0" "stick" 0.0625 nil)
schCreateWire(cv "route" "full" '((0.000 33.000) (-0.750 33.000)) 0 0 0 nil nil)
schCreateWireLabel(cv nil '(-0.250 33.000) "VIOL" "lowerRight" "R0" "stick" 0.0625 nil)
schCreatePin(cv nil "VIOL" "inputOutput" nil '(-0.750 33.000) "R0")
schCreateWire(cv "route" "full" '((1.000 33.250) (1.750 33.250)) 0 0 0 nil nil)
schCreateWireLabel(cv nil '(1.250 33.250) "GIOL" "lowerLeft" "R0" "stick" 0.0625 nil)
schCreateWire(cv "route" "full" '((1.000 33.062) (1.750 33.062)) 0 0 0 nil nil)
schCreateWireLabel(cv nil '(1.250 33.062) "VIOH" "lowerLeft" "R0" "stick" 0.0625 nil)
schCreateWire(cv "route" "full" '((1.000 32.688) (1.750 32.688)) 0 0 0 nil nil)
schCreateWireLabel(cv nil '(1.250 32.688) "GIOH" "lowerLeft" "R0" "stick" 0.0625 nil)
pvss1dgz_h_gMaster = dbOpenCellView("tphn28hpcpgv18" "PVSS1DGZ_H_G" "symbol")
dbCreateInst(cv pvss1dgz_h_gMaster "GIOL_left3" '(0 32.0) "R270")
schCreateWire(cv "route" "full" '((1.000 31.625) (1.750 31.625)) 0 0 0 nil nil)
schCreateWireLabel(cv nil '(1.250 31.625) "POC" "lowerLeft" "R0" "stick" 0.0625 nil)
schCreateWire(cv "route" "full" '((1.000 31.438) (1.750 31.438)) 0 0 0 nil nil)
schCreateWireLabel(cv nil '(1.250 31.438) "VIOL" "lowerLeft" "R0" "stick" 0.0625 nil)
schCreateWire(cv "route" "full" '((0.000 31.000) (-0.750 31.000)) 0 0 0 nil nil)
schCreateWireLabel(cv nil '(-0.250 31.000) "GIOL" "lowerRight" "R0" "stick" 0.0625 nil)
schCreatePin(cv nil "GIOL" "inputOutput" nil '(-0.750 31.000) "R0")
schCreateWire(cv "route" "full" '((1.000 31.062) (1.750 31.062)) 0 0 0 nil nil)
schCreateWireLabel(cv nil '(1.250 31.062) "VIOH" "lowerLeft" "R0" "stick" 0.0625 nil)
schCreateWire(cv "route" "full" '((1.000 30.688) (1.750 30.688)) 0 0 0 nil nil)
schCreateWireLabel(cv nil '(1.250 30.688) "GIOH" "lowerLeft" "R0" "stick" 0.0625 nil)
pvdd2poc_h_gMaster = dbOpenCellView("tphn28hpcpgv18" "PVDD2POC_H_G" "symbol")
dbCreateInst(cv pvdd2poc_h_gMaster "VIOH_left4" '(0 30.0) "R270")
schCreateWire(cv "route" "full" '((1.000 29.625) (1.750 29.625)) 0 0 0 nil nil)
schCreateWireLabel(cv nil '(1.250 29.625) "POC" "lowerLeft" "R0" "stick" 0.0625 nil)
schCreateWire(cv "route" "full" '((1.000 29.438) (1.750 29.438)) 0 0 0 nil nil)
schCreateWireLabel(cv nil '(1.250 29.438) "VIOL" "lowerLeft" "R0" "stick" 0.0625 nil)
schCreateWire(cv "route" "full" '((1.000 29.250) (1.750 29.250)) 0 0 0 nil nil)
schCreateWireLabel(cv nil '(1.250 29.250) "GIOL" "lowerLeft" "R0" "stick" 0.0625 nil)
schCreateWire(cv "route" "full" '((0.000 29.000) (-0.750 29.000)) 0 0 0 nil nil)
schCreateWireLabel(cv nil '(-0.250 29.000) "VIOH" "lowerRight" "R0" "stick" 0.0625 nil)
schCreatePin(cv nil "VIOH" "inputOutput" nil '(-0.750 29.000) "R0")
schCreateWire(cv "route" "full" '((1.000 28.688) (1.750 28.688)) 0 0 0 nil nil)
schCreateWireLabel(cv nil '(1.250 28.688) "GIOH" "lowerLeft" "R0" "stick" 0.0625 nil)
pvss2dgz_h_gMaster = dbOpenCellView("tphn28hpcpgv18" "PVSS2DGZ_H_G" "symbol")
dbCreateInst(cv pvss2dgz_h_gMaster "GIOH_left5" '(0 28.0) "R270")
schCreateWire(cv "route" "full" '((1.000 27.625) (1.750 27.625)) 0 0 0 nil nil)
schCreateWireLabel(cv nil '(1.250 27.625) "POC" "lowerLeft" "R0" "stick" 0.0625 nil)
schCreateWire(cv "route" "full" '((1.000 27.438) (1.750 27.438)) 0 0 0 nil nil)
schCreateWireLabel(cv nil '(1.250 27.438) "VIOL" "lowerLeft" "R0" "stick" 0.0625 nil)
schCreateWire(cv "route" "full" '((1.000 27.250) (1.750 27.250)) 0 0 0 nil nil)
schCreateWireLabel(cv nil '(1.250 27.250) "GIOL" "lowerLeft" "R0" "stick" 0.0625 nil)
schCreateWire(cv "route" "full" '((1.000 27.062) (1.750 27.062)) 0 0 0 nil nil)
schCreateWireLabel(cv nil '(1.250 27.062) "VIOH" "lowerLeft" "R0" "stick" 0.0625 nil)
schCreateWire(cv "route" "full" '((0.000 27.000) (-0.750 27.000)) 0 0 0 nil nil)
schCreateWireLabel(cv nil '(-0.250 27.000) "GIOH" "lowerRight" "R0" "stick" 0.0625 nil)
schCreatePin(cv nil "GIOH" "inputOutput" nil '(-0.750 27.000) "R0")
pdb3ac_h_gMaster = dbOpenCellView("tphn28hpcpgv18" "PDB3AC_H_G" "symbol")
dbCreateInst(cv pdb3ac_h_gMaster "VDD3_left6" '(0 24.8125) "R270")
schCreateWire(cv "route" "full" '((0.000 25.000) (-0.750 25.000)) 0 0 0 nil nil)
schCreateWireLabel(cv nil '(-0.250 25.000) "VDD3" "lowerRight" "R0" "stick" 0.0625 nil)
schCreatePin(cv nil "VDD3" "inputOutput" nil '(-0.750 25.000) "R0")
schCreateWire(cv "route" "full" '((0.875 25.062) (1.625 25.062)) 0 0 0 nil nil)
schCreateWireLabel(cv nil '(1.125 25.062) "VSSIB" "lowerLeft" "R0" "stick" 0.0625 nil)
schCreateWire(cv "route" "full" '((0.875 24.688) (1.625 24.688)) 0 0 0 nil nil)
schCreateWireLabel(cv nil '(1.125 24.688) "GIOL" "lowerLeft" "R0" "stick" 0.0625 nil)
schCreateWire(cv "route" "full" '((0.875 25.438) (1.625 25.438)) 0 0 0 nil nil)
schCreateWireLabel(cv nil '(1.125 25.438) "VDDIB" "lowerLeft" "R0" "stick" 0.0625 nil)
dbCreateInst(cv pdb3ac_h_gMaster "IB3_left7" '(0 22.8125) "R270")
schCreateWire(cv "route" "full" '((0.000 23.000) (-0.750 23.000)) 0 0 0 nil nil)
schCreateWireLabel(cv nil '(-0.250 23.000) "IB3" "lowerRight" "R0" "stick" 0.0625 nil)
schCreatePin(cv nil "IB3" "inputOutput" nil '(-0.750 23.000) "R0")
schCreateWire(cv "route" "full" '((0.875 23.062) (1.625 23.062)) 0 0 0 nil nil)
schCreateWireLabel(cv nil '(1.125 23.062) "VSSIB" "lowerLeft" "R0" "stick" 0.0625 nil)
schCreateWire(cv "route" "full" '((0.875 22.688) (1.625 22.688)) 0 0 0 nil nil)
schCreateWireLabel(cv nil '(1.125 22.688) "GIOL" "lowerLeft" "R0" "stick" 0.0625 nil)
schCreateWire(cv "route" "full" '((0.875 23.438) (1.625 23.438)) 0 0 0 nil nil)
schCreateWireLabel(cv nil '(1.125 23.438) "VDDIB" "lowerLeft" "R0" "stick" 0.0625 nil)
dbCreateInst(cv pdb3ac_h_gMaster "VDD12_left8" '(0 20.8125) "R270")
schCreateWire(cv "route" "full" '((0.000 21.000) (-0.750 21.000)) 0 0 0 nil nil)
schCreateWireLabel(cv nil '(-0.250 21.000) "VDD12" "lowerRight" "R0" "stick" 0.0625 nil)
schCreatePin(cv nil "VDD12" "inputOutput" nil '(-0.750 21.000) "R0")
schCreateWire(cv "route" "full" '((0.875 21.062) (1.625 21.062)) 0 0 0 nil nil)
schCreateWireLabel(cv nil '(1.125 21.062) "VSSIB" "lowerLeft" "R0" "stick" 0.0625 nil)
schCreateWire(cv "route" "full" '((0.875 20.688) (1.625 20.688)) 0 0 0 nil nil)
schCreateWireLabel(cv nil '(1.125 20.688) "GIOL" "lowerLeft" "R0" "stick" 0.0625 nil)
schCreateWire(cv "route" "full" '((0.875 21.438) (1.625 21.438)) 0 0 0 nil nil)
schCreateWireLabel(cv nil '(1.125 21.438) "VDDIB" "lowerLeft" "R0" "stick" 0.0625 nil)
dbCreateInst(cv pdb3ac_h_gMaster "IB12_left9" '(0 18.8125) "R270")
schCreateWire(cv "route" "full" '((0.000 19.000) (-0.750 19.000)) 0 0 0 nil nil)
schCreateWireLabel(cv nil '(-0.250 19.000) "IB12" "lowerRight" "R0" "stick" 0.0625 nil)
schCreatePin(cv nil "IB12" "inputOutput" nil '(-0.750 19.000) "R0")
schCreateWire(cv "route" "full" '((0.875 19.062) (1.625 19.062)) 0 0 0 nil nil)
schCreateWireLabel(cv nil '(1.125 19.062) "VSSIB" "lowerLeft" "R0" "stick" 0.0625 nil)
schCreateWire(cv "route" "full" '((0.875 18.688) (1.625 18.688)) 0 0 0 nil nil)
schCreateWireLabel(cv nil '(1.125 18.688) "GIOL" "lowerLeft" "R0" "stick" 0.0625 nil)
schCreateWire(cv "route" "full" '((0.875 19.438) (1.625 19.438)) 0 0 0 nil nil)
schCreateWireLabel(cv nil '(1.125 19.438) "VDDIB" "lowerLeft" "R0" "stick" 0.0625 nil)
dbCreateInst(cv pdb3ac_h_gMaster "VDD_CDAC_left10" '(0 16.8125) "R270")
schCreateWire(cv "route" "full" '((0.000 17.000) (-0.750 17.000)) 0 0 0 nil nil)
schCreateWireLabel(cv nil '(-0.250 17.000) "VDD_CDAC" "lowerRight" "R0" "stick" 0.0625 nil)
schCreatePin(cv nil "VDD_CDAC" "inputOutput" nil '(-0.750 17.000) "R0")
schCreateWire(cv "route" "full" '((0.875 17.062) (1.625 17.062)) 0 0 0 nil nil)
schCreateWireLabel(cv nil '(1.125 17.062) "VSSIB" "lowerLeft" "R0" "stick" 0.0625 nil)
schCreateWire(cv "route" "full" '((0.875 16.688) (1.625 16.688)) 0 0 0 nil nil)
schCreateWireLabel(cv nil '(1.125 16.688) "GIOL" "lowerLeft" "R0" "stick" 0.0625 nil)
schCreateWire(cv "route" "full" '((0.875 17.438) (1.625 17.438)) 0 0 0 nil nil)
schCreateWireLabel(cv nil '(1.125 17.438) "VDDIB" "lowerLeft" "R0" "stick" 0.0625 nil)
dbCreateInst(cv pdb3ac_h_gMaster "VREFDES_left11" '(0 14.8125) "R270")
schCreateWire(cv "route" "full" '((0.000 15.001) (-0.750 15.001)) 0 0 0 nil nil)
schCreateWireLabel(cv nil '(-0.250 15.001) "VREFDES" "lowerRight" "R0" "stick" 0.0625 nil)
schCreatePin(cv nil "VREFDES" "inputOutput" nil '(-0.750 15.001) "R0")
schCreateWire(cv "route" "full" '((0.875 15.062) (1.625 15.062)) 0 0 0 nil nil)
schCreateWireLabel(cv nil '(1.125 15.062) "VSSIB" "lowerLeft" "R0" "stick" 0.0625 nil)
schCreateWire(cv "route" "full" '((0.875 14.688) (1.625 14.688)) 0 0 0 nil nil)
schCreateWireLabel(cv nil '(1.125 14.688) "GIOL" "lowerLeft" "R0" "stick" 0.0625 nil)
schCreateWire(cv "route" "full" '((0.875 15.438) (1.625 15.438)) 0 0 0 nil nil)
schCreateWireLabel(cv nil '(1.125 15.438) "VDDIB" "lowerLeft" "R0" "stick" 0.0625 nil)
dbCreateInst(cv pdb3ac_h_gMaster "IBREF_left12" '(0 12.8125) "R270")
schCreateWire(cv "route" "full" '((0.000 13.001) (-0.750 13.001)) 0 0 0 nil nil)
schCreateWireLabel(cv nil '(-0.250 13.001) "IBREF" "lowerRight" "R0" "stick" 0.0625 nil)
schCreatePin(cv nil "IBREF" "inputOutput" nil '(-0.750 13.001) "R0")
schCreateWire(cv "route" "full" '((0.875 13.062) (1.625 13.062)) 0 0 0 nil nil)
schCreateWireLabel(cv nil '(1.125 13.062) "VSSIB" "lowerLeft" "R0" "stick" 0.0625 nil)
schCreateWire(cv "route" "full" '((0.875 12.688) (1.625 12.688)) 0 0 0 nil nil)
schCreateWireLabel(cv nil '(1.125 12.688) "GIOL" "lowerLeft" "R0" "stick" 0.0625 nil)
schCreateWire(cv "route" "full" '((0.875 13.438) (1.625 13.438)) 0 0 0 nil nil)
schCreateWireLabel(cv nil '(1.125 13.438) "VDDIB" "lowerLeft" "R0" "stick" 0.0625 nil)
dbCreateInst(cv pdb3ac_h_gMaster "VSS_left13" '(0 10.8125) "R270")
schCreateWire(cv "route" "full" '((0.000 11.001) (-0.750 11.001)) 0 0 0 nil nil)
schCreateWireLabel(cv nil '(-0.250 11.001) "VSS" "lowerRight" "R0" "stick" 0.0625 nil)
schCreatePin(cv nil "VSS" "inputOutput" nil '(-0.750 11.001) "R0")
schCreateWire(cv "route" "full" '((0.875 11.062) (1.625 11.062)) 0 0 0 nil nil)
schCreateWireLabel(cv nil '(1.125 11.062) "VSSIB" "lowerLeft" "R0" "stick" 0.0625 nil)
schCreateWire(cv "route" "full" '((0.875 10.688) (1.625 10.688)) 0 0 0 nil nil)
schCreateWireLabel(cv nil '(1.125 10.688) "GIOL" "lowerLeft" "R0" "stick" 0.0625 nil)
schCreateWire(cv "route" "full" '((0.875 11.438) (1.625 11.438)) 0 0 0 nil nil)
schCreateWireLabel(cv nil '(1.125 11.438) "VDDIB" "lowerLeft" "R0" "stick" 0.0625 nil)
dbCreateInst(cv pdb3ac_h_gMaster "IBUF_IBIAS_left14" '(0 8.8125) "R270")
schCreateWire(cv "route" "full" '((0.000 9.001) (-0.750 9.001)) 0 0 0 nil nil)
schCreateWireLabel(cv nil '(-0.250 9.001) "IBUF_IBIAS" "lowerRight" "R0" "stick" 0.0625 nil)
schCreatePin(cv nil "IBUF_IBIAS" "inputOutput" nil '(-0.750 9.001) "R0")
schCreateWire(cv "route" "full" '((0.875 9.062) (1.625 9.062)) 0 0 0 nil nil)
schCreateWireLabel(cv nil '(1.125 9.062) "VSSIB" "lowerLeft" "R0" "stick" 0.0625 nil)
schCreateWire(cv "route" "full" '((0.875 8.688) (1.625 8.688)) 0 0 0 nil nil)
schCreateWireLabel(cv nil '(1.125 8.688) "GIOL" "lowerLeft" "R0" "stick" 0.0625 nil)
schCreateWire(cv "route" "full" '((0.875 9.438) (1.625 9.438)) 0 0 0 nil nil)
schCreateWireLabel(cv nil '(1.125 9.438) "VDDIB" "lowerLeft" "R0" "stick" 0.0625 nil)
pvdd3ac_h_gMaster = dbOpenCellView("tphn28hpcpgv18" "PVDD3AC_H_G" "symbol")
dbCreateInst(cv pvdd3ac_h_gMaster "VDDIB_left15" '(0 6.8125) "R270")
schCreateWire(cv "route" "full" '((0.875 7.438) (1.625 7.438)) 0 0 0 nil nil)
schCreateWireLabel(cv nil '(1.125 7.438) "VDDIB_CORE" "lowerLeft" "R0" "stick" 0.0625 nil)
schCreatePin(cv nil "VDDIB_CORE" "inputOutput" nil '(1.625 7.438) "R180")
schCreateWire(cv "route" "full" '((0.875 7.062) (1.625 7.062)) 0 0 0 nil nil)
schCreateWireLabel(cv nil '(1.125 7.062) "VSSIB" "lowerLeft" "R0" "stick" 0.0625 nil)
schCreateWire(cv "route" "full" '((0.875 6.688) (1.625 6.688)) 0 0 0 nil nil)
schCreateWireLabel(cv nil '(1.125 6.688) "GIOL" "lowerLeft" "R0" "stick" 0.0625 nil)
schCreateWire(cv "route" "full" '((0.000 7.000) (-0.750 7.000)) 0 0 0 nil nil)
schCreateWireLabel(cv nil '(-0.250 7.000) "VDDIB" "lowerRight" "R0" "stick" 0.0625 nil)
schCreatePin(cv nil "VDDIB" "inputOutput" nil '(-0.750 7.000) "R0")
pvss3ac_h_gMaster = dbOpenCellView("tphn28hpcpgv18" "PVSS3AC_H_G" "symbol")
dbCreateInst(cv pvss3ac_h_gMaster "VSSIB_left16" '(0 4.8125) "R270")
schCreateWire(cv "route" "full" '((0.000 5.000) (-0.750 5.000)) 0 0 0 nil nil)
schCreateWireLabel(cv nil '(-0.250 5.000) "VSSIB" "lowerRight" "R0" "stick" 0.0625 nil)
schCreatePin(cv nil "VSSIB" "inputOutput" nil '(-0.750 5.000) "R0")
schCreateWire(cv "route" "full" '((0.875 4.688) (1.625 4.688)) 0 0 0 nil nil)
schCreateWireLabel(cv nil '(1.125 4.688) "GIOL" "lowerLeft" "R0" "stick" 0.0625 nil)
schCreateWire(cv "route" "full" '((0.875 5.438) (1.625 5.438)) 0 0 0 nil nil)
schCreateWireLabel(cv nil '(1.125 5.438) "VSSIB_CORE" "lowerLeft" "R0" "stick" 0.0625 nil)
schCreatePin(cv nil "VSSIB_CORE" "inputOutput" nil '(1.625 5.438) "R180")
schCreateWire(cv "route" "full" '((0.875 5.062) (1.625 5.062)) 0 0 0 nil nil)
schCreateWireLabel(cv nil '(1.125 5.062) "VDDIB" "lowerLeft" "R0" "stick" 0.0625 nil)
dbCreateInst(cv pdb3ac_h_gMaster "VINP_left17" '(0 2.8125) "R270")
schCreateWire(cv "route" "full" '((0.000 3.001) (-0.750 3.001)) 0 0 0 nil nil)
schCreateWireLabel(cv nil '(-0.250 3.001) "VINP" "lowerRight" "R0" "stick" 0.0625 nil)
schCreatePin(cv nil "VINP" "inputOutput" nil '(-0.750 3.001) "R0")
schCreateWire(cv "route" "full" '((0.875 3.062) (1.625 3.062)) 0 0 0 nil nil)
schCreateWireLabel(cv nil '(1.125 3.062) "VSSIB" "lowerLeft" "R0" "stick" 0.0625 nil)
schCreateWire(cv "route" "full" '((0.875 2.688) (1.625 2.688)) 0 0 0 nil nil)
schCreateWireLabel(cv nil '(1.125 2.688) "GIOL" "lowerLeft" "R0" "stick" 0.0625 nil)
schCreateWire(cv "route" "full" '((0.875 3.438) (1.625 3.438)) 0 0 0 nil nil)
schCreateWireLabel(cv nil '(1.125 3.438) "VDDIB" "lowerLeft" "R0" "stick" 0.0625 nil)
pdb3ac_v_gMaster = dbOpenCellView("tphn28hpcpgv18" "PDB3AC_V_G" "symbol")
dbCreateInst(cv pdb3ac_v_gMaster "VINN_bottom0" '(3.1875 0) "R0")
schCreateWire(cv "route" "full" '((2.999 0.000) (2.999 -0.750)) 0 0 0 nil nil)
schCreateWireLabel(cv nil '(2.999 -0.250) "VINN" "lowerRight" "R90" "stick" 0.0625 nil)
schCreatePin(cv nil "VINN" "inputOutput" nil '(2.999 -0.750) "R90")
schCreateWire(cv "route" "full" '((2.938 0.875) (2.938 1.625)) 0 0 0 nil nil)
schCreateWireLabel(cv nil '(2.938 1.125) "VSSIB" "lowerLeft" "R90" "stick" 0.0625 nil)
schCreateWire(cv "route" "full" '((3.312 0.875) (3.312 1.625)) 0 0 0 nil nil)
schCreateWireLabel(cv nil '(3.312 1.125) "GIOL" "lowerLeft" "R90" "stick" 0.0625 nil)
schCreateWire(cv "route" "full" '((2.562 0.875) (2.562 1.625)) 0 0 0 nil nil)
schCreateWireLabel(cv nil '(2.562 1.125) "VDDIB" "lowerLeft" "R90" "stick" 0.0625 nil)
dbCreateInst(cv pdb3ac_v_gMaster "VINCM_bottom1" '(5.1875 0) "R0")
schCreateWire(cv "route" "full" '((5.000 0.000) (5.000 -0.750)) 0 0 0 nil nil)
schCreateWireLabel(cv nil '(5.000 -0.250) "VINCM" "lowerRight" "R90" "stick" 0.0625 nil)
schCreatePin(cv nil "VINCM" "inputOutput" nil '(5.000 -0.750) "R90")
schCreateWire(cv "route" "full" '((4.938 0.875) (4.938 1.625)) 0 0 0 nil nil)
schCreateWireLabel(cv nil '(4.938 1.125) "VSSIB" "lowerLeft" "R90" "stick" 0.0625 nil)
schCreateWire(cv "route" "full" '((5.312 0.875) (5.312 1.625)) 0 0 0 nil nil)
schCreateWireLabel(cv nil '(5.312 1.125) "GIOL" "lowerLeft" "R90" "stick" 0.0625 nil)
schCreateWire(cv "route" "full" '((4.562 0.875) (4.562 1.625)) 0 0 0 nil nil)
schCreateWireLabel(cv nil '(4.562 1.125) "VDDIB" "lowerLeft" "R90" "stick" 0.0625 nil)
pvss3ac_v_gMaster = dbOpenCellView("tphn28hpcpgv18" "PVSS3AC_V_G" "symbol")
dbCreateInst(cv pvss3ac_v_gMaster "GND_CKB_bottom2" '(7.1875 0) "R0")
schCreateWire(cv "route" "full" '((7.000 0.000) (7.000 -0.750)) 0 0 0 nil nil)
schCreateWireLabel(cv nil '(7.000 -0.250) "GND_CKB" "lowerRight" "R90" "stick" 0.0625 nil)
schCreatePin(cv nil "GND_CKB" "inputOutput" nil '(7.000 -0.750) "R90")
schCreateWire(cv "route" "full" '((7.312 0.875) (7.312 1.625)) 0 0 0 nil nil)
schCreateWireLabel(cv nil '(7.312 1.125) "GIOL" "lowerLeft" "R90" "stick" 0.0625 nil)
schCreateWire(cv "route" "full" '((6.562 0.875) (6.562 1.625)) 0 0 0 nil nil)
schCreateWireLabel(cv nil '(6.562 1.125) "GND_CKB_CORE" "lowerLeft" "R90" "stick" 0.0625 nil)
schCreatePin(cv nil "GND_CKB_CORE" "inputOutput" nil '(6.562 1.625) "R270")
schCreateWire(cv "route" "full" '((6.938 0.875) (6.938 1.625)) 0 0 0 nil nil)
schCreateWireLabel(cv nil '(6.938 1.125) "VDD_CKB" "lowerLeft" "R90" "stick" 0.0625 nil)
pvdd3ac_v_gMaster = dbOpenCellView("tphn28hpcpgv18" "PVDD3AC_V_G" "symbol")
dbCreateInst(cv pvdd3ac_v_gMaster "VDD_CKB_bottom3" '(9.1875 0) "R0")
schCreateWire(cv "route" "full" '((8.562 0.875) (8.562 1.625)) 0 0 0 nil nil)
schCreateWireLabel(cv nil '(8.562 1.125) "VDD_CKB_CORE" "lowerLeft" "R90" "stick" 0.0625 nil)
schCreatePin(cv nil "VDD_CKB_CORE" "inputOutput" nil '(8.562 1.625) "R270")
schCreateWire(cv "route" "full" '((8.938 0.875) (8.938 1.625)) 0 0 0 nil nil)
schCreateWireLabel(cv nil '(8.938 1.125) "GND_CKB" "lowerLeft" "R90" "stick" 0.0625 nil)
schCreateWire(cv "route" "full" '((9.312 0.875) (9.312 1.625)) 0 0 0 nil nil)
schCreateWireLabel(cv nil '(9.312 1.125) "GIOL" "lowerLeft" "R90" "stick" 0.0625 nil)
schCreateWire(cv "route" "full" '((8.999 0.000) (8.999 -0.750)) 0 0 0 nil nil)
schCreateWireLabel(cv nil '(8.999 -0.250) "VDD_CKB" "lowerRight" "R90" "stick" 0.0625 nil)
schCreatePin(cv nil "VDD_CKB" "inputOutput" nil '(8.999 -0.750) "R90")
dbCreateInst(cv pdb3ac_v_gMaster "CLKP_bottom4" '(11.1875 0) "R0")
schCreateWire(cv "route" "full" '((10.999 0.000) (10.999 -0.750)) 0 0 0 nil nil)
schCreateWireLabel(cv nil '(10.999 -0.250) "CLKP" "lowerRight" "R90" "stick" 0.0625 nil)
schCreatePin(cv nil "CLKP" "inputOutput" nil '(10.999 -0.750) "R90")
schCreateWire(cv "route" "full" '((10.938 0.875) (10.938 1.625)) 0 0 0 nil nil)
schCreateWireLabel(cv nil '(10.938 1.125) "GND_CKB" "lowerLeft" "R90" "stick" 0.0625 nil)
schCreateWire(cv "route" "full" '((11.312 0.875) (11.312 1.625)) 0 0 0 nil nil)
schCreateWireLabel(cv nil '(11.312 1.125) "GIOL" "lowerLeft" "R90" "stick" 0.0625 nil)
schCreateWire(cv "route" "full" '((10.562 0.875) (10.562 1.625)) 0 0 0 nil nil)
schCreateWireLabel(cv nil '(10.562 1.125) "VDD_CKB" "lowerLeft" "R90" "stick" 0.0625 nil)
dbCreateInst(cv pdb3ac_v_gMaster "CLKN_bottom5" '(13.1875 0) "R0")
schCreateWire(cv "route" "full" '((12.999 0.000) (12.999 -0.750)) 0 0 0 nil nil)
schCreateWireLabel(cv nil '(12.999 -0.250) "CLKN" "lowerRight" "R90" "stick" 0.0625 nil)
schCreatePin(cv nil "CLKN" "inputOutput" nil '(12.999 -0.750) "R90")
schCreateWire(cv "route" "full" '((12.938 0.875) (12.938 1.625)) 0 0 0 nil nil)
schCreateWireLabel(cv nil '(12.938 1.125) "GND_CKB" "lowerLeft" "R90" "stick" 0.0625 nil)
schCreateWire(cv "route" "full" '((13.312 0.875) (13.312 1.625)) 0 0 0 nil nil)
schCreateWireLabel(cv nil '(13.312 1.125) "GIOL" "lowerLeft" "R90" "stick" 0.0625 nil)
schCreateWire(cv "route" "full" '((12.562 0.875) (12.562 1.625)) 0 0 0 nil nil)
schCreateWireLabel(cv nil '(12.562 1.125) "VDD_CKB" "lowerLeft" "R90" "stick" 0.0625 nil)
dbCreateInst(cv pvdd3ac_v_gMaster "VDD_DAT_bottom6" '(15.1875 0) "R0")
schCreateWire(cv "route" "full" '((14.562 0.875) (14.562 1.625)) 0 0 0 nil nil)
schCreateWireLabel(cv nil '(14.562 1.125) "VDD_DAT_CORE" "lowerLeft" "R90" "stick" 0.0625 nil)
schCreatePin(cv nil "VDD_DAT_CORE" "inputOutput" nil '(14.562 1.625) "R270")
schCreateWire(cv "route" "full" '((14.938 0.875) (14.938 1.625)) 0 0 0 nil nil)
schCreateWireLabel(cv nil '(14.938 1.125) "GND_DAT" "lowerLeft" "R90" "stick" 0.0625 nil)
schCreateWire(cv "route" "full" '((15.312 0.875) (15.312 1.625)) 0 0 0 nil nil)
schCreateWireLabel(cv nil '(15.312 1.125) "GIOL" "lowerLeft" "R90" "stick" 0.0625 nil)
schCreateWire(cv "route" "full" '((14.999 0.000) (14.999 -0.750)) 0 0 0 nil nil)
schCreateWireLabel(cv nil '(14.999 -0.250) "VDD_DAT" "lowerRight" "R90" "stick" 0.0625 nil)
schCreatePin(cv nil "VDD_DAT" "inputOutput" nil '(14.999 -0.750) "R90")
dbCreateInst(cv pvss3ac_v_gMaster "GND_DAT_bottom7" '(17.1875 0) "R0")
schCreateWire(cv "route" "full" '((17.000 0.000) (17.000 -0.750)) 0 0 0 nil nil)
schCreateWireLabel(cv nil '(17.000 -0.250) "GND_DAT" "lowerRight" "R90" "stick" 0.0625 nil)
schCreatePin(cv nil "GND_DAT" "inputOutput" nil '(17.000 -0.750) "R90")
schCreateWire(cv "route" "full" '((17.312 0.875) (17.312 1.625)) 0 0 0 nil nil)
schCreateWireLabel(cv nil '(17.312 1.125) "GIOL" "lowerLeft" "R90" "stick" 0.0625 nil)
schCreateWire(cv "route" "full" '((16.562 0.875) (16.562 1.625)) 0 0 0 nil nil)
schCreateWireLabel(cv nil '(16.562 1.125) "GND_DAT_CORE" "lowerLeft" "R90" "stick" 0.0625 nil)
schCreatePin(cv nil "GND_DAT_CORE" "inputOutput" nil '(16.562 1.625) "R270")
schCreateWire(cv "route" "full" '((16.938 0.875) (16.938 1.625)) 0 0 0 nil nil)
schCreateWireLabel(cv nil '(16.938 1.125) "VDD_DAT" "lowerLeft" "R90" "stick" 0.0625 nil)
dbCreateInst(cv pdb3ac_v_gMaster "VCM_bottom8" '(19.1875 0) "R0")
schCreateWire(cv "route" "full" '((19.000 0.000) (19.000 -0.750)) 0 0 0 nil nil)
schCreateWireLabel(cv nil '(19.000 -0.250) "VCM" "lowerRight" "R90" "stick" 0.0625 nil)
schCreatePin(cv nil "VCM" "inputOutput" nil '(19.000 -0.750) "R90")
schCreateWire(cv "route" "full" '((18.938 0.875) (18.938 1.625)) 0 0 0 nil nil)
schCreateWireLabel(cv nil '(18.938 1.125) "GND_DAT" "lowerLeft" "R90" "stick" 0.0625 nil)
schCreateWire(cv "route" "full" '((19.312 0.875) (19.312 1.625)) 0 0 0 nil nil)
schCreateWireLabel(cv nil '(19.312 1.125) "GIOL" "lowerLeft" "R90" "stick" 0.0625 nil)
schCreateWire(cv "route" "full" '((18.562 0.875) (18.562 1.625)) 0 0 0 nil nil)
schCreateWireLabel(cv nil '(18.562 1.125) "VDD_DAT" "lowerLeft" "R90" "stick" 0.0625 nil)
dbCreateInst(cv pdb3ac_v_gMaster "VSSCLK_bottom9" '(21.1875 0) "R0")
schCreateWire(cv "route" "full" '((21.000 0.000) (21.000 -0.750)) 0 0 0 nil nil)
schCreateWireLabel(cv nil '(21.000 -0.250) "VSSCLK" "lowerRight" "R90" "stick" 0.0625 nil)
schCreatePin(cv nil "VSSCLK" "inputOutput" nil '(21.000 -0.750) "R90")
schCreateWire(cv "route" "full" '((20.938 0.875) (20.938 1.625)) 0 0 0 nil nil)
schCreateWireLabel(cv nil '(20.938 1.125) "GND_DAT" "lowerLeft" "R90" "stick" 0.0625 nil)
schCreateWire(cv "route" "full" '((21.312 0.875) (21.312 1.625)) 0 0 0 nil nil)
schCreateWireLabel(cv nil '(21.312 1.125) "GIOL" "lowerLeft" "R90" "stick" 0.0625 nil)
schCreateWire(cv "route" "full" '((20.562 0.875) (20.562 1.625)) 0 0 0 nil nil)
schCreateWireLabel(cv nil '(20.562 1.125) "VDD_DAT" "lowerLeft" "R90" "stick" 0.0625 nil)
dbCreateInst(cv pdb3ac_v_gMaster "VDDCLK_bottom10" '(23.1875 0) "R0")
schCreateWire(cv "route" "full" '((23.000 0.000) (23.000 -0.750)) 0 0 0 nil nil)
schCreateWireLabel(cv nil '(23.000 -0.250) "VDDCLK" "lowerRight" "R90" "stick" 0.0625 nil)
schCreatePin(cv nil "VDDCLK" "inputOutput" nil '(23.000 -0.750) "R90")
schCreateWire(cv "route" "full" '((22.938 0.875) (22.938 1.625)) 0 0 0 nil nil)
schCreateWireLabel(cv nil '(22.938 1.125) "GND_DAT" "lowerLeft" "R90" "stick" 0.0625 nil)
schCreateWire(cv "route" "full" '((23.312 0.875) (23.312 1.625)) 0 0 0 nil nil)
schCreateWireLabel(cv nil '(23.312 1.125) "GIOL" "lowerLeft" "R90" "stick" 0.0625 nil)
schCreateWire(cv "route" "full" '((22.562 0.875) (22.562 1.625)) 0 0 0 nil nil)
schCreateWireLabel(cv nil '(22.562 1.125) "VDD_DAT" "lowerLeft" "R90" "stick" 0.0625 nil)
dbCreateInst(cv pdb3ac_v_gMaster "AVDD_bottom11" '(25.1875 0) "R0")
schCreateWire(cv "route" "full" '((25.000 0.000) (25.000 -0.750)) 0 0 0 nil nil)
schCreateWireLabel(cv nil '(25.000 -0.250) "AVDD" "lowerRight" "R90" "stick" 0.0625 nil)
schCreatePin(cv nil "AVDD" "inputOutput" nil '(25.000 -0.750) "R90")
schCreateWire(cv "route" "full" '((24.938 0.875) (24.938 1.625)) 0 0 0 nil nil)
schCreateWireLabel(cv nil '(24.938 1.125) "GND_DAT" "lowerLeft" "R90" "stick" 0.0625 nil)
schCreateWire(cv "route" "full" '((25.312 0.875) (25.312 1.625)) 0 0 0 nil nil)
schCreateWireLabel(cv nil '(25.312 1.125) "GIOL" "lowerLeft" "R90" "stick" 0.0625 nil)
schCreateWire(cv "route" "full" '((24.562 0.875) (24.562 1.625)) 0 0 0 nil nil)
schCreateWireLabel(cv nil '(24.562 1.125) "VDD_DAT" "lowerLeft" "R90" "stick" 0.0625 nil)
dbCreateInst(cv pdb3ac_v_gMaster "AVSS_bottom12" '(27.1875 0) "R0")
schCreateWire(cv "route" "full" '((27.000 0.000) (27.000 -0.750)) 0 0 0 nil nil)
schCreateWireLabel(cv nil '(27.000 -0.250) "AVSS" "lowerRight" "R90" "stick" 0.0625 nil)
schCreatePin(cv nil "AVSS" "inputOutput" nil '(27.000 -0.750) "R90")
schCreateWire(cv "route" "full" '((26.938 0.875) (26.938 1.625)) 0 0 0 nil nil)
schCreateWireLabel(cv nil '(26.938 1.125) "GND_DAT" "lowerLeft" "R90" "stick" 0.0625 nil)
schCreateWire(cv "route" "full" '((27.312 0.875) (27.312 1.625)) 0 0 0 nil nil)
schCreateWireLabel(cv nil '(27.312 1.125) "GIOL" "lowerLeft" "R90" "stick" 0.0625 nil)
schCreateWire(cv "route" "full" '((26.562 0.875) (26.562 1.625)) 0 0 0 nil nil)
schCreateWireLabel(cv nil '(26.562 1.125) "VDD_DAT" "lowerLeft" "R90" "stick" 0.0625 nil)
dbCreateInst(cv pdb3ac_v_gMaster "VDDSAR_bottom13" '(29.1875 0) "R0")
schCreateWire(cv "route" "full" '((29.000 0.000) (29.000 -0.750)) 0 0 0 nil nil)
schCreateWireLabel(cv nil '(29.000 -0.250) "VDDSAR" "lowerRight" "R90" "stick" 0.0625 nil)
schCreatePin(cv nil "VDDSAR" "inputOutput" nil '(29.000 -0.750) "R90")
schCreateWire(cv "route" "full" '((28.938 0.875) (28.938 1.625)) 0 0 0 nil nil)
schCreateWireLabel(cv nil '(28.938 1.125) "GND_DAT" "lowerLeft" "R90" "stick" 0.0625 nil)
schCreateWire(cv "route" "full" '((29.312 0.875) (29.312 1.625)) 0 0 0 nil nil)
schCreateWireLabel(cv nil '(29.312 1.125) "GIOL" "lowerLeft" "R90" "stick" 0.0625 nil)
schCreateWire(cv "route" "full" '((28.562 0.875) (28.562 1.625)) 0 0 0 nil nil)
schCreateWireLabel(cv nil '(28.562 1.125) "VDD_DAT" "lowerLeft" "R90" "stick" 0.0625 nil)
dbCreateInst(cv pdb3ac_v_gMaster "VSSSAR_bottom14" '(31.1875 0) "R0")
schCreateWire(cv "route" "full" '((31.000 0.000) (31.000 -0.750)) 0 0 0 nil nil)
schCreateWireLabel(cv nil '(31.000 -0.250) "VSSSAR" "lowerRight" "R90" "stick" 0.0625 nil)
schCreatePin(cv nil "VSSSAR" "inputOutput" nil '(31.000 -0.750) "R90")
schCreateWire(cv "route" "full" '((30.938 0.875) (30.938 1.625)) 0 0 0 nil nil)
schCreateWireLabel(cv nil '(30.938 1.125) "GND_DAT" "lowerLeft" "R90" "stick" 0.0625 nil)
schCreateWire(cv "route" "full" '((31.312 0.875) (31.312 1.625)) 0 0 0 nil nil)
schCreateWireLabel(cv nil '(31.312 1.125) "GIOL" "lowerLeft" "R90" "stick" 0.0625 nil)
schCreateWire(cv "route" "full" '((30.562 0.875) (30.562 1.625)) 0 0 0 nil nil)
schCreateWireLabel(cv nil '(30.562 1.125) "VDD_DAT" "lowerLeft" "R90" "stick" 0.0625 nil)
dbCreateInst(cv pdb3ac_v_gMaster "VREFDES2_bottom15" '(33.1875 0) "R0")
schCreateWire(cv "route" "full" '((32.999 0.000) (32.999 -0.750)) 0 0 0 nil nil)
schCreateWireLabel(cv nil '(32.999 -0.250) "VREFDES2" "lowerRight" "R90" "stick" 0.0625 nil)
schCreatePin(cv nil "VREFDES2" "inputOutput" nil '(32.999 -0.750) "R90")
schCreateWire(cv "route" "full" '((32.938 0.875) (32.938 1.625)) 0 0 0 nil nil)
schCreateWireLabel(cv nil '(32.938 1.125) "GND_DAT" "lowerLeft" "R90" "stick" 0.0625 nil)
schCreateWire(cv "route" "full" '((33.312 0.875) (33.312 1.625)) 0 0 0 nil nil)
schCreateWireLabel(cv nil '(33.312 1.125) "GIOL" "lowerLeft" "R90" "stick" 0.0625 nil)
schCreateWire(cv "route" "full" '((32.562 0.875) (32.562 1.625)) 0 0 0 nil nil)
schCreateWireLabel(cv nil '(32.562 1.125) "VDD_DAT" "lowerLeft" "R90" "stick" 0.0625 nil)
dbCreateInst(cv pdb3ac_v_gMaster "IBREF2_bottom16" '(35.1875 0) "R0")
schCreateWire(cv "route" "full" '((34.999 0.000) (34.999 -0.750)) 0 0 0 nil nil)
schCreateWireLabel(cv nil '(34.999 -0.250) "IBREF2" "lowerRight" "R90" "stick" 0.0625 nil)
schCreatePin(cv nil "IBREF2" "inputOutput" nil '(34.999 -0.750) "R90")
schCreateWire(cv "route" "full" '((34.938 0.875) (34.938 1.625)) 0 0 0 nil nil)
schCreateWireLabel(cv nil '(34.938 1.125) "GND_DAT" "lowerLeft" "R90" "stick" 0.0625 nil)
schCreateWire(cv "route" "full" '((35.312 0.875) (35.312 1.625)) 0 0 0 nil nil)
schCreateWireLabel(cv nil '(35.312 1.125) "GIOL" "lowerLeft" "R90" "stick" 0.0625 nil)
schCreateWire(cv "route" "full" '((34.562 0.875) (34.562 1.625)) 0 0 0 nil nil)
schCreateWireLabel(cv nil '(34.562 1.125) "VDD_DAT" "lowerLeft" "R90" "stick" 0.0625 nil)
dbCreateInst(cv pdb3ac_v_gMaster "VREFDES3_bottom17" '(37.1875 0) "R0")
schCreateWire(cv "route" "full" '((36.999 0.000) (36.999 -0.750)) 0 0 0 nil nil)
schCreateWireLabel(cv nil '(36.999 -0.250) "VREFDES3" "lowerRight" "R90" "stick" 0.0625 nil)
schCreatePin(cv nil "VREFDES3" "inputOutput" nil '(36.999 -0.750) "R90")
schCreateWire(cv "route" "full" '((36.938 0.875) (36.938 1.625)) 0 0 0 nil nil)
schCreateWireLabel(cv nil '(36.938 1.125) "GND_DAT" "lowerLeft" "R90" "stick" 0.0625 nil)
schCreateWire(cv "route" "full" '((37.312 0.875) (37.312 1.625)) 0 0 0 nil nil)
schCreateWireLabel(cv nil '(37.312 1.125) "GIOL" "lowerLeft" "R90" "stick" 0.0625 nil)
schCreateWire(cv "route" "full" '((36.562 0.875) (36.562 1.625)) 0 0 0 nil nil)
schCreateWireLabel(cv nil '(36.562 1.125) "VDD_DAT" "lowerLeft" "R90" "stick" 0.0625 nil)
dbCreateInst(cv pdb3ac_h_gMaster "IBREF3_right0" '(40.0 3.1875) "R90")
schCreateWire(cv "route" "full" '((40.000 2.999) (40.750 2.999)) 0 0 0 nil nil)
schCreateWireLabel(cv nil '(40.250 2.999) "IBREF3" "lowerLeft" "R0" "stick" 0.0625 nil)
schCreatePin(cv nil "IBREF3" "inputOutput" nil '(40.750 2.999) "R180")
schCreateWire(cv "route" "full" '((39.125 2.938) (38.375 2.938)) 0 0 0 nil nil)
schCreateWireLabel(cv nil '(38.875 2.938) "GND_DAT" "lowerRight" "R0" "stick" 0.0625 nil)
schCreateWire(cv "route" "full" '((39.125 3.312) (38.375 3.312)) 0 0 0 nil nil)
schCreateWireLabel(cv nil '(38.875 3.312) "GIOL" "lowerRight" "R0" "stick" 0.0625 nil)
schCreateWire(cv "route" "full" '((39.125 2.562) (38.375 2.562)) 0 0 0 nil nil)
schCreateWireLabel(cv nil '(38.875 2.562) "VDD_DAT" "lowerRight" "R0" "stick" 0.0625 nil)
dbCreateInst(cv pddw16sdgz_h_gMaster "SLP_right1" '(40.0 4.3125) "R90")
schCreateWire(cv "route" "full" '((39.000 4.438) (38.250 4.438)) 0 0 0 nil nil)
schCreateWireLabel(cv nil '(38.750 4.438) "GIOL" "lowerRight" "R0" "stick" 0.0625 nil)
schCreateWire(cv "route" "full" '((39.000 4.562) (38.250 4.562)) 0 0 0 nil nil)
schCreateWireLabel(cv nil '(38.750 4.562) "SLP_CORE" "lowerRight" "R0" "stick" 0.0625 nil)
schCreatePin(cv nil "SLP_CORE" "inputOutput" nil '(38.250 4.562) "R0")
schCreateWire(cv "route" "full" '((39.000 4.188) (38.250 4.188)) 0 0 0 nil nil)
schCreateWireLabel(cv nil '(38.750 4.188) "VIOL" "lowerRight" "R0" "stick" 0.0625 nil)
schCreateWire(cv "route" "full" '((39.000 4.062) (38.250 4.062)) 0 0 0 nil nil)
schCreateWireLabel(cv nil '(38.750 4.062) "GIOL" "lowerRight" "R0" "stick" 0.0625 nil)
schCreateWire(cv "route" "full" '((40.000 5.000) (40.750 5.000)) 0 0 0 nil nil)
schCreateWireLabel(cv nil '(40.250 5.000) "SLP" "lowerLeft" "R0" "stick" 0.0625 nil)
schCreatePin(cv nil "SLP" "inputOutput" nil '(40.750 5.000) "R180")
schCreateWire(cv "route" "full" '((39.000 4.688) (38.250 4.688)) 0 0 0 nil nil)
schCreateWireLabel(cv nil '(38.750 4.688) "POC" "lowerRight" "R0" "stick" 0.0625 nil)
schCreateWire(cv "route" "full" '((39.000 4.875) (38.250 4.875)) 0 0 0 nil nil)
schCreateWireLabel(cv nil '(38.750 4.875) "VIOL" "lowerRight" "R0" "stick" 0.0625 nil)
schCreateWire(cv "route" "full" '((39.000 5.062) (38.250 5.062)) 0 0 0 nil nil)
schCreateWireLabel(cv nil '(38.750 5.062) "GIOL" "lowerRight" "R0" "stick" 0.0625 nil)
schCreateWire(cv "route" "full" '((39.000 5.250) (38.250 5.250)) 0 0 0 nil nil)
schCreateWireLabel(cv nil '(38.750 5.250) "VIOH" "lowerRight" "R0" "stick" 0.0625 nil)
schCreateWire(cv "route" "full" '((39.000 5.625) (38.250 5.625)) 0 0 0 nil nil)
schCreateWireLabel(cv nil '(38.750 5.625) "GIOH" "lowerRight" "R0" "stick" 0.0625 nil)
dbCreateInst(cv pddw16sdgz_h_gMaster "SDI_right2" '(40.0 6.3125) "R90")
schCreateWire(cv "route" "full" '((39.000 6.438) (38.250 6.438)) 0 0 0 nil nil)
schCreateWireLabel(cv nil '(38.750 6.438) "GIOL" "lowerRight" "R0" "stick" 0.0625 nil)
schCreateWire(cv "route" "full" '((39.000 6.562) (38.250 6.562)) 0 0 0 nil nil)
schCreateWireLabel(cv nil '(38.750 6.562) "SDI_CORE" "lowerRight" "R0" "stick" 0.0625 nil)
schCreatePin(cv nil "SDI_CORE" "inputOutput" nil '(38.250 6.562) "R0")
schCreateWire(cv "route" "full" '((39.000 6.188) (38.250 6.188)) 0 0 0 nil nil)
schCreateWireLabel(cv nil '(38.750 6.188) "VIOL" "lowerRight" "R0" "stick" 0.0625 nil)
schCreateWire(cv "route" "full" '((39.000 6.062) (38.250 6.062)) 0 0 0 nil nil)
schCreateWireLabel(cv nil '(38.750 6.062) "GIOL" "lowerRight" "R0" "stick" 0.0625 nil)
schCreateWire(cv "route" "full" '((40.000 7.000) (40.750 7.000)) 0 0 0 nil nil)
schCreateWireLabel(cv nil '(40.250 7.000) "SDI" "lowerLeft" "R0" "stick" 0.0625 nil)
schCreatePin(cv nil "SDI" "inputOutput" nil '(40.750 7.000) "R180")
schCreateWire(cv "route" "full" '((39.000 6.688) (38.250 6.688)) 0 0 0 nil nil)
schCreateWireLabel(cv nil '(38.750 6.688) "POC" "lowerRight" "R0" "stick" 0.0625 nil)
schCreateWire(cv "route" "full" '((39.000 6.875) (38.250 6.875)) 0 0 0 nil nil)
schCreateWireLabel(cv nil '(38.750 6.875) "VIOL" "lowerRight" "R0" "stick" 0.0625 nil)
schCreateWire(cv "route" "full" '((39.000 7.062) (38.250 7.062)) 0 0 0 nil nil)
schCreateWireLabel(cv nil '(38.750 7.062) "GIOL" "lowerRight" "R0" "stick" 0.0625 nil)
schCreateWire(cv "route" "full" '((39.000 7.250) (38.250 7.250)) 0 0 0 nil nil)
schCreateWireLabel(cv nil '(38.750 7.250) "VIOH" "lowerRight" "R0" "stick" 0.0625 nil)
schCreateWire(cv "route" "full" '((39.000 7.625) (38.250 7.625)) 0 0 0 nil nil)
schCreateWireLabel(cv nil '(38.750 7.625) "GIOH" "lowerRight" "R0" "stick" 0.0625 nil)
dbCreateInst(cv pddw16sdgz_h_gMaster "SCK_right3" '(40.0 8.3125) "R90")
schCreateWire(cv "route" "full" '((39.000 8.438) (38.250 8.438)) 0 0 0 nil nil)
schCreateWireLabel(cv nil '(38.750 8.438) "GIOL" "lowerRight" "R0" "stick" 0.0625 nil)
schCreateWire(cv "route" "full" '((39.000 8.562) (38.250 8.562)) 0 0 0 nil nil)
schCreateWireLabel(cv nil '(38.750 8.562) "SCK_CORE" "lowerRight" "R0" "stick" 0.0625 nil)
schCreatePin(cv nil "SCK_CORE" "inputOutput" nil '(38.250 8.562) "R0")
schCreateWire(cv "route" "full" '((39.000 8.188) (38.250 8.188)) 0 0 0 nil nil)
schCreateWireLabel(cv nil '(38.750 8.188) "VIOL" "lowerRight" "R0" "stick" 0.0625 nil)
schCreateWire(cv "route" "full" '((39.000 8.062) (38.250 8.062)) 0 0 0 nil nil)
schCreateWireLabel(cv nil '(38.750 8.062) "GIOL" "lowerRight" "R0" "stick" 0.0625 nil)
schCreateWire(cv "route" "full" '((40.000 9.001) (40.750 9.001)) 0 0 0 nil nil)
schCreateWireLabel(cv nil '(40.250 9.001) "SCK" "lowerLeft" "R0" "stick" 0.0625 nil)
schCreatePin(cv nil "SCK" "inputOutput" nil '(40.750 9.001) "R180")
schCreateWire(cv "route" "full" '((39.000 8.688) (38.250 8.688)) 0 0 0 nil nil)
schCreateWireLabel(cv nil '(38.750 8.688) "POC" "lowerRight" "R0" "stick" 0.0625 nil)
schCreateWire(cv "route" "full" '((39.000 8.874) (38.250 8.874)) 0 0 0 nil nil)
schCreateWireLabel(cv nil '(38.750 8.874) "VIOL" "lowerRight" "R0" "stick" 0.0625 nil)
schCreateWire(cv "route" "full" '((39.000 9.062) (38.250 9.062)) 0 0 0 nil nil)
schCreateWireLabel(cv nil '(38.750 9.062) "GIOL" "lowerRight" "R0" "stick" 0.0625 nil)
schCreateWire(cv "route" "full" '((39.000 9.251) (38.250 9.251)) 0 0 0 nil nil)
schCreateWireLabel(cv nil '(38.750 9.251) "VIOH" "lowerRight" "R0" "stick" 0.0625 nil)
schCreateWire(cv "route" "full" '((39.000 9.624) (38.250 9.624)) 0 0 0 nil nil)
schCreateWireLabel(cv nil '(38.750 9.624) "GIOH" "lowerRight" "R0" "stick" 0.0625 nil)
dbCreateInst(cv pddw16sdgz_h_gMaster "SDO_right4" '(40.0 10.3125) "R90")
schCreateWire(cv "route" "full" '((39.000 10.438) (38.250 10.438)) 0 0 0 nil nil)
schCreateWireLabel(cv nil '(38.750 10.438) "VIOL" "lowerRight" "R0" "stick" 0.0625 nil)
schCreateWire(cv "route" "full" '((39.000 10.562) (38.250 10.562)) 0 0 0 nil nil)
dbCreateInst(cv noConnMaster "noConn_SDO_right4_C" '(38.250 10.562) "R270")
schCreateWire(cv "route" "full" '((39.000 10.188) (38.250 10.188)) 0 0 0 nil nil)
schCreateWireLabel(cv nil '(38.750 10.188) "GIOL" "lowerRight" "R0" "stick" 0.0625 nil)
schCreateWire(cv "route" "full" '((39.000 10.062) (38.250 10.062)) 0 0 0 nil nil)
schCreateWireLabel(cv nil '(38.750 10.062) "SDO_CORE" "lowerRight" "R0" "stick" 0.0625 nil)
schCreatePin(cv nil "SDO_CORE" "inputOutput" nil '(38.250 10.062) "R0")
schCreateWire(cv "route" "full" '((40.000 11.001) (40.750 11.001)) 0 0 0 nil nil)
schCreateWireLabel(cv nil '(40.250 11.001) "SDO" "lowerLeft" "R0" "stick" 0.0625 nil)
schCreatePin(cv nil "SDO" "inputOutput" nil '(40.750 11.001) "R180")
schCreateWire(cv "route" "full" '((39.000 10.688) (38.250 10.688)) 0 0 0 nil nil)
schCreateWireLabel(cv nil '(38.750 10.688) "POC" "lowerRight" "R0" "stick" 0.0625 nil)
schCreateWire(cv "route" "full" '((39.000 10.874) (38.250 10.874)) 0 0 0 nil nil)
schCreateWireLabel(cv nil '(38.750 10.874) "VIOL" "lowerRight" "R0" "stick" 0.0625 nil)
schCreateWire(cv "route" "full" '((39.000 11.062) (38.250 11.062)) 0 0 0 nil nil)
schCreateWireLabel(cv nil '(38.750 11.062) "GIOL" "lowerRight" "R0" "stick" 0.0625 nil)
schCreateWire(cv "route" "full" '((39.000 11.251) (38.250 11.251)) 0 0 0 nil nil)
schCreateWireLabel(cv nil '(38.750 11.251) "VIOH" "lowerRight" "R0" "stick" 0.0625 nil)
schCreateWire(cv "route" "full" '((39.000 11.624) (38.250 11.624)) 0 0 0 nil nil)
schCreateWireLabel(cv nil '(38.750 11.624) "GIOH" "lowerRight" "R0" "stick" 0.0625 nil)
dbCreateInst(cv pddw16sdgz_h_gMaster "RST_right5" '(40.0 12.3125) "R90")
schCreateWire(cv "route" "full" '((39.000 12.438) (38.250 12.438)) 0 0 0 nil nil)
schCreateWireLabel(cv nil '(38.750 12.438) "GIOL" "lowerRight" "R0" "stick" 0.0625 nil)
schCreateWire(cv "route" "full" '((39.000 12.562) (38.250 12.562)) 0 0 0 nil nil)
schCreateWireLabel(cv nil '(38.750 12.562) "RST_CORE" "lowerRight" "R0" "stick" 0.0625 nil)
schCreatePin(cv nil "RST_CORE" "inputOutput" nil '(38.250 12.562) "R0")
schCreateWire(cv "route" "full" '((39.000 12.188) (38.250 12.188)) 0 0 0 nil nil)
schCreateWireLabel(cv nil '(38.750 12.188) "VIOL" "lowerRight" "R0" "stick" 0.0625 nil)
schCreateWire(cv "route" "full" '((39.000 12.062) (38.250 12.062)) 0 0 0 nil nil)
schCreateWireLabel(cv nil '(38.750 12.062) "GIOL" "lowerRight" "R0" "stick" 0.0625 nil)
schCreateWire(cv "route" "full" '((40.000 13.001) (40.750 13.001)) 0 0 0 nil nil)
schCreateWireLabel(cv nil '(40.250 13.001) "RST" "lowerLeft" "R0" "stick" 0.0625 nil)
schCreatePin(cv nil "RST" "inputOutput" nil '(40.750 13.001) "R180")
schCreateWire(cv "route" "full" '((39.000 12.688) (38.250 12.688)) 0 0 0 nil nil)
schCreateWireLabel(cv nil '(38.750 12.688) "POC" "lowerRight" "R0" "stick" 0.0625 nil)
schCreateWire(cv "route" "full" '((39.000 12.874) (38.250 12.874)) 0 0 0 nil nil)
schCreateWireLabel(cv nil '(38.750 12.874) "VIOL" "lowerRight" "R0" "stick" 0.0625 nil)
schCreateWire(cv "route" "full" '((39.000 13.062) (38.250 13.062)) 0 0 0 nil nil)
schCreateWireLabel(cv nil '(38.750 13.062) "GIOL" "lowerRight" "R0" "stick" 0.0625 nil)
schCreateWire(cv "route" "full" '((39.000 13.251) (38.250 13.251)) 0 0 0 nil nil)
schCreateWireLabel(cv nil '(38.750 13.251) "VIOH" "lowerRight" "R0" "stick" 0.0625 nil)
schCreateWire(cv "route" "full" '((39.000 13.624) (38.250 13.624)) 0 0 0 nil nil)
schCreateWireLabel(cv nil '(38.750 13.624) "GIOH" "lowerRight" "R0" "stick" 0.0625 nil)
dbCreateInst(cv pddw16sdgz_h_gMaster "D0_right6" '(40.0 14.3125) "R90")
schCreateWire(cv "route" "full" '((39.000 14.438) (38.250 14.438)) 0 0 0 nil nil)
schCreateWireLabel(cv nil '(38.750 14.438) "VIOL" "lowerRight" "R0" "stick" 0.0625 nil)
schCreateWire(cv "route" "full" '((39.000 14.562) (38.250 14.562)) 0 0 0 nil nil)
dbCreateInst(cv noConnMaster "noConn_D0_right6_C" '(38.250 14.562) "R270")
schCreateWire(cv "route" "full" '((39.000 14.188) (38.250 14.188)) 0 0 0 nil nil)
schCreateWireLabel(cv nil '(38.750 14.188) "GIOL" "lowerRight" "R0" "stick" 0.0625 nil)
schCreateWire(cv "route" "full" '((39.000 14.062) (38.250 14.062)) 0 0 0 nil nil)
schCreateWireLabel(cv nil '(38.750 14.062) "D0_CORE" "lowerRight" "R0" "stick" 0.0625 nil)
schCreatePin(cv nil "D0_CORE" "inputOutput" nil '(38.250 14.062) "R0")
schCreateWire(cv "route" "full" '((40.000 15.001) (40.750 15.001)) 0 0 0 nil nil)
schCreateWireLabel(cv nil '(40.250 15.001) "D0" "lowerLeft" "R0" "stick" 0.0625 nil)
schCreatePin(cv nil "D0" "inputOutput" nil '(40.750 15.001) "R180")
schCreateWire(cv "route" "full" '((39.000 14.688) (38.250 14.688)) 0 0 0 nil nil)
schCreateWireLabel(cv nil '(38.750 14.688) "POC" "lowerRight" "R0" "stick" 0.0625 nil)
schCreateWire(cv "route" "full" '((39.000 14.874) (38.250 14.874)) 0 0 0 nil nil)
schCreateWireLabel(cv nil '(38.750 14.874) "VIOL" "lowerRight" "R0" "stick" 0.0625 nil)
schCreateWire(cv "route" "full" '((39.000 15.062) (38.250 15.062)) 0 0 0 nil nil)
schCreateWireLabel(cv nil '(38.750 15.062) "GIOL" "lowerRight" "R0" "stick" 0.0625 nil)
schCreateWire(cv "route" "full" '((39.000 15.251) (38.250 15.251)) 0 0 0 nil nil)
schCreateWireLabel(cv nil '(38.750 15.251) "VIOH" "lowerRight" "R0" "stick" 0.0625 nil)
schCreateWire(cv "route" "full" '((39.000 15.624) (38.250 15.624)) 0 0 0 nil nil)
schCreateWireLabel(cv nil '(38.750 15.624) "GIOH" "lowerRight" "R0" "stick" 0.0625 nil)
dbCreateInst(cv pddw16sdgz_h_gMaster "D1_right7" '(40.0 16.3125) "R90")
schCreateWire(cv "route" "full" '((39.000 16.438) (38.250 16.438)) 0 0 0 nil nil)
schCreateWireLabel(cv nil '(38.750 16.438) "VIOL" "lowerRight" "R0" "stick" 0.0625 nil)
schCreateWire(cv "route" "full" '((39.000 16.562) (38.250 16.562)) 0 0 0 nil nil)
dbCreateInst(cv noConnMaster "noConn_D1_right7_C" '(38.250 16.562) "R270")
schCreateWire(cv "route" "full" '((39.000 16.188) (38.250 16.188)) 0 0 0 nil nil)
schCreateWireLabel(cv nil '(38.750 16.188) "GIOL" "lowerRight" "R0" "stick" 0.0625 nil)
schCreateWire(cv "route" "full" '((39.000 16.062) (38.250 16.062)) 0 0 0 nil nil)
schCreateWireLabel(cv nil '(38.750 16.062) "D1_CORE" "lowerRight" "R0" "stick" 0.0625 nil)
schCreatePin(cv nil "D1_CORE" "inputOutput" nil '(38.250 16.062) "R0")
schCreateWire(cv "route" "full" '((40.000 17.000) (40.750 17.000)) 0 0 0 nil nil)
schCreateWireLabel(cv nil '(40.250 17.000) "D1" "lowerLeft" "R0" "stick" 0.0625 nil)
schCreatePin(cv nil "D1" "inputOutput" nil '(40.750 17.000) "R180")
schCreateWire(cv "route" "full" '((39.000 16.688) (38.250 16.688)) 0 0 0 nil nil)
schCreateWireLabel(cv nil '(38.750 16.688) "POC" "lowerRight" "R0" "stick" 0.0625 nil)
schCreateWire(cv "route" "full" '((39.000 16.875) (38.250 16.875)) 0 0 0 nil nil)
schCreateWireLabel(cv nil '(38.750 16.875) "VIOL" "lowerRight" "R0" "stick" 0.0625 nil)
schCreateWire(cv "route" "full" '((39.000 17.062) (38.250 17.062)) 0 0 0 nil nil)
schCreateWireLabel(cv nil '(38.750 17.062) "GIOL" "lowerRight" "R0" "stick" 0.0625 nil)
schCreateWire(cv "route" "full" '((39.000 17.250) (38.250 17.250)) 0 0 0 nil nil)
schCreateWireLabel(cv nil '(38.750 17.250) "VIOH" "lowerRight" "R0" "stick" 0.0625 nil)
schCreateWire(cv "route" "full" '((39.000 17.625) (38.250 17.625)) 0 0 0 nil nil)
schCreateWireLabel(cv nil '(38.750 17.625) "GIOH" "lowerRight" "R0" "stick" 0.0625 nil)
dbCreateInst(cv pddw16sdgz_h_gMaster "D2_right8" '(40.0 18.3125) "R90")
schCreateWire(cv "route" "full" '((39.000 18.438) (38.250 18.438)) 0 0 0 nil nil)
schCreateWireLabel(cv nil '(38.750 18.438) "VIOL" "lowerRight" "R0" "stick" 0.0625 nil)
schCreateWire(cv "route" "full" '((39.000 18.562) (38.250 18.562)) 0 0 0 nil nil)
dbCreateInst(cv noConnMaster "noConn_D2_right8_C" '(38.250 18.562) "R270")
schCreateWire(cv "route" "full" '((39.000 18.188) (38.250 18.188)) 0 0 0 nil nil)
schCreateWireLabel(cv nil '(38.750 18.188) "GIOL" "lowerRight" "R0" "stick" 0.0625 nil)
schCreateWire(cv "route" "full" '((39.000 18.062) (38.250 18.062)) 0 0 0 nil nil)
schCreateWireLabel(cv nil '(38.750 18.062) "D2_CORE" "lowerRight" "R0" "stick" 0.0625 nil)
schCreatePin(cv nil "D2_CORE" "inputOutput" nil '(38.250 18.062) "R0")
schCreateWire(cv "route" "full" '((40.000 19.000) (40.750 19.000)) 0 0 0 nil nil)
schCreateWireLabel(cv nil '(40.250 19.000) "D2" "lowerLeft" "R0" "stick" 0.0625 nil)
schCreatePin(cv nil "D2" "inputOutput" nil '(40.750 19.000) "R180")
schCreateWire(cv "route" "full" '((39.000 18.688) (38.250 18.688)) 0 0 0 nil nil)
schCreateWireLabel(cv nil '(38.750 18.688) "POC" "lowerRight" "R0" "stick" 0.0625 nil)
schCreateWire(cv "route" "full" '((39.000 18.875) (38.250 18.875)) 0 0 0 nil nil)
schCreateWireLabel(cv nil '(38.750 18.875) "VIOL" "lowerRight" "R0" "stick" 0.0625 nil)
schCreateWire(cv "route" "full" '((39.000 19.062) (38.250 19.062)) 0 0 0 nil nil)
schCreateWireLabel(cv nil '(38.750 19.062) "GIOL" "lowerRight" "R0" "stick" 0.0625 nil)
schCreateWire(cv "route" "full" '((39.000 19.250) (38.250 19.250)) 0 0 0 nil nil)
schCreateWireLabel(cv nil '(38.750 19.250) "VIOH" "lowerRight" "R0" "stick" 0.0625 nil)
schCreateWire(cv "route" "full" '((39.000 19.625) (38.250 19.625)) 0 0 0 nil nil)
schCreateWireLabel(cv nil '(38.750 19.625) "GIOH" "lowerRight" "R0" "stick" 0.0625 nil)
dbCreateInst(cv pddw16sdgz_h_gMaster "D3_right9" '(40.0 20.3125) "R90")
schCreateWire(cv "route" "full" '((39.000 20.438) (38.250 20.438)) 0 0 0 nil nil)
schCreateWireLabel(cv nil '(38.750 20.438) "VIOL" "lowerRight" "R0" "stick" 0.0625 nil)
schCreateWire(cv "route" "full" '((39.000 20.562) (38.250 20.562)) 0 0 0 nil nil)
dbCreateInst(cv noConnMaster "noConn_D3_right9_C" '(38.250 20.562) "R270")
schCreateWire(cv "route" "full" '((39.000 20.188) (38.250 20.188)) 0 0 0 nil nil)
schCreateWireLabel(cv nil '(38.750 20.188) "GIOL" "lowerRight" "R0" "stick" 0.0625 nil)
schCreateWire(cv "route" "full" '((39.000 20.062) (38.250 20.062)) 0 0 0 nil nil)
schCreateWireLabel(cv nil '(38.750 20.062) "D3_CORE" "lowerRight" "R0" "stick" 0.0625 nil)
schCreatePin(cv nil "D3_CORE" "inputOutput" nil '(38.250 20.062) "R0")
schCreateWire(cv "route" "full" '((40.000 21.000) (40.750 21.000)) 0 0 0 nil nil)
schCreateWireLabel(cv nil '(40.250 21.000) "D3" "lowerLeft" "R0" "stick" 0.0625 nil)
schCreatePin(cv nil "D3" "inputOutput" nil '(40.750 21.000) "R180")
schCreateWire(cv "route" "full" '((39.000 20.688) (38.250 20.688)) 0 0 0 nil nil)
schCreateWireLabel(cv nil '(38.750 20.688) "POC" "lowerRight" "R0" "stick" 0.0625 nil)
schCreateWire(cv "route" "full" '((39.000 20.875) (38.250 20.875)) 0 0 0 nil nil)
schCreateWireLabel(cv nil '(38.750 20.875) "VIOL" "lowerRight" "R0" "stick" 0.0625 nil)
schCreateWire(cv "route" "full" '((39.000 21.062) (38.250 21.062)) 0 0 0 nil nil)
schCreateWireLabel(cv nil '(38.750 21.062) "GIOL" "lowerRight" "R0" "stick" 0.0625 nil)
schCreateWire(cv "route" "full" '((39.000 21.250) (38.250 21.250)) 0 0 0 nil nil)
schCreateWireLabel(cv nil '(38.750 21.250) "VIOH" "lowerRight" "R0" "stick" 0.0625 nil)
schCreateWire(cv "route" "full" '((39.000 21.625) (38.250 21.625)) 0 0 0 nil nil)
schCreateWireLabel(cv nil '(38.750 21.625) "GIOH" "lowerRight" "R0" "stick" 0.0625 nil)
dbCreateInst(cv pddw16sdgz_h_gMaster "D4_right10" '(40.0 22.3125) "R90")
schCreateWire(cv "route" "full" '((39.000 22.438) (38.250 22.438)) 0 0 0 nil nil)
schCreateWireLabel(cv nil '(38.750 22.438) "VIOL" "lowerRight" "R0" "stick" 0.0625 nil)
schCreateWire(cv "route" "full" '((39.000 22.562) (38.250 22.562)) 0 0 0 nil nil)
dbCreateInst(cv noConnMaster "noConn_D4_right10_C" '(38.250 22.562) "R270")
schCreateWire(cv "route" "full" '((39.000 22.188) (38.250 22.188)) 0 0 0 nil nil)
schCreateWireLabel(cv nil '(38.750 22.188) "GIOL" "lowerRight" "R0" "stick" 0.0625 nil)
schCreateWire(cv "route" "full" '((39.000 22.062) (38.250 22.062)) 0 0 0 nil nil)
schCreateWireLabel(cv nil '(38.750 22.062) "D4_CORE" "lowerRight" "R0" "stick" 0.0625 nil)
schCreatePin(cv nil "D4_CORE" "inputOutput" nil '(38.250 22.062) "R0")
schCreateWire(cv "route" "full" '((40.000 23.000) (40.750 23.000)) 0 0 0 nil nil)
schCreateWireLabel(cv nil '(40.250 23.000) "D4" "lowerLeft" "R0" "stick" 0.0625 nil)
schCreatePin(cv nil "D4" "inputOutput" nil '(40.750 23.000) "R180")
schCreateWire(cv "route" "full" '((39.000 22.688) (38.250 22.688)) 0 0 0 nil nil)
schCreateWireLabel(cv nil '(38.750 22.688) "POC" "lowerRight" "R0" "stick" 0.0625 nil)
schCreateWire(cv "route" "full" '((39.000 22.875) (38.250 22.875)) 0 0 0 nil nil)
schCreateWireLabel(cv nil '(38.750 22.875) "VIOL" "lowerRight" "R0" "stick" 0.0625 nil)
schCreateWire(cv "route" "full" '((39.000 23.062) (38.250 23.062)) 0 0 0 nil nil)
schCreateWireLabel(cv nil '(38.750 23.062) "GIOL" "lowerRight" "R0" "stick" 0.0625 nil)
schCreateWire(cv "route" "full" '((39.000 23.250) (38.250 23.250)) 0 0 0 nil nil)
schCreateWireLabel(cv nil '(38.750 23.250) "VIOH" "lowerRight" "R0" "stick" 0.0625 nil)
schCreateWire(cv "route" "full" '((39.000 23.625) (38.250 23.625)) 0 0 0 nil nil)
schCreateWireLabel(cv nil '(38.750 23.625) "GIOH" "lowerRight" "R0" "stick" 0.0625 nil)
dbCreateInst(cv pddw16sdgz_h_gMaster "D5_right11" '(40.0 24.3125) "R90")
schCreateWire(cv "route" "full" '((39.000 24.438) (38.250 24.438)) 0 0 0 nil nil)
schCreateWireLabel(cv nil '(38.750 24.438) "VIOL" "lowerRight" "R0" "stick" 0.0625 nil)
schCreateWire(cv "route" "full" '((39.000 24.562) (38.250 24.562)) 0 0 0 nil nil)
dbCreateInst(cv noConnMaster "noConn_D5_right11_C" '(38.250 24.562) "R270")
schCreateWire(cv "route" "full" '((39.000 24.188) (38.250 24.188)) 0 0 0 nil nil)
schCreateWireLabel(cv nil '(38.750 24.188) "GIOL" "lowerRight" "R0" "stick" 0.0625 nil)
schCreateWire(cv "route" "full" '((39.000 24.062) (38.250 24.062)) 0 0 0 nil nil)
schCreateWireLabel(cv nil '(38.750 24.062) "D5_CORE" "lowerRight" "R0" "stick" 0.0625 nil)
schCreatePin(cv nil "D5_CORE" "inputOutput" nil '(38.250 24.062) "R0")
schCreateWire(cv "route" "full" '((40.000 25.000) (40.750 25.000)) 0 0 0 nil nil)
schCreateWireLabel(cv nil '(40.250 25.000) "D5" "lowerLeft" "R0" "stick" 0.0625 nil)
schCreatePin(cv nil "D5" "inputOutput" nil '(40.750 25.000) "R180")
schCreateWire(cv "route" "full" '((39.000 24.688) (38.250 24.688)) 0 0 0 nil nil)
schCreateWireLabel(cv nil '(38.750 24.688) "POC" "lowerRight" "R0" "stick" 0.0625 nil)
schCreateWire(cv "route" "full" '((39.000 24.875) (38.250 24.875)) 0 0 0 nil nil)
schCreateWireLabel(cv nil '(38.750 24.875) "VIOL" "lowerRight" "R0" "stick" 0.0625 nil)
schCreateWire(cv "route" "full" '((39.000 25.062) (38.250 25.062)) 0 0 0 nil nil)
schCreateWireLabel(cv nil '(38.750 25.062) "GIOL" "lowerRight" "R0" "stick" 0.0625 nil)
schCreateWire(cv "route" "full" '((39.000 25.250) (38.250 25.250)) 0 0 0 nil nil)
schCreateWireLabel(cv nil '(38.750 25.250) "VIOH" "lowerRight" "R0" "stick" 0.0625 nil)
schCreateWire(cv "route" "full" '((39.000 25.625) (38.250 25.625)) 0 0 0 nil nil)
schCreateWireLabel(cv nil '(38.750 25.625) "GIOH" "lowerRight" "R0" "stick" 0.0625 nil)
dbCreateInst(cv pddw16sdgz_h_gMaster "D6_right12" '(40.0 26.3125) "R90")
schCreateWire(cv "route" "full" '((39.000 26.438) (38.250 26.438)) 0 0 0 nil nil)
schCreateWireLabel(cv nil '(38.750 26.438) "VIOL" "lowerRight" "R0" "stick" 0.0625 nil)
schCreateWire(cv "route" "full" '((39.000 26.562) (38.250 26.562)) 0 0 0 nil nil)
dbCreateInst(cv noConnMaster "noConn_D6_right12_C" '(38.250 26.562) "R270")
schCreateWire(cv "route" "full" '((39.000 26.188) (38.250 26.188)) 0 0 0 nil nil)
schCreateWireLabel(cv nil '(38.750 26.188) "GIOL" "lowerRight" "R0" "stick" 0.0625 nil)
schCreateWire(cv "route" "full" '((39.000 26.062) (38.250 26.062)) 0 0 0 nil nil)
schCreateWireLabel(cv nil '(38.750 26.062) "D6_CORE" "lowerRight" "R0" "stick" 0.0625 nil)
schCreatePin(cv nil "D6_CORE" "inputOutput" nil '(38.250 26.062) "R0")
schCreateWire(cv "route" "full" '((40.000 27.000) (40.750 27.000)) 0 0 0 nil nil)
schCreateWireLabel(cv nil '(40.250 27.000) "D6" "lowerLeft" "R0" "stick" 0.0625 nil)
schCreatePin(cv nil "D6" "inputOutput" nil '(40.750 27.000) "R180")
schCreateWire(cv "route" "full" '((39.000 26.688) (38.250 26.688)) 0 0 0 nil nil)
schCreateWireLabel(cv nil '(38.750 26.688) "POC" "lowerRight" "R0" "stick" 0.0625 nil)
schCreateWire(cv "route" "full" '((39.000 26.875) (38.250 26.875)) 0 0 0 nil nil)
schCreateWireLabel(cv nil '(38.750 26.875) "VIOL" "lowerRight" "R0" "stick" 0.0625 nil)
schCreateWire(cv "route" "full" '((39.000 27.062) (38.250 27.062)) 0 0 0 nil nil)
schCreateWireLabel(cv nil '(38.750 27.062) "GIOL" "lowerRight" "R0" "stick" 0.0625 nil)
schCreateWire(cv "route" "full" '((39.000 27.250) (38.250 27.250)) 0 0 0 nil nil)
schCreateWireLabel(cv nil '(38.750 27.250) "VIOH" "lowerRight" "R0" "stick" 0.0625 nil)
schCreateWire(cv "route" "full" '((39.000 27.625) (38.250 27.625)) 0 0 0 nil nil)
schCreateWireLabel(cv nil '(38.750 27.625) "GIOH" "lowerRight" "R0" "stick" 0.0625 nil)
dbCreateInst(cv pddw16sdgz_h_gMaster "D7_right13" '(40.0 28.3125) "R90")
schCreateWire(cv "route" "full" '((39.000 28.438) (38.250 28.438)) 0 0 0 nil nil)
schCreateWireLabel(cv nil '(38.750 28.438) "VIOL" "lowerRight" "R0" "stick" 0.0625 nil)
schCreateWire(cv "route" "full" '((39.000 28.562) (38.250 28.562)) 0 0 0 nil nil)
dbCreateInst(cv noConnMaster "noConn_D7_right13_C" '(38.250 28.562) "R270")
schCreateWire(cv "route" "full" '((39.000 28.188) (38.250 28.188)) 0 0 0 nil nil)
schCreateWireLabel(cv nil '(38.750 28.188) "GIOL" "lowerRight" "R0" "stick" 0.0625 nil)
schCreateWire(cv "route" "full" '((39.000 28.062) (38.250 28.062)) 0 0 0 nil nil)
schCreateWireLabel(cv nil '(38.750 28.062) "D7_CORE" "lowerRight" "R0" "stick" 0.0625 nil)
schCreatePin(cv nil "D7_CORE" "inputOutput" nil '(38.250 28.062) "R0")
schCreateWire(cv "route" "full" '((40.000 29.000) (40.750 29.000)) 0 0 0 nil nil)
schCreateWireLabel(cv nil '(40.250 29.000) "D7" "lowerLeft" "R0" "stick" 0.0625 nil)
schCreatePin(cv nil "D7" "inputOutput" nil '(40.750 29.000) "R180")
schCreateWire(cv "route" "full" '((39.000 28.688) (38.250 28.688)) 0 0 0 nil nil)
schCreateWireLabel(cv nil '(38.750 28.688) "POC" "lowerRight" "R0" "stick" 0.0625 nil)
schCreateWire(cv "route" "full" '((39.000 28.875) (38.250 28.875)) 0 0 0 nil nil)
schCreateWireLabel(cv nil '(38.750 28.875) "VIOL" "lowerRight" "R0" "stick" 0.0625 nil)
schCreateWire(cv "route" "full" '((39.000 29.062) (38.250 29.062)) 0 0 0 nil nil)
schCreateWireLabel(cv nil '(38.750 29.062) "GIOL" "lowerRight" "R0" "stick" 0.0625 nil)
schCreateWire(cv "route" "full" '((39.000 29.250) (38.250 29.250)) 0 0 0 nil nil)
schCreateWireLabel(cv nil '(38.750 29.250) "VIOH" "lowerRight" "R0" "stick" 0.0625 nil)
schCreateWire(cv "route" "full" '((39.000 29.625) (38.250 29.625)) 0 0 0 nil nil)
schCreateWireLabel(cv nil '(38.750 29.625) "GIOH" "lowerRight" "R0" "stick" 0.0625 nil)
dbCreateInst(cv pddw16sdgz_h_gMaster "D8_right14" '(40.0 30.3125) "R90")
schCreateWire(cv "route" "full" '((39.000 30.438) (38.250 30.438)) 0 0 0 nil nil)
schCreateWireLabel(cv nil '(38.750 30.438) "VIOL" "lowerRight" "R0" "stick" 0.0625 nil)
schCreateWire(cv "route" "full" '((39.000 30.562) (38.250 30.562)) 0 0 0 nil nil)
dbCreateInst(cv noConnMaster "noConn_D8_right14_C" '(38.250 30.562) "R270")
schCreateWire(cv "route" "full" '((39.000 30.188) (38.250 30.188)) 0 0 0 nil nil)
schCreateWireLabel(cv nil '(38.750 30.188) "GIOL" "lowerRight" "R0" "stick" 0.0625 nil)
schCreateWire(cv "route" "full" '((39.000 30.062) (38.250 30.062)) 0 0 0 nil nil)
schCreateWireLabel(cv nil '(38.750 30.062) "D8_CORE" "lowerRight" "R0" "stick" 0.0625 nil)
schCreatePin(cv nil "D8_CORE" "inputOutput" nil '(38.250 30.062) "R0")
schCreateWire(cv "route" "full" '((40.000 31.000) (40.750 31.000)) 0 0 0 nil nil)
schCreateWireLabel(cv nil '(40.250 31.000) "D8" "lowerLeft" "R0" "stick" 0.0625 nil)
schCreatePin(cv nil "D8" "inputOutput" nil '(40.750 31.000) "R180")
schCreateWire(cv "route" "full" '((39.000 30.688) (38.250 30.688)) 0 0 0 nil nil)
schCreateWireLabel(cv nil '(38.750 30.688) "POC" "lowerRight" "R0" "stick" 0.0625 nil)
schCreateWire(cv "route" "full" '((39.000 30.875) (38.250 30.875)) 0 0 0 nil nil)
schCreateWireLabel(cv nil '(38.750 30.875) "VIOL" "lowerRight" "R0" "stick" 0.0625 nil)
schCreateWire(cv "route" "full" '((39.000 31.062) (38.250 31.062)) 0 0 0 nil nil)
schCreateWireLabel(cv nil '(38.750 31.062) "GIOL" "lowerRight" "R0" "stick" 0.0625 nil)
schCreateWire(cv "route" "full" '((39.000 31.250) (38.250 31.250)) 0 0 0 nil nil)
schCreateWireLabel(cv nil '(38.750 31.250) "VIOH" "lowerRight" "R0" "stick" 0.0625 nil)
schCreateWire(cv "route" "full" '((39.000 31.625) (38.250 31.625)) 0 0 0 nil nil)
schCreateWireLabel(cv nil '(38.750 31.625) "GIOH" "lowerRight" "R0" "stick" 0.0625 nil)
dbCreateInst(cv pddw16sdgz_h_gMaster "D9_right15" '(40.0 32.3125) "R90")
schCreateWire(cv "route" "full" '((39.000 32.438) (38.250 32.438)) 0 0 0 nil nil)
schCreateWireLabel(cv nil '(38.750 32.438) "VIOL" "lowerRight" "R0" "stick" 0.0625 nil)
schCreateWire(cv "route" "full" '((39.000 32.562) (38.250 32.562)) 0 0 0 nil nil)
dbCreateInst(cv noConnMaster "noConn_D9_right15_C" '(38.250 32.562) "R270")
schCreateWire(cv "route" "full" '((39.000 32.188) (38.250 32.188)) 0 0 0 nil nil)
schCreateWireLabel(cv nil '(38.750 32.188) "GIOL" "lowerRight" "R0" "stick" 0.0625 nil)
schCreateWire(cv "route" "full" '((39.000 32.062) (38.250 32.062)) 0 0 0 nil nil)
schCreateWireLabel(cv nil '(38.750 32.062) "D9_CORE" "lowerRight" "R0" "stick" 0.0625 nil)
schCreatePin(cv nil "D9_CORE" "inputOutput" nil '(38.250 32.062) "R0")
schCreateWire(cv "route" "full" '((40.000 33.001) (40.750 33.001)) 0 0 0 nil nil)
schCreateWireLabel(cv nil '(40.250 33.001) "D9" "lowerLeft" "R0" "stick" 0.0625 nil)
schCreatePin(cv nil "D9" "inputOutput" nil '(40.750 33.001) "R180")
schCreateWire(cv "route" "full" '((39.000 32.688) (38.250 32.688)) 0 0 0 nil nil)
schCreateWireLabel(cv nil '(38.750 32.688) "POC" "lowerRight" "R0" "stick" 0.0625 nil)
schCreateWire(cv "route" "full" '((39.000 32.874) (38.250 32.874)) 0 0 0 nil nil)
schCreateWireLabel(cv nil '(38.750 32.874) "VIOL" "lowerRight" "R0" "stick" 0.0625 nil)
schCreateWire(cv "route" "full" '((39.000 33.062) (38.250 33.062)) 0 0 0 nil nil)
schCreateWireLabel(cv nil '(38.750 33.062) "GIOL" "lowerRight" "R0" "stick" 0.0625 nil)
schCreateWire(cv "route" "full" '((39.000 33.251) (38.250 33.251)) 0 0 0 nil nil)
schCreateWireLabel(cv nil '(38.750 33.251) "VIOH" "lowerRight" "R0" "stick" 0.0625 nil)
schCreateWire(cv "route" "full" '((39.000 33.624) (38.250 33.624)) 0 0 0 nil nil)
schCreateWireLabel(cv nil '(38.750 33.624) "GIOH" "lowerRight" "R0" "stick" 0.0625 nil)
dbCreateInst(cv pddw16sdgz_h_gMaster "D10_right16" '(40.0 34.3125) "R90")
schCreateWire(cv "route" "full" '((39.000 34.438) (38.250 34.438)) 0 0 0 nil nil)
schCreateWireLabel(cv nil '(38.750 34.438) "VIOL" "lowerRight" "R0" "stick" 0.0625 nil)
schCreateWire(cv "route" "full" '((39.000 34.562) (38.250 34.562)) 0 0 0 nil nil)
dbCreateInst(cv noConnMaster "noConn_D10_right16_C" '(38.250 34.562) "R270")
schCreateWire(cv "route" "full" '((39.000 34.188) (38.250 34.188)) 0 0 0 nil nil)
schCreateWireLabel(cv nil '(38.750 34.188) "GIOL" "lowerRight" "R0" "stick" 0.0625 nil)
schCreateWire(cv "route" "full" '((39.000 34.062) (38.250 34.062)) 0 0 0 nil nil)
schCreateWireLabel(cv nil '(38.750 34.062) "D10_CORE" "lowerRight" "R0" "stick" 0.0625 nil)
schCreatePin(cv nil "D10_CORE" "inputOutput" nil '(38.250 34.062) "R0")
schCreateWire(cv "route" "full" '((40.000 35.001) (40.750 35.001)) 0 0 0 nil nil)
schCreateWireLabel(cv nil '(40.250 35.001) "D10" "lowerLeft" "R0" "stick" 0.0625 nil)
schCreatePin(cv nil "D10" "inputOutput" nil '(40.750 35.001) "R180")
schCreateWire(cv "route" "full" '((39.000 34.688) (38.250 34.688)) 0 0 0 nil nil)
schCreateWireLabel(cv nil '(38.750 34.688) "POC" "lowerRight" "R0" "stick" 0.0625 nil)
schCreateWire(cv "route" "full" '((39.000 34.874) (38.250 34.874)) 0 0 0 nil nil)
schCreateWireLabel(cv nil '(38.750 34.874) "VIOL" "lowerRight" "R0" "stick" 0.0625 nil)
schCreateWire(cv "route" "full" '((39.000 35.062) (38.250 35.062)) 0 0 0 nil nil)
schCreateWireLabel(cv nil '(38.750 35.062) "GIOL" "lowerRight" "R0" "stick" 0.0625 nil)
schCreateWire(cv "route" "full" '((39.000 35.251) (38.250 35.251)) 0 0 0 nil nil)
schCreateWireLabel(cv nil '(38.750 35.251) "VIOH" "lowerRight" "R0" "stick" 0.0625 nil)
schCreateWire(cv "route" "full" '((39.000 35.624) (38.250 35.624)) 0 0 0 nil nil)
schCreateWireLabel(cv nil '(38.750 35.624) "GIOH" "lowerRight" "R0" "stick" 0.0625 nil)
dbCreateInst(cv pddw16sdgz_h_gMaster "D11_right17" '(40.0 36.3125) "R90")
schCreateWire(cv "route" "full" '((39.000 36.438) (38.250 36.438)) 0 0 0 nil nil)
schCreateWireLabel(cv nil '(38.750 36.438) "VIOL" "lowerRight" "R0" "stick" 0.0625 nil)
schCreateWire(cv "route" "full" '((39.000 36.562) (38.250 36.562)) 0 0 0 nil nil)
dbCreateInst(cv noConnMaster "noConn_D11_right17_C" '(38.250 36.562) "R270")
schCreateWire(cv "route" "full" '((39.000 36.188) (38.250 36.188)) 0 0 0 nil nil)
schCreateWireLabel(cv nil '(38.750 36.188) "GIOL" "lowerRight" "R0" "stick" 0.0625 nil)
schCreateWire(cv "route" "full" '((39.000 36.062) (38.250 36.062)) 0 0 0 nil nil)
schCreateWireLabel(cv nil '(38.750 36.062) "D11_CORE" "lowerRight" "R0" "stick" 0.0625 nil)
schCreatePin(cv nil "D11_CORE" "inputOutput" nil '(38.250 36.062) "R0")
schCreateWire(cv "route" "full" '((40.000 37.001) (40.750 37.001)) 0 0 0 nil nil)
schCreateWireLabel(cv nil '(40.250 37.001) "D11" "lowerLeft" "R0" "stick" 0.0625 nil)
schCreatePin(cv nil "D11" "inputOutput" nil '(40.750 37.001) "R180")
schCreateWire(cv "route" "full" '((39.000 36.688) (38.250 36.688)) 0 0 0 nil nil)
schCreateWireLabel(cv nil '(38.750 36.688) "POC" "lowerRight" "R0" "stick" 0.0625 nil)
schCreateWire(cv "route" "full" '((39.000 36.874) (38.250 36.874)) 0 0 0 nil nil)
schCreateWireLabel(cv nil '(38.750 36.874) "VIOL" "lowerRight" "R0" "stick" 0.0625 nil)
schCreateWire(cv "route" "full" '((39.000 37.062) (38.250 37.062)) 0 0 0 nil nil)
schCreateWireLabel(cv nil '(38.750 37.062) "GIOL" "lowerRight" "R0" "stick" 0.0625 nil)
schCreateWire(cv "route" "full" '((39.000 37.251) (38.250 37.251)) 0 0 0 nil nil)
schCreateWireLabel(cv nil '(38.750 37.251) "VIOH" "lowerRight" "R0" "stick" 0.0625 nil)
schCreateWire(cv "route" "full" '((39.000 37.624) (38.250 37.624)) 0 0 0 nil nil)
schCreateWireLabel(cv nil '(38.750 37.624) "GIOH" "lowerRight" "R0" "stick" 0.0625 nil)
pddw16sdgz_v_gMaster = dbOpenCellView("tphn28hpcpgv18" "PDDW16SDGZ_V_G" "symbol")
dbCreateInst(cv pddw16sdgz_v_gMaster "D12_top0" '(37.6875 40.0) "R180")
schCreateWire(cv "route" "full" '((37.562 39.000) (37.562 38.250)) 0 0 0 nil nil)
schCreateWireLabel(cv nil '(37.562 38.750) "VIOL" "lowerRight" "R90" "stick" 0.0625 nil)
schCreateWire(cv "route" "full" '((37.438 39.000) (37.438 38.250)) 0 0 0 nil nil)
dbCreateInst(cv noConnMaster "noConn_D12_top0_C" '(37.438 38.250) "R0")
schCreateWire(cv "route" "full" '((37.812 39.000) (37.812 38.250)) 0 0 0 nil nil)
schCreateWireLabel(cv nil '(37.812 38.750) "GIOL" "lowerRight" "R90" "stick" 0.0625 nil)
schCreateWire(cv "route" "full" '((37.938 39.000) (37.938 38.250)) 0 0 0 nil nil)
schCreateWireLabel(cv nil '(37.938 38.750) "D12_CORE" "lowerRight" "R90" "stick" 0.0625 nil)
schCreatePin(cv nil "D12_CORE" "inputOutput" nil '(37.938 38.250) "R90")
schCreateWire(cv "route" "full" '((36.999 40.000) (36.999 40.750)) 0 0 0 nil nil)
schCreateWireLabel(cv nil '(36.999 40.250) "D12" "lowerLeft" "R90" "stick" 0.0625 nil)
schCreatePin(cv nil "D12" "inputOutput" nil '(36.999 40.750) "R270")
schCreateWire(cv "route" "full" '((37.312 39.000) (37.312 38.250)) 0 0 0 nil nil)
schCreateWireLabel(cv nil '(37.312 38.750) "POC" "lowerRight" "R90" "stick" 0.0625 nil)
schCreateWire(cv "route" "full" '((37.126 39.000) (37.126 38.250)) 0 0 0 nil nil)
schCreateWireLabel(cv nil '(37.126 38.750) "VIOL" "lowerRight" "R90" "stick" 0.0625 nil)
schCreateWire(cv "route" "full" '((36.938 39.000) (36.938 38.250)) 0 0 0 nil nil)
schCreateWireLabel(cv nil '(36.938 38.750) "GIOL" "lowerRight" "R90" "stick" 0.0625 nil)
schCreateWire(cv "route" "full" '((36.749 39.000) (36.749 38.250)) 0 0 0 nil nil)
schCreateWireLabel(cv nil '(36.749 38.750) "VIOH" "lowerRight" "R90" "stick" 0.0625 nil)
schCreateWire(cv "route" "full" '((36.376 39.000) (36.376 38.250)) 0 0 0 nil nil)
schCreateWireLabel(cv nil '(36.376 38.750) "GIOH" "lowerRight" "R90" "stick" 0.0625 nil)
dbCreateInst(cv pddw16sdgz_v_gMaster "D13_top1" '(35.6875 40.0) "R180")
schCreateWire(cv "route" "full" '((35.562 39.000) (35.562 38.250)) 0 0 0 nil nil)
schCreateWireLabel(cv nil '(35.562 38.750) "VIOL" "lowerRight" "R90" "stick" 0.0625 nil)
schCreateWire(cv "route" "full" '((35.438 39.000) (35.438 38.250)) 0 0 0 nil nil)
dbCreateInst(cv noConnMaster "noConn_D13_top1_C" '(35.438 38.250) "R0")
schCreateWire(cv "route" "full" '((35.812 39.000) (35.812 38.250)) 0 0 0 nil nil)
schCreateWireLabel(cv nil '(35.812 38.750) "GIOL" "lowerRight" "R90" "stick" 0.0625 nil)
schCreateWire(cv "route" "full" '((35.938 39.000) (35.938 38.250)) 0 0 0 nil nil)
schCreateWireLabel(cv nil '(35.938 38.750) "D13_CORE" "lowerRight" "R90" "stick" 0.0625 nil)
schCreatePin(cv nil "D13_CORE" "inputOutput" nil '(35.938 38.250) "R90")
schCreateWire(cv "route" "full" '((34.999 40.000) (34.999 40.750)) 0 0 0 nil nil)
schCreateWireLabel(cv nil '(34.999 40.250) "D13" "lowerLeft" "R90" "stick" 0.0625 nil)
schCreatePin(cv nil "D13" "inputOutput" nil '(34.999 40.750) "R270")
schCreateWire(cv "route" "full" '((35.312 39.000) (35.312 38.250)) 0 0 0 nil nil)
schCreateWireLabel(cv nil '(35.312 38.750) "POC" "lowerRight" "R90" "stick" 0.0625 nil)
schCreateWire(cv "route" "full" '((35.126 39.000) (35.126 38.250)) 0 0 0 nil nil)
schCreateWireLabel(cv nil '(35.126 38.750) "VIOL" "lowerRight" "R90" "stick" 0.0625 nil)
schCreateWire(cv "route" "full" '((34.938 39.000) (34.938 38.250)) 0 0 0 nil nil)
schCreateWireLabel(cv nil '(34.938 38.750) "GIOL" "lowerRight" "R90" "stick" 0.0625 nil)
schCreateWire(cv "route" "full" '((34.749 39.000) (34.749 38.250)) 0 0 0 nil nil)
schCreateWireLabel(cv nil '(34.749 38.750) "VIOH" "lowerRight" "R90" "stick" 0.0625 nil)
schCreateWire(cv "route" "full" '((34.376 39.000) (34.376 38.250)) 0 0 0 nil nil)
schCreateWireLabel(cv nil '(34.376 38.750) "GIOH" "lowerRight" "R90" "stick" 0.0625 nil)
dbCreateInst(cv pddw16sdgz_v_gMaster "D14_top2" '(33.6875 40.0) "R180")
schCreateWire(cv "route" "full" '((33.562 39.000) (33.562 38.250)) 0 0 0 nil nil)
schCreateWireLabel(cv nil '(33.562 38.750) "VIOL" "lowerRight" "R90" "stick" 0.0625 nil)
schCreateWire(cv "route" "full" '((33.438 39.000) (33.438 38.250)) 0 0 0 nil nil)
dbCreateInst(cv noConnMaster "noConn_D14_top2_C" '(33.438 38.250) "R0")
schCreateWire(cv "route" "full" '((33.812 39.000) (33.812 38.250)) 0 0 0 nil nil)
schCreateWireLabel(cv nil '(33.812 38.750) "GIOL" "lowerRight" "R90" "stick" 0.0625 nil)
schCreateWire(cv "route" "full" '((33.938 39.000) (33.938 38.250)) 0 0 0 nil nil)
schCreateWireLabel(cv nil '(33.938 38.750) "D14_CORE" "lowerRight" "R90" "stick" 0.0625 nil)
schCreatePin(cv nil "D14_CORE" "inputOutput" nil '(33.938 38.250) "R90")
schCreateWire(cv "route" "full" '((32.999 40.000) (32.999 40.750)) 0 0 0 nil nil)
schCreateWireLabel(cv nil '(32.999 40.250) "D14" "lowerLeft" "R90" "stick" 0.0625 nil)
schCreatePin(cv nil "D14" "inputOutput" nil '(32.999 40.750) "R270")
schCreateWire(cv "route" "full" '((33.312 39.000) (33.312 38.250)) 0 0 0 nil nil)
schCreateWireLabel(cv nil '(33.312 38.750) "POC" "lowerRight" "R90" "stick" 0.0625 nil)
schCreateWire(cv "route" "full" '((33.126 39.000) (33.126 38.250)) 0 0 0 nil nil)
schCreateWireLabel(cv nil '(33.126 38.750) "VIOL" "lowerRight" "R90" "stick" 0.0625 nil)
schCreateWire(cv "route" "full" '((32.938 39.000) (32.938 38.250)) 0 0 0 nil nil)
schCreateWireLabel(cv nil '(32.938 38.750) "GIOL" "lowerRight" "R90" "stick" 0.0625 nil)
schCreateWire(cv "route" "full" '((32.749 39.000) (32.749 38.250)) 0 0 0 nil nil)
schCreateWireLabel(cv nil '(32.749 38.750) "VIOH" "lowerRight" "R90" "stick" 0.0625 nil)
schCreateWire(cv "route" "full" '((32.376 39.000) (32.376 38.250)) 0 0 0 nil nil)
schCreateWireLabel(cv nil '(32.376 38.750) "GIOH" "lowerRight" "R90" "stick" 0.0625 nil)
dbCreateInst(cv pddw16sdgz_v_gMaster "D15_top3" '(31.6875 40.0) "R180")
schCreateWire(cv "route" "full" '((31.562 39.000) (31.562 38.250)) 0 0 0 nil nil)
schCreateWireLabel(cv nil '(31.562 38.750) "VIOL" "lowerRight" "R90" "stick" 0.0625 nil)
schCreateWire(cv "route" "full" '((31.438 39.000) (31.438 38.250)) 0 0 0 nil nil)
dbCreateInst(cv noConnMaster "noConn_D15_top3_C" '(31.438 38.250) "R0")
schCreateWire(cv "route" "full" '((31.812 39.000) (31.812 38.250)) 0 0 0 nil nil)
schCreateWireLabel(cv nil '(31.812 38.750) "GIOL" "lowerRight" "R90" "stick" 0.0625 nil)
schCreateWire(cv "route" "full" '((31.938 39.000) (31.938 38.250)) 0 0 0 nil nil)
schCreateWireLabel(cv nil '(31.938 38.750) "D15_CORE" "lowerRight" "R90" "stick" 0.0625 nil)
schCreatePin(cv nil "D15_CORE" "inputOutput" nil '(31.938 38.250) "R90")
schCreateWire(cv "route" "full" '((31.000 40.000) (31.000 40.750)) 0 0 0 nil nil)
schCreateWireLabel(cv nil '(31.000 40.250) "D15" "lowerLeft" "R90" "stick" 0.0625 nil)
schCreatePin(cv nil "D15" "inputOutput" nil '(31.000 40.750) "R270")
schCreateWire(cv "route" "full" '((31.312 39.000) (31.312 38.250)) 0 0 0 nil nil)
schCreateWireLabel(cv nil '(31.312 38.750) "POC" "lowerRight" "R90" "stick" 0.0625 nil)
schCreateWire(cv "route" "full" '((31.125 39.000) (31.125 38.250)) 0 0 0 nil nil)
schCreateWireLabel(cv nil '(31.125 38.750) "VIOL" "lowerRight" "R90" "stick" 0.0625 nil)
schCreateWire(cv "route" "full" '((30.938 39.000) (30.938 38.250)) 0 0 0 nil nil)
schCreateWireLabel(cv nil '(30.938 38.750) "GIOL" "lowerRight" "R90" "stick" 0.0625 nil)
schCreateWire(cv "route" "full" '((30.750 39.000) (30.750 38.250)) 0 0 0 nil nil)
schCreateWireLabel(cv nil '(30.750 38.750) "VIOH" "lowerRight" "R90" "stick" 0.0625 nil)
schCreateWire(cv "route" "full" '((30.375 39.000) (30.375 38.250)) 0 0 0 nil nil)
schCreateWireLabel(cv nil '(30.375 38.750) "GIOH" "lowerRight" "R90" "stick" 0.0625 nil)
dbCreateInst(cv pddw16sdgz_v_gMaster "CS_top4" '(29.6875 40.0) "R180")
schCreateWire(cv "route" "full" '((29.562 39.000) (29.562 38.250)) 0 0 0 nil nil)
schCreateWireLabel(cv nil '(29.562 38.750) "GIOL" "lowerRight" "R90" "stick" 0.0625 nil)
schCreateWire(cv "route" "full" '((29.438 39.000) (29.438 38.250)) 0 0 0 nil nil)
schCreateWireLabel(cv nil '(29.438 38.750) "CS_CORE" "lowerRight" "R90" "stick" 0.0625 nil)
schCreatePin(cv nil "CS_CORE" "inputOutput" nil '(29.438 38.250) "R90")
schCreateWire(cv "route" "full" '((29.812 39.000) (29.812 38.250)) 0 0 0 nil nil)
schCreateWireLabel(cv nil '(29.812 38.750) "VIOL" "lowerRight" "R90" "stick" 0.0625 nil)
schCreateWire(cv "route" "full" '((29.938 39.000) (29.938 38.250)) 0 0 0 nil nil)
schCreateWireLabel(cv nil '(29.938 38.750) "GIOL" "lowerRight" "R90" "stick" 0.0625 nil)
schCreateWire(cv "route" "full" '((29.000 40.000) (29.000 40.750)) 0 0 0 nil nil)
schCreateWireLabel(cv nil '(29.000 40.250) "CS" "lowerLeft" "R90" "stick" 0.0625 nil)
schCreatePin(cv nil "CS" "inputOutput" nil '(29.000 40.750) "R270")
schCreateWire(cv "route" "full" '((29.312 39.000) (29.312 38.250)) 0 0 0 nil nil)
schCreateWireLabel(cv nil '(29.312 38.750) "POC" "lowerRight" "R90" "stick" 0.0625 nil)
schCreateWire(cv "route" "full" '((29.125 39.000) (29.125 38.250)) 0 0 0 nil nil)
schCreateWireLabel(cv nil '(29.125 38.750) "VIOL" "lowerRight" "R90" "stick" 0.0625 nil)
schCreateWire(cv "route" "full" '((28.938 39.000) (28.938 38.250)) 0 0 0 nil nil)
schCreateWireLabel(cv nil '(28.938 38.750) "GIOL" "lowerRight" "R90" "stick" 0.0625 nil)
schCreateWire(cv "route" "full" '((28.750 39.000) (28.750 38.250)) 0 0 0 nil nil)
schCreateWireLabel(cv nil '(28.750 38.750) "VIOH" "lowerRight" "R90" "stick" 0.0625 nil)
schCreateWire(cv "route" "full" '((28.375 39.000) (28.375 38.250)) 0 0 0 nil nil)
schCreateWireLabel(cv nil '(28.375 38.750) "GIOH" "lowerRight" "R90" "stick" 0.0625 nil)
dbCreateInst(cv pddw16sdgz_v_gMaster "EN_top5" '(27.6875 40.0) "R180")
schCreateWire(cv "route" "full" '((27.562 39.000) (27.562 38.250)) 0 0 0 nil nil)
schCreateWireLabel(cv nil '(27.562 38.750) "GIOL" "lowerRight" "R90" "stick" 0.0625 nil)
schCreateWire(cv "route" "full" '((27.438 39.000) (27.438 38.250)) 0 0 0 nil nil)
schCreateWireLabel(cv nil '(27.438 38.750) "EN_CORE" "lowerRight" "R90" "stick" 0.0625 nil)
schCreatePin(cv nil "EN_CORE" "inputOutput" nil '(27.438 38.250) "R90")
schCreateWire(cv "route" "full" '((27.812 39.000) (27.812 38.250)) 0 0 0 nil nil)
schCreateWireLabel(cv nil '(27.812 38.750) "VIOL" "lowerRight" "R90" "stick" 0.0625 nil)
schCreateWire(cv "route" "full" '((27.938 39.000) (27.938 38.250)) 0 0 0 nil nil)
schCreateWireLabel(cv nil '(27.938 38.750) "GIOL" "lowerRight" "R90" "stick" 0.0625 nil)
schCreateWire(cv "route" "full" '((27.000 40.000) (27.000 40.750)) 0 0 0 nil nil)
schCreateWireLabel(cv nil '(27.000 40.250) "EN" "lowerLeft" "R90" "stick" 0.0625 nil)
schCreatePin(cv nil "EN" "inputOutput" nil '(27.000 40.750) "R270")
schCreateWire(cv "route" "full" '((27.312 39.000) (27.312 38.250)) 0 0 0 nil nil)
schCreateWireLabel(cv nil '(27.312 38.750) "POC" "lowerRight" "R90" "stick" 0.0625 nil)
schCreateWire(cv "route" "full" '((27.125 39.000) (27.125 38.250)) 0 0 0 nil nil)
schCreateWireLabel(cv nil '(27.125 38.750) "VIOL" "lowerRight" "R90" "stick" 0.0625 nil)
schCreateWire(cv "route" "full" '((26.938 39.000) (26.938 38.250)) 0 0 0 nil nil)
schCreateWireLabel(cv nil '(26.938 38.750) "GIOL" "lowerRight" "R90" "stick" 0.0625 nil)
schCreateWire(cv "route" "full" '((26.750 39.000) (26.750 38.250)) 0 0 0 nil nil)
schCreateWireLabel(cv nil '(26.750 38.750) "VIOH" "lowerRight" "R90" "stick" 0.0625 nil)
schCreateWire(cv "route" "full" '((26.375 39.000) (26.375 38.250)) 0 0 0 nil nil)
schCreateWireLabel(cv nil '(26.375 38.750) "GIOH" "lowerRight" "R90" "stick" 0.0625 nil)
dbCreateInst(cv pddw16sdgz_v_gMaster "TEST_top6" '(25.6875 40.0) "R180")
schCreateWire(cv "route" "full" '((25.562 39.000) (25.562 38.250)) 0 0 0 nil nil)
schCreateWireLabel(cv nil '(25.562 38.750) "GIOL" "lowerRight" "R90" "stick" 0.0625 nil)
schCreateWire(cv "route" "full" '((25.438 39.000) (25.438 38.250)) 0 0 0 nil nil)
schCreateWireLabel(cv nil '(25.438 38.750) "TEST_CORE" "lowerRight" "R90" "stick" 0.0625 nil)
schCreatePin(cv nil "TEST_CORE" "inputOutput" nil '(25.438 38.250) "R90")
schCreateWire(cv "route" "full" '((25.812 39.000) (25.812 38.250)) 0 0 0 nil nil)
schCreateWireLabel(cv nil '(25.812 38.750) "VIOL" "lowerRight" "R90" "stick" 0.0625 nil)
schCreateWire(cv "route" "full" '((25.938 39.000) (25.938 38.250)) 0 0 0 nil nil)
schCreateWireLabel(cv nil '(25.938 38.750) "GIOL" "lowerRight" "R90" "stick" 0.0625 nil)
schCreateWire(cv "route" "full" '((25.000 40.000) (25.000 40.750)) 0 0 0 nil nil)
schCreateWireLabel(cv nil '(25.000 40.250) "TEST" "lowerLeft" "R90" "stick" 0.0625 nil)
schCreatePin(cv nil "TEST" "inputOutput" nil '(25.000 40.750) "R270")
schCreateWire(cv "route" "full" '((25.312 39.000) (25.312 38.250)) 0 0 0 nil nil)
schCreateWireLabel(cv nil '(25.312 38.750) "POC" "lowerRight" "R90" "stick" 0.0625 nil)
schCreateWire(cv "route" "full" '((25.125 39.000) (25.125 38.250)) 0 0 0 nil nil)
schCreateWireLabel(cv nil '(25.125 38.750) "VIOL" "lowerRight" "R90" "stick" 0.0625 nil)
schCreateWire(cv "route" "full" '((24.938 39.000) (24.938 38.250)) 0 0 0 nil nil)
schCreateWireLabel(cv nil '(24.938 38.750) "GIOL" "lowerRight" "R90" "stick" 0.0625 nil)
schCreateWire(cv "route" "full" '((24.750 39.000) (24.750 38.250)) 0 0 0 nil nil)
schCreateWireLabel(cv nil '(24.750 38.750) "VIOH" "lowerRight" "R90" "stick" 0.0625 nil)
schCreateWire(cv "route" "full" '((24.375 39.000) (24.375 38.250)) 0 0 0 nil nil)
schCreateWireLabel(cv nil '(24.375 38.750) "GIOH" "lowerRight" "R90" "stick" 0.0625 nil)
dbCreateInst(cv pddw16sdgz_v_gMaster "RSTN_top7" '(23.6875 40.0) "R180")
schCreateWire(cv "route" "full" '((23.562 39.000) (23.562 38.250)) 0 0 0 nil nil)
schCreateWireLabel(cv nil '(23.562 38.750) "GIOL" "lowerRight" "R90" "stick" 0.0625 nil)
schCreateWire(cv "route" "full" '((23.438 39.000) (23.438 38.250)) 0 0 0 nil nil)
schCreateWireLabel(cv nil '(23.438 38.750) "RSTN_CORE" "lowerRight" "R90" "stick" 0.0625 nil)
schCreatePin(cv nil "RSTN_CORE" "inputOutput" nil '(23.438 38.250) "R90")
schCreateWire(cv "route" "full" '((23.812 39.000) (23.812 38.250)) 0 0 0 nil nil)
schCreateWireLabel(cv nil '(23.812 38.750) "VIOL" "lowerRight" "R90" "stick" 0.0625 nil)
schCreateWire(cv "route" "full" '((23.938 39.000) (23.938 38.250)) 0 0 0 nil nil)
schCreateWireLabel(cv nil '(23.938 38.750) "GIOL" "lowerRight" "R90" "stick" 0.0625 nil)
schCreateWire(cv "route" "full" '((23.000 40.000) (23.000 40.750)) 0 0 0 nil nil)
schCreateWireLabel(cv nil '(23.000 40.250) "RSTN" "lowerLeft" "R90" "stick" 0.0625 nil)
schCreatePin(cv nil "RSTN" "inputOutput" nil '(23.000 40.750) "R270")
schCreateWire(cv "route" "full" '((23.312 39.000) (23.312 38.250)) 0 0 0 nil nil)
schCreateWireLabel(cv nil '(23.312 38.750) "POC" "lowerRight" "R90" "stick" 0.0625 nil)
schCreateWire(cv "route" "full" '((23.125 39.000) (23.125 38.250)) 0 0 0 nil nil)
schCreateWireLabel(cv nil '(23.125 38.750) "VIOL" "lowerRight" "R90" "stick" 0.0625 nil)
schCreateWire(cv "route" "full" '((22.938 39.000) (22.938 38.250)) 0 0 0 nil nil)
schCreateWireLabel(cv nil '(22.938 38.750) "GIOL" "lowerRight" "R90" "stick" 0.0625 nil)
schCreateWire(cv "route" "full" '((22.750 39.000) (22.750 38.250)) 0 0 0 nil nil)
schCreateWireLabel(cv nil '(22.750 38.750) "VIOH" "lowerRight" "R90" "stick" 0.0625 nil)
schCreateWire(cv "route" "full" '((22.375 39.000) (22.375 38.250)) 0 0 0 nil nil)
schCreateWireLabel(cv nil '(22.375 38.750) "GIOH" "lowerRight" "R90" "stick" 0.0625 nil)
dbCreateInst(cv pddw16sdgz_v_gMaster "MCLK_top8" '(21.6875 40.0) "R180")
schCreateWire(cv "route" "full" '((21.562 39.000) (21.562 38.250)) 0 0 0 nil nil)
schCreateWireLabel(cv nil '(21.562 38.750) "GIOL" "lowerRight" "R90" "stick" 0.0625 nil)
schCreateWire(cv "route" "full" '((21.438 39.000) (21.438 38.250)) 0 0 0 nil nil)
schCreateWireLabel(cv nil '(21.438 38.750) "MCLK_CORE" "lowerRight" "R90" "stick" 0.0625 nil)
schCreatePin(cv nil "MCLK_CORE" "inputOutput" nil '(21.438 38.250) "R90")
schCreateWire(cv "route" "full" '((21.812 39.000) (21.812 38.250)) 0 0 0 nil nil)
schCreateWireLabel(cv nil '(21.812 38.750) "VIOL" "lowerRight" "R90" "stick" 0.0625 nil)
schCreateWire(cv "route" "full" '((21.938 39.000) (21.938 38.250)) 0 0 0 nil nil)
schCreateWireLabel(cv nil '(21.938 38.750) "GIOL" "lowerRight" "R90" "stick" 0.0625 nil)
schCreateWire(cv "route" "full" '((21.000 40.000) (21.000 40.750)) 0 0 0 nil nil)
schCreateWireLabel(cv nil '(21.000 40.250) "MCLK" "lowerLeft" "R90" "stick" 0.0625 nil)
schCreatePin(cv nil "MCLK" "inputOutput" nil '(21.000 40.750) "R270")
schCreateWire(cv "route" "full" '((21.312 39.000) (21.312 38.250)) 0 0 0 nil nil)
schCreateWireLabel(cv nil '(21.312 38.750) "POC" "lowerRight" "R90" "stick" 0.0625 nil)
schCreateWire(cv "route" "full" '((21.125 39.000) (21.125 38.250)) 0 0 0 nil nil)
schCreateWireLabel(cv nil '(21.125 38.750) "VIOL" "lowerRight" "R90" "stick" 0.0625 nil)
schCreateWire(cv "route" "full" '((20.938 39.000) (20.938 38.250)) 0 0 0 nil nil)
schCreateWireLabel(cv nil '(20.938 38.750) "GIOL" "lowerRight" "R90" "stick" 0.0625 nil)
schCreateWire(cv "route" "full" '((20.750 39.000) (20.750 38.250)) 0 0 0 nil nil)
schCreateWireLabel(cv nil '(20.750 38.750) "VIOH" "lowerRight" "R90" "stick" 0.0625 nil)
schCreateWire(cv "route" "full" '((20.375 39.000) (20.375 38.250)) 0 0 0 nil nil)
schCreateWireLabel(cv nil '(20.375 38.750) "GIOH" "lowerRight" "R90" "stick" 0.0625 nil)
dbCreateInst(cv pddw16sdgz_v_gMaster "SCLK_top9" '(19.6875 40.0) "R180")
schCreateWire(cv "route" "full" '((19.562 39.000) (19.562 38.250)) 0 0 0 nil nil)
schCreateWireLabel(cv nil '(19.562 38.750) "GIOL" "lowerRight" "R90" "stick" 0.0625 nil)
schCreateWire(cv "route" "full" '((19.438 39.000) (19.438 38.250)) 0 0 0 nil nil)
schCreateWireLabel(cv nil '(19.438 38.750) "SCLK_CORE" "lowerRight" "R90" "stick" 0.0625 nil)
schCreatePin(cv nil "SCLK_CORE" "inputOutput" nil '(19.438 38.250) "R90")
schCreateWire(cv "route" "full" '((19.812 39.000) (19.812 38.250)) 0 0 0 nil nil)
schCreateWireLabel(cv nil '(19.812 38.750) "VIOL" "lowerRight" "R90" "stick" 0.0625 nil)
schCreateWire(cv "route" "full" '((19.938 39.000) (19.938 38.250)) 0 0 0 nil nil)
schCreateWireLabel(cv nil '(19.938 38.750) "GIOL" "lowerRight" "R90" "stick" 0.0625 nil)
schCreateWire(cv "route" "full" '((19.000 40.000) (19.000 40.750)) 0 0 0 nil nil)
schCreateWireLabel(cv nil '(19.000 40.250) "SCLK" "lowerLeft" "R90" "stick" 0.0625 nil)
schCreatePin(cv nil "SCLK" "inputOutput" nil '(19.000 40.750) "R270")
schCreateWire(cv "route" "full" '((19.312 39.000) (19.312 38.250)) 0 0 0 nil nil)
schCreateWireLabel(cv nil '(19.312 38.750) "POC" "lowerRight" "R90" "stick" 0.0625 nil)
schCreateWire(cv "route" "full" '((19.125 39.000) (19.125 38.250)) 0 0 0 nil nil)
schCreateWireLabel(cv nil '(19.125 38.750) "VIOL" "lowerRight" "R90" "stick" 0.0625 nil)
schCreateWire(cv "route" "full" '((18.938 39.000) (18.938 38.250)) 0 0 0 nil nil)
schCreateWireLabel(cv nil '(18.938 38.750) "GIOL" "lowerRight" "R90" "stick" 0.0625 nil)
schCreateWire(cv "route" "full" '((18.750 39.000) (18.750 38.250)) 0 0 0 nil nil)
schCreateWireLabel(cv nil '(18.750 38.750) "VIOH" "lowerRight" "R90" "stick" 0.0625 nil)
schCreateWire(cv "route" "full" '((18.375 39.000) (18.375 38.250)) 0 0 0 nil nil)
schCreateWireLabel(cv nil '(18.375 38.750) "GIOH" "lowerRight" "R90" "stick" 0.0625 nil)
dbCreateInst(cv pddw16sdgz_v_gMaster "LRCK_top10" '(17.6875 40.0) "R180")
schCreateWire(cv "route" "full" '((17.562 39.000) (17.562 38.250)) 0 0 0 nil nil)
schCreateWireLabel(cv nil '(17.562 38.750) "GIOL" "lowerRight" "R90" "stick" 0.0625 nil)
schCreateWire(cv "route" "full" '((17.438 39.000) (17.438 38.250)) 0 0 0 nil nil)
schCreateWireLabel(cv nil '(17.438 38.750) "LRCK_CORE" "lowerRight" "R90" "stick" 0.0625 nil)
schCreatePin(cv nil "LRCK_CORE" "inputOutput" nil '(17.438 38.250) "R90")
schCreateWire(cv "route" "full" '((17.812 39.000) (17.812 38.250)) 0 0 0 nil nil)
schCreateWireLabel(cv nil '(17.812 38.750) "VIOL" "lowerRight" "R90" "stick" 0.0625 nil)
schCreateWire(cv "route" "full" '((17.938 39.000) (17.938 38.250)) 0 0 0 nil nil)
schCreateWireLabel(cv nil '(17.938 38.750) "GIOL" "lowerRight" "R90" "stick" 0.0625 nil)
schCreateWire(cv "route" "full" '((17.000 40.000) (17.000 40.750)) 0 0 0 nil nil)
schCreateWireLabel(cv nil '(17.000 40.250) "LRCK" "lowerLeft" "R90" "stick" 0.0625 nil)
schCreatePin(cv nil "LRCK" "inputOutput" nil '(17.000 40.750) "R270")
schCreateWire(cv "route" "full" '((17.312 39.000) (17.312 38.250)) 0 0 0 nil nil)
schCreateWireLabel(cv nil '(17.312 38.750) "POC" "lowerRight" "R90" "stick" 0.0625 nil)
schCreateWire(cv "route" "full" '((17.125 39.000) (17.125 38.250)) 0 0 0 nil nil)
schCreateWireLabel(cv nil '(17.125 38.750) "VIOL" "lowerRight" "R90" "stick" 0.0625 nil)
schCreateWire(cv "route" "full" '((16.938 39.000) (16.938 38.250)) 0 0 0 nil nil)
schCreateWireLabel(cv nil '(16.938 38.750) "GIOL" "lowerRight" "R90" "stick" 0.0625 nil)
schCreateWire(cv "route" "full" '((16.750 39.000) (16.750 38.250)) 0 0 0 nil nil)
schCreateWireLabel(cv nil '(16.750 38.750) "VIOH" "lowerRight" "R90" "stick" 0.0625 nil)
schCreateWire(cv "route" "full" '((16.375 39.000) (16.375 38.250)) 0 0 0 nil nil)
schCreateWireLabel(cv nil '(16.375 38.750) "GIOH" "lowerRight" "R90" "stick" 0.0625 nil)
dbCreateInst(cv pddw16sdgz_v_gMaster "DIN_top11" '(15.6875 40.0) "R180")
schCreateWire(cv "route" "full" '((15.562 39.000) (15.562 38.250)) 0 0 0 nil nil)
schCreateWireLabel(cv nil '(15.562 38.750) "GIOL" "lowerRight" "R90" "stick" 0.0625 nil)
schCreateWire(cv "route" "full" '((15.438 39.000) (15.438 38.250)) 0 0 0 nil nil)
schCreateWireLabel(cv nil '(15.438 38.750) "DIN_CORE" "lowerRight" "R90" "stick" 0.0625 nil)
schCreatePin(cv nil "DIN_CORE" "inputOutput" nil '(15.438 38.250) "R90")
schCreateWire(cv "route" "full" '((15.812 39.000) (15.812 38.250)) 0 0 0 nil nil)
schCreateWireLabel(cv nil '(15.812 38.750) "VIOL" "lowerRight" "R90" "stick" 0.0625 nil)
schCreateWire(cv "route" "full" '((15.938 39.000) (15.938 38.250)) 0 0 0 nil nil)
schCreateWireLabel(cv nil '(15.938 38.750) "GIOL" "lowerRight" "R90" "stick" 0.0625 nil)
schCreateWire(cv "route" "full" '((14.999 40.000) (14.999 40.750)) 0 0 0 nil nil)
schCreateWireLabel(cv nil '(14.999 40.250) "DIN" "lowerLeft" "R90" "stick" 0.0625 nil)
schCreatePin(cv nil "DIN" "inputOutput" nil '(14.999 40.750) "R270")
schCreateWire(cv "route" "full" '((15.312 39.000) (15.312 38.250)) 0 0 0 nil nil)
schCreateWireLabel(cv nil '(15.312 38.750) "POC" "lowerRight" "R90" "stick" 0.0625 nil)
schCreateWire(cv "route" "full" '((15.126 39.000) (15.126 38.250)) 0 0 0 nil nil)
schCreateWireLabel(cv nil '(15.126 38.750) "VIOL" "lowerRight" "R90" "stick" 0.0625 nil)
schCreateWire(cv "route" "full" '((14.938 39.000) (14.938 38.250)) 0 0 0 nil nil)
schCreateWireLabel(cv nil '(14.938 38.750) "GIOL" "lowerRight" "R90" "stick" 0.0625 nil)
schCreateWire(cv "route" "full" '((14.749 39.000) (14.749 38.250)) 0 0 0 nil nil)
schCreateWireLabel(cv nil '(14.749 38.750) "VIOH" "lowerRight" "R90" "stick" 0.0625 nil)
schCreateWire(cv "route" "full" '((14.376 39.000) (14.376 38.250)) 0 0 0 nil nil)
schCreateWireLabel(cv nil '(14.376 38.750) "GIOH" "lowerRight" "R90" "stick" 0.0625 nil)
dbCreateInst(cv pddw16sdgz_v_gMaster "DOUT_top12" '(13.6875 40.0) "R180")
schCreateWire(cv "route" "full" '((13.562 39.000) (13.562 38.250)) 0 0 0 nil nil)
schCreateWireLabel(cv nil '(13.562 38.750) "VIOL" "lowerRight" "R90" "stick" 0.0625 nil)
schCreateWire(cv "route" "full" '((13.438 39.000) (13.438 38.250)) 0 0 0 nil nil)
dbCreateInst(cv noConnMaster "noConn_DOUT_top12_C" '(13.438 38.250) "R0")
schCreateWire(cv "route" "full" '((13.812 39.000) (13.812 38.250)) 0 0 0 nil nil)
schCreateWireLabel(cv nil '(13.812 38.750) "GIOL" "lowerRight" "R90" "stick" 0.0625 nil)
schCreateWire(cv "route" "full" '((13.938 39.000) (13.938 38.250)) 0 0 0 nil nil)
schCreateWireLabel(cv nil '(13.938 38.750) "DOUT_CORE" "lowerRight" "R90" "stick" 0.0625 nil)
schCreatePin(cv nil "DOUT_CORE" "inputOutput" nil '(13.938 38.250) "R90")
schCreateWire(cv "route" "full" '((12.999 40.000) (12.999 40.750)) 0 0 0 nil nil)
schCreateWireLabel(cv nil '(12.999 40.250) "DOUT" "lowerLeft" "R90" "stick" 0.0625 nil)
schCreatePin(cv nil "DOUT" "inputOutput" nil '(12.999 40.750) "R270")
schCreateWire(cv "route" "full" '((13.312 39.000) (13.312 38.250)) 0 0 0 nil nil)
schCreateWireLabel(cv nil '(13.312 38.750) "POC" "lowerRight" "R90" "stick" 0.0625 nil)
schCreateWire(cv "route" "full" '((13.126 39.000) (13.126 38.250)) 0 0 0 nil nil)
schCreateWireLabel(cv nil '(13.126 38.750) "VIOL" "lowerRight" "R90" "stick" 0.0625 nil)
schCreateWire(cv "route" "full" '((12.938 39.000) (12.938 38.250)) 0 0 0 nil nil)
schCreateWireLabel(cv nil '(12.938 38.750) "GIOL" "lowerRight" "R90" "stick" 0.0625 nil)
schCreateWire(cv "route" "full" '((12.749 39.000) (12.749 38.250)) 0 0 0 nil nil)
schCreateWireLabel(cv nil '(12.749 38.750) "VIOH" "lowerRight" "R90" "stick" 0.0625 nil)
schCreateWire(cv "route" "full" '((12.376 39.000) (12.376 38.250)) 0 0 0 nil nil)
schCreateWireLabel(cv nil '(12.376 38.750) "GIOH" "lowerRight" "R90" "stick" 0.0625 nil)
dbCreateInst(cv pddw16sdgz_v_gMaster "DOUT1_top13" '(11.6875 40.0) "R180")
schCreateWire(cv "route" "full" '((11.562 39.000) (11.562 38.250)) 0 0 0 nil nil)
schCreateWireLabel(cv nil '(11.562 38.750) "VIOL" "lowerRight" "R90" "stick" 0.0625 nil)
schCreateWire(cv "route" "full" '((11.438 39.000) (11.438 38.250)) 0 0 0 nil nil)
dbCreateInst(cv noConnMaster "noConn_DOUT1_top13_C" '(11.438 38.250) "R0")
schCreateWire(cv "route" "full" '((11.812 39.000) (11.812 38.250)) 0 0 0 nil nil)
schCreateWireLabel(cv nil '(11.812 38.750) "GIOL" "lowerRight" "R90" "stick" 0.0625 nil)
schCreateWire(cv "route" "full" '((11.938 39.000) (11.938 38.250)) 0 0 0 nil nil)
schCreateWireLabel(cv nil '(11.938 38.750) "DOUT1_CORE" "lowerRight" "R90" "stick" 0.0625 nil)
schCreatePin(cv nil "DOUT1_CORE" "inputOutput" nil '(11.938 38.250) "R90")
schCreateWire(cv "route" "full" '((10.999 40.000) (10.999 40.750)) 0 0 0 nil nil)
schCreateWireLabel(cv nil '(10.999 40.250) "DOUT1" "lowerLeft" "R90" "stick" 0.0625 nil)
schCreatePin(cv nil "DOUT1" "inputOutput" nil '(10.999 40.750) "R270")
schCreateWire(cv "route" "full" '((11.312 39.000) (11.312 38.250)) 0 0 0 nil nil)
schCreateWireLabel(cv nil '(11.312 38.750) "POC" "lowerRight" "R90" "stick" 0.0625 nil)
schCreateWire(cv "route" "full" '((11.126 39.000) (11.126 38.250)) 0 0 0 nil nil)
schCreateWireLabel(cv nil '(11.126 38.750) "VIOL" "lowerRight" "R90" "stick" 0.0625 nil)
schCreateWire(cv "route" "full" '((10.938 39.000) (10.938 38.250)) 0 0 0 nil nil)
schCreateWireLabel(cv nil '(10.938 38.750) "GIOL" "lowerRight" "R90" "stick" 0.0625 nil)
schCreateWire(cv "route" "full" '((10.749 39.000) (10.749 38.250)) 0 0 0 nil nil)
schCreateWireLabel(cv nil '(10.749 38.750) "VIOH" "lowerRight" "R90" "stick" 0.0625 nil)
schCreateWire(cv "route" "full" '((10.376 39.000) (10.376 38.250)) 0 0 0 nil nil)
schCreateWireLabel(cv nil '(10.376 38.750) "GIOH" "lowerRight" "R90" "stick" 0.0625 nil)
dbCreateInst(cv pddw16sdgz_v_gMaster "DOUT2_top14" '(9.6875 40.0) "R180")
schCreateWire(cv "route" "full" '((9.562 39.000) (9.562 38.250)) 0 0 0 nil nil)
schCreateWireLabel(cv nil '(9.562 38.750) "VIOL" "lowerRight" "R90" "stick" 0.0625 nil)
schCreateWire(cv "route" "full" '((9.438 39.000) (9.438 38.250)) 0 0 0 nil nil)
dbCreateInst(cv noConnMaster "noConn_DOUT2_top14_C" '(9.438 38.250) "R0")
schCreateWire(cv "route" "full" '((9.812 39.000) (9.812 38.250)) 0 0 0 nil nil)
schCreateWireLabel(cv nil '(9.812 38.750) "GIOL" "lowerRight" "R90" "stick" 0.0625 nil)
schCreateWire(cv "route" "full" '((9.938 39.000) (9.938 38.250)) 0 0 0 nil nil)
schCreateWireLabel(cv nil '(9.938 38.750) "DOUT2_CORE" "lowerRight" "R90" "stick" 0.0625 nil)
schCreatePin(cv nil "DOUT2_CORE" "inputOutput" nil '(9.938 38.250) "R90")
schCreateWire(cv "route" "full" '((8.999 40.000) (8.999 40.750)) 0 0 0 nil nil)
schCreateWireLabel(cv nil '(8.999 40.250) "DOUT2" "lowerLeft" "R90" "stick" 0.0625 nil)
schCreatePin(cv nil "DOUT2" "inputOutput" nil '(8.999 40.750) "R270")
schCreateWire(cv "route" "full" '((9.312 39.000) (9.312 38.250)) 0 0 0 nil nil)
schCreateWireLabel(cv nil '(9.312 38.750) "POC" "lowerRight" "R90" "stick" 0.0625 nil)
schCreateWire(cv "route" "full" '((9.126 39.000) (9.126 38.250)) 0 0 0 nil nil)
schCreateWireLabel(cv nil '(9.126 38.750) "VIOL" "lowerRight" "R90" "stick" 0.0625 nil)
schCreateWire(cv "route" "full" '((8.938 39.000) (8.938 38.250)) 0 0 0 nil nil)
schCreateWireLabel(cv nil '(8.938 38.750) "GIOL" "lowerRight" "R90" "stick" 0.0625 nil)
schCreateWire(cv "route" "full" '((8.749 39.000) (8.749 38.250)) 0 0 0 nil nil)
schCreateWireLabel(cv nil '(8.749 38.750) "VIOH" "lowerRight" "R90" "stick" 0.0625 nil)
schCreateWire(cv "route" "full" '((8.376 39.000) (8.376 38.250)) 0 0 0 nil nil)
schCreateWireLabel(cv nil '(8.376 38.750) "GIOH" "lowerRight" "R90" "stick" 0.0625 nil)
dbCreateInst(cv pddw16sdgz_v_gMaster "DOUT3_top15" '(7.6875 40.0) "R180")
schCreateWire(cv "route" "full" '((7.562 39.000) (7.562 38.250)) 0 0 0 nil nil)
schCreateWireLabel(cv nil '(7.562 38.750) "VIOL" "lowerRight" "R90" "stick" 0.0625 nil)
schCreateWire(cv "route" "full" '((7.438 39.000) (7.438 38.250)) 0 0 0 nil nil)
dbCreateInst(cv noConnMaster "noConn_DOUT3_top15_C" '(7.438 38.250) "R0")
schCreateWire(cv "route" "full" '((7.812 39.000) (7.812 38.250)) 0 0 0 nil nil)
schCreateWireLabel(cv nil '(7.812 38.750) "GIOL" "lowerRight" "R90" "stick" 0.0625 nil)
schCreateWire(cv "route" "full" '((7.938 39.000) (7.938 38.250)) 0 0 0 nil nil)
schCreateWireLabel(cv nil '(7.938 38.750) "DOUT3_CORE" "lowerRight" "R90" "stick" 0.0625 nil)
schCreatePin(cv nil "DOUT3_CORE" "inputOutput" nil '(7.938 38.250) "R90")
schCreateWire(cv "route" "full" '((7.000 40.000) (7.000 40.750)) 0 0 0 nil nil)
schCreateWireLabel(cv nil '(7.000 40.250) "DOUT3" "lowerLeft" "R90" "stick" 0.0625 nil)
schCreatePin(cv nil "DOUT3" "inputOutput" nil '(7.000 40.750) "R270")
schCreateWire(cv "route" "full" '((7.312 39.000) (7.312 38.250)) 0 0 0 nil nil)
schCreateWireLabel(cv nil '(7.312 38.750) "POC" "lowerRight" "R90" "stick" 0.0625 nil)
schCreateWire(cv "route" "full" '((7.125 39.000) (7.125 38.250)) 0 0 0 nil nil)
schCreateWireLabel(cv nil '(7.125 38.750) "VIOL" "lowerRight" "R90" "stick" 0.0625 nil)
schCreateWire(cv "route" "full" '((6.938 39.000) (6.938 38.250)) 0 0 0 nil nil)
schCreateWireLabel(cv nil '(6.938 38.750) "GIOL" "lowerRight" "R90" "stick" 0.0625 nil)
schCreateWire(cv "route" "full" '((6.750 39.000) (6.750 38.250)) 0 0 0 nil nil)
schCreateWireLabel(cv nil '(6.750 38.750) "VIOH" "lowerRight" "R90" "stick" 0.0625 nil)
schCreateWire(cv "route" "full" '((6.375 39.000) (6.375 38.250)) 0 0 0 nil nil)
schCreateWireLabel(cv nil '(6.375 38.750) "GIOH" "lowerRight" "R90" "stick" 0.0625 nil)
dbCreateInst(cv pddw16sdgz_v_gMaster "DOUT4_top16" '(5.6875 40.0) "R180")
schCreateWire(cv "route" "full" '((5.562 39.000) (5.562 38.250)) 0 0 0 nil nil)
schCreateWireLabel(cv nil '(5.562 38.750) "VIOL" "lowerRight" "R90" "stick" 0.0625 nil)
schCreateWire(cv "route" "full" '((5.438 39.000) (5.438 38.250)) 0 0 0 nil nil)
dbCreateInst(cv noConnMaster "noConn_DOUT4_top16_C" '(5.438 38.250) "R0")
schCreateWire(cv "route" "full" '((5.812 39.000) (5.812 38.250)) 0 0 0 nil nil)
schCreateWireLabel(cv nil '(5.812 38.750) "GIOL" "lowerRight" "R90" "stick" 0.0625 nil)
schCreateWire(cv "route" "full" '((5.938 39.000) (5.938 38.250)) 0 0 0 nil nil)
schCreateWireLabel(cv nil '(5.938 38.750) "DOUT4_CORE" "lowerRight" "R90" "stick" 0.0625 nil)
schCreatePin(cv nil "DOUT4_CORE" "inputOutput" nil '(5.938 38.250) "R90")
schCreateWire(cv "route" "full" '((5.000 40.000) (5.000 40.750)) 0 0 0 nil nil)
schCreateWireLabel(cv nil '(5.000 40.250) "DOUT4" "lowerLeft" "R90" "stick" 0.0625 nil)
schCreatePin(cv nil "DOUT4" "inputOutput" nil '(5.000 40.750) "R270")
schCreateWire(cv "route" "full" '((5.312 39.000) (5.312 38.250)) 0 0 0 nil nil)
schCreateWireLabel(cv nil '(5.312 38.750) "POC" "lowerRight" "R90" "stick" 0.0625 nil)
schCreateWire(cv "route" "full" '((5.125 39.000) (5.125 38.250)) 0 0 0 nil nil)
schCreateWireLabel(cv nil '(5.125 38.750) "VIOL" "lowerRight" "R90" "stick" 0.0625 nil)
schCreateWire(cv "route" "full" '((4.938 39.000) (4.938 38.250)) 0 0 0 nil nil)
schCreateWireLabel(cv nil '(4.938 38.750) "GIOL" "lowerRight" "R90" "stick" 0.0625 nil)
schCreateWire(cv "route" "full" '((4.750 39.000) (4.750 38.250)) 0 0 0 nil nil)
schCreateWireLabel(cv nil '(4.750 38.750) "VIOH" "lowerRight" "R90" "stick" 0.0625 nil)
schCreateWire(cv "route" "full" '((4.375 39.000) (4.375 38.250)) 0 0 0 nil nil)
schCreateWireLabel(cv nil '(4.375 38.750) "GIOH" "lowerRight" "R90" "stick" 0.0625 nil)
dbCreateInst(cv pddw16sdgz_v_gMaster "DOUT5_top17" '(3.6875 40.0) "R180")
schCreateWire(cv "route" "full" '((3.562 39.000) (3.562 38.250)) 0 0 0 nil nil)
schCreateWireLabel(cv nil '(3.562 38.750) "VIOL" "lowerRight" "R90" "stick" 0.0625 nil)
schCreateWire(cv "route" "full" '((3.438 39.000) (3.438 38.250)) 0 0 0 nil nil)
dbCreateInst(cv noConnMaster "noConn_DOUT5_top17_C" '(3.438 38.250) "R0")
schCreateWire(cv "route" "full" '((3.812 39.000) (3.812 38.250)) 0 0 0 nil nil)
schCreateWireLabel(cv nil '(3.812 38.750) "GIOL" "lowerRight" "R90" "stick" 0.0625 nil)
schCreateWire(cv "route" "full" '((3.938 39.000) (3.938 38.250)) 0 0 0 nil nil)
schCreateWireLabel(cv nil '(3.938 38.750) "DOUT5_CORE" "lowerRight" "R90" "stick" 0.0625 nil)
schCreatePin(cv nil "DOUT5_CORE" "inputOutput" nil '(3.938 38.250) "R90")
schCreateWire(cv "route" "full" '((3.000 40.000) (3.000 40.750)) 0 0 0 nil nil)
schCreateWireLabel(cv nil '(3.000 40.250) "DOUT5" "lowerLeft" "R90" "stick" 0.0625 nil)
schCreatePin(cv nil "DOUT5" "inputOutput" nil '(3.000 40.750) "R270")
schCreateWire(cv "route" "full" '((3.312 39.000) (3.312 38.250)) 0 0 0 nil nil)
schCreateWireLabel(cv nil '(3.312 38.750) "POC" "lowerRight" "R90" "stick" 0.0625 nil)
schCreateWire(cv "route" "full" '((3.125 39.000) (3.125 38.250)) 0 0 0 nil nil)
schCreateWireLabel(cv nil '(3.125 38.750) "VIOL" "lowerRight" "R90" "stick" 0.0625 nil)
schCreateWire(cv "route" "full" '((2.938 39.000) (2.938 38.250)) 0 0 0 nil nil)
schCreateWireLabel(cv nil '(2.938 38.750) "GIOL" "lowerRight" "R90" "stick" 0.0625 nil)
schCreateWire(cv "route" "full" '((2.750 39.000) (2.750 38.250)) 0 0 0 nil nil)
schCreateWireLabel(cv nil '(2.750 38.750) "VIOH" "lowerRight" "R90" "stick" 0.0625 nil)
schCreateWire(cv "route" "full" '((2.375 39.000) (2.375 38.250)) 0 0 0 nil nil)
schCreateWireLabel(cv nil '(2.375 38.750) "GIOH" "lowerRight" "R90" "stick" 0.0625 nil)
pvss1ac_v_gMaster = dbOpenCellView("tphn28hpcpgv18" "PVSS1AC_V_G" "symbol")
dbCreateInst(cv pvss1ac_v_gMaster "VSS_CORE_bottom1314" '(30.375 4.0) "R0")
schCreateWire(cv "route" "full" '((30.187 4.000) (30.187 3.250)) 0 0 0 nil nil)
schCreateWireLabel(cv nil '(30.187 3.750) "VSS_CORE" "lowerRight" "R90" "stick" 0.0625 nil)
schCreatePin(cv nil "VSS_CORE" "inputOutput" nil '(30.187 3.250) "R90")
schCreateWire(cv "route" "full" '((30.125 4.875) (30.125 5.625)) 0 0 0 nil nil)
schCreateWireLabel(cv nil '(30.125 5.125) "VSSSAR" "lowerLeft" "R90" "stick" 0.0625 nil)
schCreateWire(cv "route" "full" '((30.500 4.875) (30.500 5.625)) 0 0 0 nil nil)
schCreateWireLabel(cv nil '(30.500 5.125) "GIOL" "lowerLeft" "R90" "stick" 0.0625 nil)
schCreateWire(cv "route" "full" '((29.750 4.875) (29.750 5.625)) 0 0 0 nil nil)
schCreateWireLabel(cv nil '(29.750 5.125) "VDDSAR" "lowerLeft" "R90" "stick" 0.0625 nil)
dbCreateInst(cv pddw16sdgz_v_gMaster "D16_top23" '(33.375 36.0) "R180")
schCreateWire(cv "route" "full" '((33.250 35.000) (33.250 34.250)) 0 0 0 nil nil)
schCreateWireLabel(cv nil '(33.250 34.750) "VIOL" "lowerRight" "R90" "stick" 0.0625 nil)
schCreateWire(cv "route" "full" '((33.125 35.000) (33.125 34.250)) 0 0 0 nil nil)
dbCreateInst(cv noConnMaster "noConn_D16_top23_C" '(33.125 34.250) "R0")
schCreateWire(cv "route" "full" '((33.500 35.000) (33.500 34.250)) 0 0 0 nil nil)
schCreateWireLabel(cv nil '(33.500 34.750) "GIOL" "lowerRight" "R90" "stick" 0.0625 nil)
schCreateWire(cv "route" "full" '((33.625 35.000) (33.625 34.250)) 0 0 0 nil nil)
schCreateWireLabel(cv nil '(33.625 34.750) "D16_CORE" "lowerRight" "R90" "stick" 0.0625 nil)
schCreatePin(cv nil "D16_CORE" "inputOutput" nil '(33.625 34.250) "R90")
schCreateWire(cv "route" "full" '((32.687 36.000) (32.687 36.750)) 0 0 0 nil nil)
schCreateWireLabel(cv nil '(32.687 36.250) "D16" "lowerLeft" "R90" "stick" 0.0625 nil)
schCreatePin(cv nil "D16" "inputOutput" nil '(32.687 36.750) "R270")
schCreateWire(cv "route" "full" '((33.000 35.000) (33.000 34.250)) 0 0 0 nil nil)
schCreateWireLabel(cv nil '(33.000 34.750) "POC" "lowerRight" "R90" "stick" 0.0625 nil)
schCreateWire(cv "route" "full" '((32.813 35.000) (32.813 34.250)) 0 0 0 nil nil)
schCreateWireLabel(cv nil '(32.813 34.750) "VIOL" "lowerRight" "R90" "stick" 0.0625 nil)
schCreateWire(cv "route" "full" '((32.625 35.000) (32.625 34.250)) 0 0 0 nil nil)
schCreateWireLabel(cv nil '(32.625 34.750) "GIOL" "lowerRight" "R90" "stick" 0.0625 nil)
schCreateWire(cv "route" "full" '((32.437 35.000) (32.437 34.250)) 0 0 0 nil nil)
schCreateWireLabel(cv nil '(32.437 34.750) "VIOH" "lowerRight" "R90" "stick" 0.0625 nil)
schCreateWire(cv "route" "full" '((32.063 35.000) (32.063 34.250)) 0 0 0 nil nil)
schCreateWireLabel(cv nil '(32.063 34.750) "GIOH" "lowerRight" "R90" "stick" 0.0625 nil)
pvdd1ac_v_gMaster = dbOpenCellView("tphn28hpcpgv18" "PVDD1AC_V_G" "symbol")
dbCreateInst(cv pvdd1ac_v_gMaster "AVDD_CORE_bottom1112" '(26.375 4.0) "R0")
schCreateWire(cv "route" "full" '((26.125 4.875) (26.125 5.625)) 0 0 0 nil nil)
schCreateWireLabel(cv nil '(26.125 5.125) "AVSS" "lowerLeft" "R90" "stick" 0.0625 nil)
schCreateWire(cv "route" "full" '((26.500 4.875) (26.500 5.625)) 0 0 0 nil nil)
schCreateWireLabel(cv nil '(26.500 5.125) "GIOL" "lowerLeft" "R90" "stick" 0.0625 nil)
schCreateWire(cv "route" "full" '((26.187 4.000) (26.187 3.250)) 0 0 0 nil nil)
schCreateWireLabel(cv nil '(26.187 3.750) "AVDD_CORE" "lowerRight" "R90" "stick" 0.0625 nil)
schCreatePin(cv nil "AVDD_CORE" "inputOutput" nil '(26.187 3.250) "R90")
schCreateWire(cv "route" "full" '((25.750 4.875) (25.750 5.625)) 0 0 0 nil nil)
schCreateWireLabel(cv nil '(25.750 5.125) "AVDD" "lowerLeft" "R90" "stick" 0.0625 nil)
dbCreateInst(cv pddw16sdgz_v_gMaster "DCLK_top89" '(21.375 36.0) "R180")
schCreateWire(cv "route" "full" '((21.250 35.000) (21.250 34.250)) 0 0 0 nil nil)
schCreateWireLabel(cv nil '(21.250 34.750) "VIOL" "lowerRight" "R90" "stick" 0.0625 nil)
schCreateWire(cv "route" "full" '((21.125 35.000) (21.125 34.250)) 0 0 0 nil nil)
dbCreateInst(cv noConnMaster "noConn_DCLK_top89_C" '(21.125 34.250) "R0")
schCreateWire(cv "route" "full" '((21.500 35.000) (21.500 34.250)) 0 0 0 nil nil)
schCreateWireLabel(cv nil '(21.500 34.750) "GIOL" "lowerRight" "R90" "stick" 0.0625 nil)
schCreateWire(cv "route" "full" '((21.625 35.000) (21.625 34.250)) 0 0 0 nil nil)
schCreateWireLabel(cv nil '(21.625 34.750) "DCLK_CORE" "lowerRight" "R90" "stick" 0.0625 nil)
schCreatePin(cv nil "DCLK_CORE" "inputOutput" nil '(21.625 34.250) "R90")
schCreateWire(cv "route" "full" '((20.687 36.000) (20.687 36.750)) 0 0 0 nil nil)
schCreateWireLabel(cv nil '(20.687 36.250) "DCLK" "lowerLeft" "R90" "stick" 0.0625 nil)
schCreatePin(cv nil "DCLK" "inputOutput" nil '(20.687 36.750) "R270")
schCreateWire(cv "route" "full" '((21.000 35.000) (21.000 34.250)) 0 0 0 nil nil)
schCreateWireLabel(cv nil '(21.000 34.750) "POC" "lowerRight" "R90" "stick" 0.0625 nil)
schCreateWire(cv "route" "full" '((20.813 35.000) (20.813 34.250)) 0 0 0 nil nil)
schCreateWireLabel(cv nil '(20.813 34.750) "VIOL" "lowerRight" "R90" "stick" 0.0625 nil)
schCreateWire(cv "route" "full" '((20.625 35.000) (20.625 34.250)) 0 0 0 nil nil)
schCreateWireLabel(cv nil '(20.625 34.750) "GIOL" "lowerRight" "R90" "stick" 0.0625 nil)
schCreateWire(cv "route" "full" '((20.437 35.000) (20.437 34.250)) 0 0 0 nil nil)
schCreateWireLabel(cv nil '(20.437 34.750) "VIOH" "lowerRight" "R90" "stick" 0.0625 nil)
schCreateWire(cv "route" "full" '((20.063 35.000) (20.063 34.250)) 0 0 0 nil nil)
schCreateWireLabel(cv nil '(20.063 34.750) "GIOH" "lowerRight" "R90" "stick" 0.0625 nil)
schCheck(cv)
dbSave(cv)
t
