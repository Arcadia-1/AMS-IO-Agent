; Generated Layout Script with Dual Ring Support

; ==================== All Components (Sorted by Placement Order) ====================
dbCreateParamInstByMasterName(cv "tphn28hpcpgv18" "PDB3AC_H_G" "layout" "VINP_left_17" list(0 150) "R270")
dbCreateParamInstByMasterName(cv "PAD" "PAD60GU" "layout" "pad60gu_VINP_left_17" list(0 150) "R270")
dbCreateParamInstByMasterName(cv "tphn28hpcpgv18" "PVSS3AC_H_G" "layout" "VSSIB_left_16" list(0 210) "R270")
dbCreateParamInstByMasterName(cv "PAD" "PAD60GU" "layout" "pad60gu_VSSIB_left_16" list(0 210) "R270")
dbCreateParamInstByMasterName(cv "tphn28hpcpgv18" "PVDD3AC_H_G" "layout" "VDDIB_left_15" list(0 270) "R270")
dbCreateParamInstByMasterName(cv "PAD" "PAD60GU" "layout" "pad60gu_VDDIB_left_15" list(0 270) "R270")
dbCreateParamInstByMasterName(cv "tphn28hpcpgv18" "PDB3AC_H_G" "layout" "IBUF_IBIAS_left_14" list(0 330) "R270")
dbCreateParamInstByMasterName(cv "PAD" "PAD60GU" "layout" "pad60gu_IBUF_IBIAS_left_14" list(0 330) "R270")
dbCreateParamInstByMasterName(cv "tphn28hpcpgv18" "PDB3AC_H_G" "layout" "VSS_left_13" list(0 390) "R270")
dbCreateParamInstByMasterName(cv "PAD" "PAD60GU" "layout" "pad60gu_VSS_left_13" list(0 390) "R270")
dbCreateParamInstByMasterName(cv "tphn28hpcpgv18" "PDB3AC_H_G" "layout" "IBREF_left_12" list(0 450) "R270")
dbCreateParamInstByMasterName(cv "PAD" "PAD60GU" "layout" "pad60gu_IBREF_left_12" list(0 450) "R270")
dbCreateParamInstByMasterName(cv "tphn28hpcpgv18" "PDB3AC_H_G" "layout" "VREFDES_left_11" list(0 510) "R270")
dbCreateParamInstByMasterName(cv "PAD" "PAD60GU" "layout" "pad60gu_VREFDES_left_11" list(0 510) "R270")
dbCreateParamInstByMasterName(cv "tphn28hpcpgv18" "PDB3AC_H_G" "layout" "VDD_CDAC_left_10" list(0 570) "R270")
dbCreateParamInstByMasterName(cv "PAD" "PAD60GU" "layout" "pad60gu_VDD_CDAC_left_10" list(0 570) "R270")
dbCreateParamInstByMasterName(cv "tphn28hpcpgv18" "PDB3AC_H_G" "layout" "IB12_left_9" list(0 630) "R270")
dbCreateParamInstByMasterName(cv "PAD" "PAD60GU" "layout" "pad60gu_IB12_left_9" list(0 630) "R270")
dbCreateParamInstByMasterName(cv "tphn28hpcpgv18" "PDB3AC_H_G" "layout" "VDD12_left_8" list(0 690) "R270")
dbCreateParamInstByMasterName(cv "PAD" "PAD60GU" "layout" "pad60gu_VDD12_left_8" list(0 690) "R270")
dbCreateParamInstByMasterName(cv "tphn28hpcpgv18" "PDB3AC_H_G" "layout" "IB3_left_7" list(0 750) "R270")
dbCreateParamInstByMasterName(cv "PAD" "PAD60GU" "layout" "pad60gu_IB3_left_7" list(0 750) "R270")
dbCreateParamInstByMasterName(cv "tphn28hpcpgv18" "PDB3AC_H_G" "layout" "VDD3_left_6" list(0 810) "R270")
dbCreateParamInstByMasterName(cv "PAD" "PAD60GU" "layout" "pad60gu_VDD3_left_6" list(0 810) "R270")
dbCreateParamInstByMasterName(cv "tphn28hpcpgv18" "PVSS2DGZ_H_G" "layout" "GIOH_left_5" list(0 870) "R270")
dbCreateParamInstByMasterName(cv "PAD" "PAD60GU" "layout" "pad60gu_GIOH_left_5" list(0 870) "R270")
dbCreateParamInstByMasterName(cv "tphn28hpcpgv18" "PVDD2POC_H_G" "layout" "VIOH_left_4" list(0 930) "R270")
dbCreateParamInstByMasterName(cv "PAD" "PAD60GU" "layout" "pad60gu_VIOH_left_4" list(0 930) "R270")
dbCreateParamInstByMasterName(cv "tphn28hpcpgv18" "PVSS1DGZ_H_G" "layout" "GIOL_left_3" list(0 990) "R270")
dbCreateParamInstByMasterName(cv "PAD" "PAD60GU" "layout" "pad60gu_GIOL_left_3" list(0 990) "R270")
dbCreateParamInstByMasterName(cv "tphn28hpcpgv18" "PVDD1DGZ_H_G" "layout" "VIOL_left_2" list(0 1050) "R270")
dbCreateParamInstByMasterName(cv "PAD" "PAD60GU" "layout" "pad60gu_VIOL_left_2" list(0 1050) "R270")
dbCreateParamInstByMasterName(cv "tphn28hpcpgv18" "PDDW16SDGZ_H_G" "layout" "SYNC_left_1" list(0 1110) "R270")
dbCreateParamInstByMasterName(cv "PAD" "PAD60GU" "layout" "pad60gu_SYNC_left_1" list(0 1110) "R270")
dbCreateParamInstByMasterName(cv "tphn28hpcpgv18" "PDDW16SDGZ_H_G" "layout" "DCLK_left_0" list(0 1170) "R270")
dbCreateParamInstByMasterName(cv "PAD" "PAD60GU" "layout" "pad60gu_DCLK_left_0" list(0 1170) "R270")
dbCreateParamInstByMasterName(cv "tphn28hpcpgv18" "PCORNER_G" "layout" "CORNER_TL_top_left" list(0 1300) "R270")
dbCreateParamInstByMasterName(cv "tphn28hpcpgv18" "PDB3AC_V_G" "layout" "VREFDES3_bottom_17" list(1150 0) "R0")
dbCreateParamInstByMasterName(cv "PAD" "PAD60GU" "layout" "pad60gu_VREFDES3_bottom_17" list(1150 0) "R0")
dbCreateParamInstByMasterName(cv "tphn28hpcpgv18" "PDB3AC_V_G" "layout" "IBREF2_bottom_16" list(1090 0) "R0")
dbCreateParamInstByMasterName(cv "PAD" "PAD60GU" "layout" "pad60gu_IBREF2_bottom_16" list(1090 0) "R0")
dbCreateParamInstByMasterName(cv "tphn28hpcpgv18" "PDB3AC_V_G" "layout" "VREFDES2_bottom_15" list(1030 0) "R0")
dbCreateParamInstByMasterName(cv "PAD" "PAD60GU" "layout" "pad60gu_VREFDES2_bottom_15" list(1030 0) "R0")
dbCreateParamInstByMasterName(cv "tphn28hpcpgv18" "PDB3AC_V_G" "layout" "VSSSAR_bottom_14" list(970 0) "R0")
dbCreateParamInstByMasterName(cv "PAD" "PAD60GU" "layout" "pad60gu_VSSSAR_bottom_14" list(970 0) "R0")
dbCreateParamInstByMasterName(cv "tphn28hpcpgv18" "PDB3AC_V_G" "layout" "VDDSAR_bottom_13" list(910 0) "R0")
dbCreateParamInstByMasterName(cv "PAD" "PAD60GU" "layout" "pad60gu_VDDSAR_bottom_13" list(910 0) "R0")
dbCreateParamInstByMasterName(cv "tphn28hpcpgv18" "PDB3AC_V_G" "layout" "AVSS_bottom_12" list(850 0) "R0")
dbCreateParamInstByMasterName(cv "PAD" "PAD60GU" "layout" "pad60gu_AVSS_bottom_12" list(850 0) "R0")
dbCreateParamInstByMasterName(cv "tphn28hpcpgv18" "PDB3AC_V_G" "layout" "AVDD_bottom_11" list(790 0) "R0")
dbCreateParamInstByMasterName(cv "PAD" "PAD60GU" "layout" "pad60gu_AVDD_bottom_11" list(790 0) "R0")
dbCreateParamInstByMasterName(cv "tphn28hpcpgv18" "PDB3AC_V_G" "layout" "VDDCLK_bottom_10" list(730 0) "R0")
dbCreateParamInstByMasterName(cv "PAD" "PAD60GU" "layout" "pad60gu_VDDCLK_bottom_10" list(730 0) "R0")
dbCreateParamInstByMasterName(cv "tphn28hpcpgv18" "PDB3AC_V_G" "layout" "VSSCLK_bottom_9" list(670 0) "R0")
dbCreateParamInstByMasterName(cv "PAD" "PAD60GU" "layout" "pad60gu_VSSCLK_bottom_9" list(670 0) "R0")
dbCreateParamInstByMasterName(cv "tphn28hpcpgv18" "PDB3AC_V_G" "layout" "VCM_bottom_8" list(610 0) "R0")
dbCreateParamInstByMasterName(cv "PAD" "PAD60GU" "layout" "pad60gu_VCM_bottom_8" list(610 0) "R0")
dbCreateParamInstByMasterName(cv "tphn28hpcpgv18" "PVSS3AC_V_G" "layout" "GND_DAT_bottom_7" list(550 0) "R0")
dbCreateParamInstByMasterName(cv "PAD" "PAD60GU" "layout" "pad60gu_GND_DAT_bottom_7" list(550 0) "R0")
dbCreateParamInstByMasterName(cv "tphn28hpcpgv18" "PVDD3AC_V_G" "layout" "VDD_DAT_bottom_6" list(490 0) "R0")
dbCreateParamInstByMasterName(cv "PAD" "PAD60GU" "layout" "pad60gu_VDD_DAT_bottom_6" list(490 0) "R0")
dbCreateParamInstByMasterName(cv "tphn28hpcpgv18" "PDB3AC_V_G" "layout" "CLKN_bottom_5" list(430 0) "R0")
dbCreateParamInstByMasterName(cv "PAD" "PAD60GU" "layout" "pad60gu_CLKN_bottom_5" list(430 0) "R0")
dbCreateParamInstByMasterName(cv "tphn28hpcpgv18" "PDB3AC_V_G" "layout" "CLKP_bottom_4" list(370 0) "R0")
dbCreateParamInstByMasterName(cv "PAD" "PAD60GU" "layout" "pad60gu_CLKP_bottom_4" list(370 0) "R0")
dbCreateParamInstByMasterName(cv "tphn28hpcpgv18" "PVDD3AC_V_G" "layout" "VDD_CKB_bottom_3" list(310 0) "R0")
dbCreateParamInstByMasterName(cv "PAD" "PAD60GU" "layout" "pad60gu_VDD_CKB_bottom_3" list(310 0) "R0")
dbCreateParamInstByMasterName(cv "tphn28hpcpgv18" "PVSS3AC_V_G" "layout" "GND_CKB_bottom_2" list(250 0) "R0")
dbCreateParamInstByMasterName(cv "PAD" "PAD60GU" "layout" "pad60gu_GND_CKB_bottom_2" list(250 0) "R0")
dbCreateParamInstByMasterName(cv "tphn28hpcpgv18" "PDB3AC_V_G" "layout" "VINCM_bottom_1" list(190 0) "R0")
dbCreateParamInstByMasterName(cv "PAD" "PAD60GU" "layout" "pad60gu_VINCM_bottom_1" list(190 0) "R0")
dbCreateParamInstByMasterName(cv "tphn28hpcpgv18" "PDB3AC_V_G" "layout" "VINN_bottom_0" list(130 0) "R0")
dbCreateParamInstByMasterName(cv "PAD" "PAD60GU" "layout" "pad60gu_VINN_bottom_0" list(130 0) "R0")
dbCreateParamInstByMasterName(cv "tphn28hpcpgv18" "PCORNERA_G" "layout" "CORNER_BL_bottom_left" list(0 0) "R0")
dbCreateParamInstByMasterName(cv "tphn28hpcpgv18" "PDDW16SDGZ_H_G" "layout" "D11_right_17" list(1300 1150) "R90")
dbCreateParamInstByMasterName(cv "PAD" "PAD60GU" "layout" "pad60gu_D11_right_17" list(1300 1150) "R90")
dbCreateParamInstByMasterName(cv "tphn28hpcpgv18" "PDDW16SDGZ_H_G" "layout" "D10_right_16" list(1300 1090) "R90")
dbCreateParamInstByMasterName(cv "PAD" "PAD60GU" "layout" "pad60gu_D10_right_16" list(1300 1090) "R90")
dbCreateParamInstByMasterName(cv "tphn28hpcpgv18" "PDDW16SDGZ_H_G" "layout" "D9_right_15" list(1300 1030) "R90")
dbCreateParamInstByMasterName(cv "PAD" "PAD60GU" "layout" "pad60gu_D9_right_15" list(1300 1030) "R90")
dbCreateParamInstByMasterName(cv "tphn28hpcpgv18" "PDDW16SDGZ_H_G" "layout" "D8_right_14" list(1300 970) "R90")
dbCreateParamInstByMasterName(cv "PAD" "PAD60GU" "layout" "pad60gu_D8_right_14" list(1300 970) "R90")
dbCreateParamInstByMasterName(cv "tphn28hpcpgv18" "PDDW16SDGZ_H_G" "layout" "D7_right_13" list(1300 910) "R90")
dbCreateParamInstByMasterName(cv "PAD" "PAD60GU" "layout" "pad60gu_D7_right_13" list(1300 910) "R90")
dbCreateParamInstByMasterName(cv "tphn28hpcpgv18" "PDDW16SDGZ_H_G" "layout" "D6_right_12" list(1300 850) "R90")
dbCreateParamInstByMasterName(cv "PAD" "PAD60GU" "layout" "pad60gu_D6_right_12" list(1300 850) "R90")
dbCreateParamInstByMasterName(cv "tphn28hpcpgv18" "PDDW16SDGZ_H_G" "layout" "D5_right_11" list(1300 790) "R90")
dbCreateParamInstByMasterName(cv "PAD" "PAD60GU" "layout" "pad60gu_D5_right_11" list(1300 790) "R90")
dbCreateParamInstByMasterName(cv "tphn28hpcpgv18" "PDDW16SDGZ_H_G" "layout" "D4_right_10" list(1300 730) "R90")
dbCreateParamInstByMasterName(cv "PAD" "PAD60GU" "layout" "pad60gu_D4_right_10" list(1300 730) "R90")
dbCreateParamInstByMasterName(cv "tphn28hpcpgv18" "PDDW16SDGZ_H_G" "layout" "D3_right_9" list(1300 670) "R90")
dbCreateParamInstByMasterName(cv "PAD" "PAD60GU" "layout" "pad60gu_D3_right_9" list(1300 670) "R90")
dbCreateParamInstByMasterName(cv "tphn28hpcpgv18" "PDDW16SDGZ_H_G" "layout" "D2_right_8" list(1300 610) "R90")
dbCreateParamInstByMasterName(cv "PAD" "PAD60GU" "layout" "pad60gu_D2_right_8" list(1300 610) "R90")
dbCreateParamInstByMasterName(cv "tphn28hpcpgv18" "PDDW16SDGZ_H_G" "layout" "D1_right_7" list(1300 550) "R90")
dbCreateParamInstByMasterName(cv "PAD" "PAD60GU" "layout" "pad60gu_D1_right_7" list(1300 550) "R90")
dbCreateParamInstByMasterName(cv "tphn28hpcpgv18" "PDDW16SDGZ_H_G" "layout" "D0_right_6" list(1300 490) "R90")
dbCreateParamInstByMasterName(cv "PAD" "PAD60GU" "layout" "pad60gu_D0_right_6" list(1300 490) "R90")
dbCreateParamInstByMasterName(cv "tphn28hpcpgv18" "PDDW16SDGZ_H_G" "layout" "RST_right_5" list(1300 430) "R90")
dbCreateParamInstByMasterName(cv "PAD" "PAD60GU" "layout" "pad60gu_RST_right_5" list(1300 430) "R90")
dbCreateParamInstByMasterName(cv "tphn28hpcpgv18" "PDDW16SDGZ_H_G" "layout" "SDO_right_4" list(1300 370) "R90")
dbCreateParamInstByMasterName(cv "PAD" "PAD60GU" "layout" "pad60gu_SDO_right_4" list(1300 370) "R90")
dbCreateParamInstByMasterName(cv "tphn28hpcpgv18" "PDDW16SDGZ_H_G" "layout" "SCK_right_3" list(1300 310) "R90")
dbCreateParamInstByMasterName(cv "PAD" "PAD60GU" "layout" "pad60gu_SCK_right_3" list(1300 310) "R90")
dbCreateParamInstByMasterName(cv "tphn28hpcpgv18" "PDDW16SDGZ_H_G" "layout" "SDI_right_2" list(1300 250) "R90")
dbCreateParamInstByMasterName(cv "PAD" "PAD60GU" "layout" "pad60gu_SDI_right_2" list(1300 250) "R90")
dbCreateParamInstByMasterName(cv "tphn28hpcpgv18" "PDDW16SDGZ_H_G" "layout" "SLP_right_1" list(1300 190) "R90")
dbCreateParamInstByMasterName(cv "PAD" "PAD60GU" "layout" "pad60gu_SLP_right_1" list(1300 190) "R90")
dbCreateParamInstByMasterName(cv "tphn28hpcpgv18" "PDB3AC_H_G" "layout" "IBREF3_right_0" list(1300 130) "R90")
dbCreateParamInstByMasterName(cv "PAD" "PAD60GU" "layout" "pad60gu_IBREF3_right_0" list(1300 130) "R90")
dbCreateParamInstByMasterName(cv "tphn28hpcpgv18" "PCORNERA_G" "layout" "CORNER_BR_bottom_right" list(1300 0) "R90")
dbCreateParamInstByMasterName(cv "tphn28hpcpgv18" "PDDW16SDGZ_V_G" "layout" "DOUT5_top_17" list(150 1300) "R180")
dbCreateParamInstByMasterName(cv "PAD" "PAD60GU" "layout" "pad60gu_DOUT5_top_17" list(150 1300) "R180")
dbCreateParamInstByMasterName(cv "tphn28hpcpgv18" "PDDW16SDGZ_V_G" "layout" "DOUT4_top_16" list(210 1300) "R180")
dbCreateParamInstByMasterName(cv "PAD" "PAD60GU" "layout" "pad60gu_DOUT4_top_16" list(210 1300) "R180")
dbCreateParamInstByMasterName(cv "tphn28hpcpgv18" "PDDW16SDGZ_V_G" "layout" "DOUT3_top_15" list(270 1300) "R180")
dbCreateParamInstByMasterName(cv "PAD" "PAD60GU" "layout" "pad60gu_DOUT3_top_15" list(270 1300) "R180")
dbCreateParamInstByMasterName(cv "tphn28hpcpgv18" "PDDW16SDGZ_V_G" "layout" "DOUT2_top_14" list(330 1300) "R180")
dbCreateParamInstByMasterName(cv "PAD" "PAD60GU" "layout" "pad60gu_DOUT2_top_14" list(330 1300) "R180")
dbCreateParamInstByMasterName(cv "tphn28hpcpgv18" "PDDW16SDGZ_V_G" "layout" "DOUT1_top_13" list(390 1300) "R180")
dbCreateParamInstByMasterName(cv "PAD" "PAD60GU" "layout" "pad60gu_DOUT1_top_13" list(390 1300) "R180")
dbCreateParamInstByMasterName(cv "tphn28hpcpgv18" "PDDW16SDGZ_V_G" "layout" "DOUT_top_12" list(450 1300) "R180")
dbCreateParamInstByMasterName(cv "PAD" "PAD60GU" "layout" "pad60gu_DOUT_top_12" list(450 1300) "R180")
dbCreateParamInstByMasterName(cv "tphn28hpcpgv18" "PDDW16SDGZ_V_G" "layout" "DIN_top_11" list(510 1300) "R180")
dbCreateParamInstByMasterName(cv "PAD" "PAD60GU" "layout" "pad60gu_DIN_top_11" list(510 1300) "R180")
dbCreateParamInstByMasterName(cv "tphn28hpcpgv18" "PDDW16SDGZ_V_G" "layout" "LRCK_top_10" list(570 1300) "R180")
dbCreateParamInstByMasterName(cv "PAD" "PAD60GU" "layout" "pad60gu_LRCK_top_10" list(570 1300) "R180")
dbCreateParamInstByMasterName(cv "tphn28hpcpgv18" "PDDW16SDGZ_V_G" "layout" "SCLK_top_9" list(630 1300) "R180")
dbCreateParamInstByMasterName(cv "PAD" "PAD60GU" "layout" "pad60gu_SCLK_top_9" list(630 1300) "R180")
dbCreateParamInstByMasterName(cv "tphn28hpcpgv18" "PDDW16SDGZ_V_G" "layout" "MCLK_top_8" list(690 1300) "R180")
dbCreateParamInstByMasterName(cv "PAD" "PAD60GU" "layout" "pad60gu_MCLK_top_8" list(690 1300) "R180")
dbCreateParamInstByMasterName(cv "tphn28hpcpgv18" "PDDW16SDGZ_V_G" "layout" "RSTN_top_7" list(750 1300) "R180")
dbCreateParamInstByMasterName(cv "PAD" "PAD60GU" "layout" "pad60gu_RSTN_top_7" list(750 1300) "R180")
dbCreateParamInstByMasterName(cv "tphn28hpcpgv18" "PDDW16SDGZ_V_G" "layout" "TEST_top_6" list(810 1300) "R180")
dbCreateParamInstByMasterName(cv "PAD" "PAD60GU" "layout" "pad60gu_TEST_top_6" list(810 1300) "R180")
dbCreateParamInstByMasterName(cv "tphn28hpcpgv18" "PDDW16SDGZ_V_G" "layout" "EN_top_5" list(870 1300) "R180")
dbCreateParamInstByMasterName(cv "PAD" "PAD60GU" "layout" "pad60gu_EN_top_5" list(870 1300) "R180")
dbCreateParamInstByMasterName(cv "tphn28hpcpgv18" "PDDW16SDGZ_V_G" "layout" "CS_top_4" list(930 1300) "R180")
dbCreateParamInstByMasterName(cv "PAD" "PAD60GU" "layout" "pad60gu_CS_top_4" list(930 1300) "R180")
dbCreateParamInstByMasterName(cv "tphn28hpcpgv18" "PDDW16SDGZ_V_G" "layout" "D15_top_3" list(990 1300) "R180")
dbCreateParamInstByMasterName(cv "PAD" "PAD60GU" "layout" "pad60gu_D15_top_3" list(990 1300) "R180")
dbCreateParamInstByMasterName(cv "tphn28hpcpgv18" "PDDW16SDGZ_V_G" "layout" "D14_top_2" list(1050 1300) "R180")
dbCreateParamInstByMasterName(cv "PAD" "PAD60GU" "layout" "pad60gu_D14_top_2" list(1050 1300) "R180")
dbCreateParamInstByMasterName(cv "tphn28hpcpgv18" "PDDW16SDGZ_V_G" "layout" "D13_top_1" list(1110 1300) "R180")
dbCreateParamInstByMasterName(cv "PAD" "PAD60GU" "layout" "pad60gu_D13_top_1" list(1110 1300) "R180")
dbCreateParamInstByMasterName(cv "tphn28hpcpgv18" "PDDW16SDGZ_V_G" "layout" "D12_top_0" list(1170 1300) "R180")
dbCreateParamInstByMasterName(cv "PAD" "PAD60GU" "layout" "pad60gu_D12_top_0" list(1170 1300) "R180")
dbCreateParamInstByMasterName(cv "tphn28hpcpgv18" "PCORNER_G" "layout" "CORNER_TR_top_right" list(1300 1300) "R180")

; ==================== Inner Ring Pads ====================
dbCreateParamInstByMasterName(cv "tphn28hpcpgv18" "PVSS1AC_V_G" "layout" "inner_pad_VSS_CORE_bottom_13_14" list(940 0) "R0")
dbCreateParamInstByMasterName(cv "PAD" "PAD60NU" "layout" "inner_pad60nu_VSS_CORE_bottom_13_14" list(940 0) "R0")
dbCreateParamInstByMasterName(cv "tphn28hpcpgv18" "PDDW16SDGZ_V_G" "layout" "inner_pad_D16_top_2_3" list(1020 1300) "R180")
dbCreateParamInstByMasterName(cv "PAD" "PAD60NU" "layout" "inner_pad60nu_D16_top_2_3" list(1020 1300) "R180")
dbCreateParamInstByMasterName(cv "tphn28hpcpgv18" "PVDD1AC_V_G" "layout" "inner_pad_AVDD_CORE_bottom_11_12" list(820 0) "R0")
dbCreateParamInstByMasterName(cv "PAD" "PAD60NU" "layout" "inner_pad60nu_AVDD_CORE_bottom_11_12" list(820 0) "R0")
dbCreateParamInstByMasterName(cv "tphn28hpcpgv18" "PDDW16SDGZ_V_G" "layout" "inner_pad_DCLK_top_8_9" list(660 1300) "R180")
dbCreateParamInstByMasterName(cv "PAD" "PAD60NU" "layout" "inner_pad60nu_DCLK_top_8_9" list(660 1300) "R180")

; ==================== Filler Components ====================
dbCreateParamInstByMasterName(cv "tphn28hpcpgv18" "PFILLER20A_G" "layout" "sep_bottom_right_corner" list(1170 0) "R0")
dbCreateParamInstByMasterName(cv "tphn28hpcpgv18" "PFILLER20A_G" "layout" "filler_bottom_left_corner" list(110 0) "R0")
dbCreateParamInstByMasterName(cv "tphn28hpcpgv18" "PFILLER20A_G" "layout" "filler_R0_1_1" list(1130 0) "R0")
dbCreateParamInstByMasterName(cv "tphn28hpcpgv18" "PFILLER20A_G" "layout" "filler_R0_1_2" list(1110 0) "R0")
dbCreateParamInstByMasterName(cv "tphn28hpcpgv18" "PFILLER20A_G" "layout" "filler_R0_2_1" list(1070 0) "R0")
dbCreateParamInstByMasterName(cv "tphn28hpcpgv18" "PFILLER20A_G" "layout" "filler_R0_2_2" list(1050 0) "R0")
dbCreateParamInstByMasterName(cv "tphn28hpcpgv18" "PFILLER20A_G" "layout" "filler_R0_3_1" list(1010 0) "R0")
dbCreateParamInstByMasterName(cv "tphn28hpcpgv18" "PFILLER20A_G" "layout" "filler_R0_3_2" list(990 0) "R0")
dbCreateParamInstByMasterName(cv "tphn28hpcpgv18" "PFILLER10A_G" "layout" "filler_R0_4_1" list(960 0) "R0")
dbCreateParamInstByMasterName(cv "tphn28hpcpgv18" "PFILLER10A_G" "layout" "filler_R0_4_2" list(930 0) "R0")
dbCreateParamInstByMasterName(cv "tphn28hpcpgv18" "PFILLER20A_G" "layout" "filler_R0_5_1" list(890 0) "R0")
dbCreateParamInstByMasterName(cv "tphn28hpcpgv18" "PFILLER20A_G" "layout" "filler_R0_5_2" list(870 0) "R0")
dbCreateParamInstByMasterName(cv "tphn28hpcpgv18" "PFILLER10A_G" "layout" "filler_R0_6_1" list(840 0) "R0")
dbCreateParamInstByMasterName(cv "tphn28hpcpgv18" "PFILLER10A_G" "layout" "filler_R0_6_2" list(810 0) "R0")
dbCreateParamInstByMasterName(cv "tphn28hpcpgv18" "PFILLER20A_G" "layout" "filler_R0_7_1" list(770 0) "R0")
dbCreateParamInstByMasterName(cv "tphn28hpcpgv18" "PFILLER20A_G" "layout" "filler_R0_7_2" list(750 0) "R0")
dbCreateParamInstByMasterName(cv "tphn28hpcpgv18" "PFILLER20A_G" "layout" "filler_R0_8_1" list(710 0) "R0")
dbCreateParamInstByMasterName(cv "tphn28hpcpgv18" "PFILLER20A_G" "layout" "filler_R0_8_2" list(690 0) "R0")
dbCreateParamInstByMasterName(cv "tphn28hpcpgv18" "PFILLER20A_G" "layout" "filler_R0_9_1" list(650 0) "R0")
dbCreateParamInstByMasterName(cv "tphn28hpcpgv18" "PFILLER20A_G" "layout" "filler_R0_9_2" list(630 0) "R0")
dbCreateParamInstByMasterName(cv "tphn28hpcpgv18" "PFILLER20A_G" "layout" "filler_R0_10_1" list(590 0) "R0")
dbCreateParamInstByMasterName(cv "tphn28hpcpgv18" "PFILLER20A_G" "layout" "filler_R0_10_2" list(570 0) "R0")
dbCreateParamInstByMasterName(cv "tphn28hpcpgv18" "PFILLER20A_G" "layout" "filler_R0_11_1" list(530 0) "R0")
dbCreateParamInstByMasterName(cv "tphn28hpcpgv18" "PFILLER20A_G" "layout" "filler_R0_11_2" list(510 0) "R0")
dbCreateParamInstByMasterName(cv "tphn28hpcpgv18" "PRCUTA_G" "layout" "filler_R0_12_1" list(470 0) "R0")
dbCreateParamInstByMasterName(cv "tphn28hpcpgv18" "PRCUTA_G" "layout" "filler_R0_12_2" list(450 0) "R0")
dbCreateParamInstByMasterName(cv "tphn28hpcpgv18" "PFILLER20A_G" "layout" "filler_R0_13_1" list(410 0) "R0")
dbCreateParamInstByMasterName(cv "tphn28hpcpgv18" "PFILLER20A_G" "layout" "filler_R0_13_2" list(390 0) "R0")
dbCreateParamInstByMasterName(cv "tphn28hpcpgv18" "PFILLER20A_G" "layout" "filler_R0_14_1" list(350 0) "R0")
dbCreateParamInstByMasterName(cv "tphn28hpcpgv18" "PFILLER20A_G" "layout" "filler_R0_14_2" list(330 0) "R0")
dbCreateParamInstByMasterName(cv "tphn28hpcpgv18" "PFILLER20A_G" "layout" "filler_R0_15_1" list(290 0) "R0")
dbCreateParamInstByMasterName(cv "tphn28hpcpgv18" "PFILLER20A_G" "layout" "filler_R0_15_2" list(270 0) "R0")
dbCreateParamInstByMasterName(cv "tphn28hpcpgv18" "PRCUTA_G" "layout" "filler_R0_16_1" list(230 0) "R0")
dbCreateParamInstByMasterName(cv "tphn28hpcpgv18" "PRCUTA_G" "layout" "filler_R0_16_2" list(210 0) "R0")
dbCreateParamInstByMasterName(cv "tphn28hpcpgv18" "PFILLER20A_G" "layout" "filler_R0_17_1" list(170 0) "R0")
dbCreateParamInstByMasterName(cv "tphn28hpcpgv18" "PFILLER20A_G" "layout" "filler_R0_17_2" list(150 0) "R0")
dbCreateParamInstByMasterName(cv "tphn28hpcpgv18" "PFILLER20_G" "layout" "filler_right_top_corner" list(1300 1170) "R90")
dbCreateParamInstByMasterName(cv "tphn28hpcpgv18" "PFILLER20A_G" "layout" "filler_right_bottom_corner" list(1300 110) "R90")
dbCreateParamInstByMasterName(cv "tphn28hpcpgv18" "PFILLER20_G" "layout" "filler_R90_1_1" list(1300 1130) "R90")
dbCreateParamInstByMasterName(cv "tphn28hpcpgv18" "PFILLER20_G" "layout" "filler_R90_1_2" list(1300 1110) "R90")
dbCreateParamInstByMasterName(cv "tphn28hpcpgv18" "PFILLER20_G" "layout" "filler_R90_2_1" list(1300 1070) "R90")
dbCreateParamInstByMasterName(cv "tphn28hpcpgv18" "PFILLER20_G" "layout" "filler_R90_2_2" list(1300 1050) "R90")
dbCreateParamInstByMasterName(cv "tphn28hpcpgv18" "PFILLER20_G" "layout" "filler_R90_3_1" list(1300 1010) "R90")
dbCreateParamInstByMasterName(cv "tphn28hpcpgv18" "PFILLER20_G" "layout" "filler_R90_3_2" list(1300 990) "R90")
dbCreateParamInstByMasterName(cv "tphn28hpcpgv18" "PFILLER20_G" "layout" "filler_R90_4_1" list(1300 950) "R90")
dbCreateParamInstByMasterName(cv "tphn28hpcpgv18" "PFILLER20_G" "layout" "filler_R90_4_2" list(1300 930) "R90")
dbCreateParamInstByMasterName(cv "tphn28hpcpgv18" "PFILLER20_G" "layout" "filler_R90_5_1" list(1300 890) "R90")
dbCreateParamInstByMasterName(cv "tphn28hpcpgv18" "PFILLER20_G" "layout" "filler_R90_5_2" list(1300 870) "R90")
dbCreateParamInstByMasterName(cv "tphn28hpcpgv18" "PFILLER20_G" "layout" "filler_R90_6_1" list(1300 830) "R90")
dbCreateParamInstByMasterName(cv "tphn28hpcpgv18" "PFILLER20_G" "layout" "filler_R90_6_2" list(1300 810) "R90")
dbCreateParamInstByMasterName(cv "tphn28hpcpgv18" "PFILLER20_G" "layout" "filler_R90_7_1" list(1300 770) "R90")
dbCreateParamInstByMasterName(cv "tphn28hpcpgv18" "PFILLER20_G" "layout" "filler_R90_7_2" list(1300 750) "R90")
dbCreateParamInstByMasterName(cv "tphn28hpcpgv18" "PFILLER20_G" "layout" "filler_R90_8_1" list(1300 710) "R90")
dbCreateParamInstByMasterName(cv "tphn28hpcpgv18" "PFILLER20_G" "layout" "filler_R90_8_2" list(1300 690) "R90")
dbCreateParamInstByMasterName(cv "tphn28hpcpgv18" "PFILLER20_G" "layout" "filler_R90_9_1" list(1300 650) "R90")
dbCreateParamInstByMasterName(cv "tphn28hpcpgv18" "PFILLER20_G" "layout" "filler_R90_9_2" list(1300 630) "R90")
dbCreateParamInstByMasterName(cv "tphn28hpcpgv18" "PFILLER20_G" "layout" "filler_R90_10_1" list(1300 590) "R90")
dbCreateParamInstByMasterName(cv "tphn28hpcpgv18" "PFILLER20_G" "layout" "filler_R90_10_2" list(1300 570) "R90")
dbCreateParamInstByMasterName(cv "tphn28hpcpgv18" "PFILLER20_G" "layout" "filler_R90_11_1" list(1300 530) "R90")
dbCreateParamInstByMasterName(cv "tphn28hpcpgv18" "PFILLER20_G" "layout" "filler_R90_11_2" list(1300 510) "R90")
dbCreateParamInstByMasterName(cv "tphn28hpcpgv18" "PFILLER20_G" "layout" "filler_R90_12_1" list(1300 470) "R90")
dbCreateParamInstByMasterName(cv "tphn28hpcpgv18" "PFILLER20_G" "layout" "filler_R90_12_2" list(1300 450) "R90")
dbCreateParamInstByMasterName(cv "tphn28hpcpgv18" "PFILLER20_G" "layout" "filler_R90_13_1" list(1300 410) "R90")
dbCreateParamInstByMasterName(cv "tphn28hpcpgv18" "PFILLER20_G" "layout" "filler_R90_13_2" list(1300 390) "R90")
dbCreateParamInstByMasterName(cv "tphn28hpcpgv18" "PFILLER20_G" "layout" "filler_R90_14_1" list(1300 350) "R90")
dbCreateParamInstByMasterName(cv "tphn28hpcpgv18" "PFILLER20_G" "layout" "filler_R90_14_2" list(1300 330) "R90")
dbCreateParamInstByMasterName(cv "tphn28hpcpgv18" "PFILLER20_G" "layout" "filler_R90_15_1" list(1300 290) "R90")
dbCreateParamInstByMasterName(cv "tphn28hpcpgv18" "PFILLER20_G" "layout" "filler_R90_15_2" list(1300 270) "R90")
dbCreateParamInstByMasterName(cv "tphn28hpcpgv18" "PFILLER20_G" "layout" "filler_R90_16_1" list(1300 230) "R90")
dbCreateParamInstByMasterName(cv "tphn28hpcpgv18" "PFILLER20_G" "layout" "filler_R90_16_2" list(1300 210) "R90")
dbCreateParamInstByMasterName(cv "tphn28hpcpgv18" "PRCUTA_G" "layout" "filler_R90_17_1" list(1300 170) "R90")
dbCreateParamInstByMasterName(cv "tphn28hpcpgv18" "PRCUTA_G" "layout" "filler_R90_17_2" list(1300 150) "R90")
dbCreateParamInstByMasterName(cv "tphn28hpcpgv18" "PFILLER20_G" "layout" "sep_top_left_corner" list(130 1300) "R180")
dbCreateParamInstByMasterName(cv "tphn28hpcpgv18" "PFILLER20_G" "layout" "filler_top_right_corner" list(1190 1300) "R180")
dbCreateParamInstByMasterName(cv "tphn28hpcpgv18" "PFILLER20_G" "layout" "filler_R180_1_1" list(170 1300) "R180")
dbCreateParamInstByMasterName(cv "tphn28hpcpgv18" "PFILLER20_G" "layout" "filler_R180_1_2" list(190 1300) "R180")
dbCreateParamInstByMasterName(cv "tphn28hpcpgv18" "PFILLER20_G" "layout" "filler_R180_2_1" list(230 1300) "R180")
dbCreateParamInstByMasterName(cv "tphn28hpcpgv18" "PFILLER20_G" "layout" "filler_R180_2_2" list(250 1300) "R180")
dbCreateParamInstByMasterName(cv "tphn28hpcpgv18" "PFILLER20_G" "layout" "filler_R180_3_1" list(290 1300) "R180")
dbCreateParamInstByMasterName(cv "tphn28hpcpgv18" "PFILLER20_G" "layout" "filler_R180_3_2" list(310 1300) "R180")
dbCreateParamInstByMasterName(cv "tphn28hpcpgv18" "PFILLER20_G" "layout" "filler_R180_4_1" list(350 1300) "R180")
dbCreateParamInstByMasterName(cv "tphn28hpcpgv18" "PFILLER20_G" "layout" "filler_R180_4_2" list(370 1300) "R180")
dbCreateParamInstByMasterName(cv "tphn28hpcpgv18" "PFILLER20_G" "layout" "filler_R180_5_1" list(410 1300) "R180")
dbCreateParamInstByMasterName(cv "tphn28hpcpgv18" "PFILLER20_G" "layout" "filler_R180_5_2" list(430 1300) "R180")
dbCreateParamInstByMasterName(cv "tphn28hpcpgv18" "PFILLER20_G" "layout" "filler_R180_6_1" list(470 1300) "R180")
dbCreateParamInstByMasterName(cv "tphn28hpcpgv18" "PFILLER20_G" "layout" "filler_R180_6_2" list(490 1300) "R180")
dbCreateParamInstByMasterName(cv "tphn28hpcpgv18" "PFILLER20_G" "layout" "filler_R180_7_1" list(530 1300) "R180")
dbCreateParamInstByMasterName(cv "tphn28hpcpgv18" "PFILLER20_G" "layout" "filler_R180_7_2" list(550 1300) "R180")
dbCreateParamInstByMasterName(cv "tphn28hpcpgv18" "PFILLER20_G" "layout" "filler_R180_8_1" list(590 1300) "R180")
dbCreateParamInstByMasterName(cv "tphn28hpcpgv18" "PFILLER20_G" "layout" "filler_R180_8_2" list(610 1300) "R180")
dbCreateParamInstByMasterName(cv "tphn28hpcpgv18" "PFILLER10_G" "layout" "filler_R180_9_1" list(640 1300) "R180")
dbCreateParamInstByMasterName(cv "tphn28hpcpgv18" "PFILLER10_G" "layout" "filler_R180_9_2" list(670 1300) "R180")
dbCreateParamInstByMasterName(cv "tphn28hpcpgv18" "PFILLER20_G" "layout" "filler_R180_10_1" list(710 1300) "R180")
dbCreateParamInstByMasterName(cv "tphn28hpcpgv18" "PFILLER20_G" "layout" "filler_R180_10_2" list(730 1300) "R180")
dbCreateParamInstByMasterName(cv "tphn28hpcpgv18" "PFILLER20_G" "layout" "filler_R180_11_1" list(770 1300) "R180")
dbCreateParamInstByMasterName(cv "tphn28hpcpgv18" "PFILLER20_G" "layout" "filler_R180_11_2" list(790 1300) "R180")
dbCreateParamInstByMasterName(cv "tphn28hpcpgv18" "PFILLER20_G" "layout" "filler_R180_12_1" list(830 1300) "R180")
dbCreateParamInstByMasterName(cv "tphn28hpcpgv18" "PFILLER20_G" "layout" "filler_R180_12_2" list(850 1300) "R180")
dbCreateParamInstByMasterName(cv "tphn28hpcpgv18" "PFILLER20_G" "layout" "filler_R180_13_1" list(890 1300) "R180")
dbCreateParamInstByMasterName(cv "tphn28hpcpgv18" "PFILLER20_G" "layout" "filler_R180_13_2" list(910 1300) "R180")
dbCreateParamInstByMasterName(cv "tphn28hpcpgv18" "PFILLER20_G" "layout" "filler_R180_14_1" list(950 1300) "R180")
dbCreateParamInstByMasterName(cv "tphn28hpcpgv18" "PFILLER20_G" "layout" "filler_R180_14_2" list(970 1300) "R180")
dbCreateParamInstByMasterName(cv "tphn28hpcpgv18" "PFILLER10_G" "layout" "filler_R180_15_1" list(1000 1300) "R180")
dbCreateParamInstByMasterName(cv "tphn28hpcpgv18" "PFILLER10_G" "layout" "filler_R180_15_2" list(1030 1300) "R180")
dbCreateParamInstByMasterName(cv "tphn28hpcpgv18" "PFILLER20_G" "layout" "filler_R180_16_1" list(1070 1300) "R180")
dbCreateParamInstByMasterName(cv "tphn28hpcpgv18" "PFILLER20_G" "layout" "filler_R180_16_2" list(1090 1300) "R180")
dbCreateParamInstByMasterName(cv "tphn28hpcpgv18" "PFILLER20_G" "layout" "filler_R180_17_1" list(1130 1300) "R180")
dbCreateParamInstByMasterName(cv "tphn28hpcpgv18" "PFILLER20_G" "layout" "filler_R180_17_2" list(1150 1300) "R180")
dbCreateParamInstByMasterName(cv "tphn28hpcpgv18" "PFILLER20A_G" "layout" "filler_left_bottom_corner" list(0 130) "R270")
dbCreateParamInstByMasterName(cv "tphn28hpcpgv18" "PFILLER20_G" "layout" "sep_left_top_corner" list(0 1190) "R270")
dbCreateParamInstByMasterName(cv "tphn28hpcpgv18" "PFILLER20A_G" "layout" "filler_R270_1_1" list(0 170) "R270")
dbCreateParamInstByMasterName(cv "tphn28hpcpgv18" "PFILLER20A_G" "layout" "filler_R270_1_2" list(0 190) "R270")
dbCreateParamInstByMasterName(cv "tphn28hpcpgv18" "PFILLER20A_G" "layout" "filler_R270_2_1" list(0 230) "R270")
dbCreateParamInstByMasterName(cv "tphn28hpcpgv18" "PFILLER20A_G" "layout" "filler_R270_2_2" list(0 250) "R270")
dbCreateParamInstByMasterName(cv "tphn28hpcpgv18" "PFILLER20A_G" "layout" "filler_R270_3_1" list(0 290) "R270")
dbCreateParamInstByMasterName(cv "tphn28hpcpgv18" "PFILLER20A_G" "layout" "filler_R270_3_2" list(0 310) "R270")
dbCreateParamInstByMasterName(cv "tphn28hpcpgv18" "PFILLER20A_G" "layout" "filler_R270_4_1" list(0 350) "R270")
dbCreateParamInstByMasterName(cv "tphn28hpcpgv18" "PFILLER20A_G" "layout" "filler_R270_4_2" list(0 370) "R270")
dbCreateParamInstByMasterName(cv "tphn28hpcpgv18" "PFILLER20A_G" "layout" "filler_R270_5_1" list(0 410) "R270")
dbCreateParamInstByMasterName(cv "tphn28hpcpgv18" "PFILLER20A_G" "layout" "filler_R270_5_2" list(0 430) "R270")
dbCreateParamInstByMasterName(cv "tphn28hpcpgv18" "PFILLER20A_G" "layout" "filler_R270_6_1" list(0 470) "R270")
dbCreateParamInstByMasterName(cv "tphn28hpcpgv18" "PFILLER20A_G" "layout" "filler_R270_6_2" list(0 490) "R270")
dbCreateParamInstByMasterName(cv "tphn28hpcpgv18" "PFILLER20A_G" "layout" "filler_R270_7_1" list(0 530) "R270")
dbCreateParamInstByMasterName(cv "tphn28hpcpgv18" "PFILLER20A_G" "layout" "filler_R270_7_2" list(0 550) "R270")
dbCreateParamInstByMasterName(cv "tphn28hpcpgv18" "PFILLER20A_G" "layout" "filler_R270_8_1" list(0 590) "R270")
dbCreateParamInstByMasterName(cv "tphn28hpcpgv18" "PFILLER20A_G" "layout" "filler_R270_8_2" list(0 610) "R270")
dbCreateParamInstByMasterName(cv "tphn28hpcpgv18" "PFILLER20A_G" "layout" "filler_R270_9_1" list(0 650) "R270")
dbCreateParamInstByMasterName(cv "tphn28hpcpgv18" "PFILLER20A_G" "layout" "filler_R270_9_2" list(0 670) "R270")
dbCreateParamInstByMasterName(cv "tphn28hpcpgv18" "PFILLER20A_G" "layout" "filler_R270_10_1" list(0 710) "R270")
dbCreateParamInstByMasterName(cv "tphn28hpcpgv18" "PFILLER20A_G" "layout" "filler_R270_10_2" list(0 730) "R270")
dbCreateParamInstByMasterName(cv "tphn28hpcpgv18" "PFILLER20A_G" "layout" "filler_R270_11_1" list(0 770) "R270")
dbCreateParamInstByMasterName(cv "tphn28hpcpgv18" "PFILLER20A_G" "layout" "filler_R270_11_2" list(0 790) "R270")
dbCreateParamInstByMasterName(cv "tphn28hpcpgv18" "PRCUTA_G" "layout" "filler_R270_12_1" list(0 830) "R270")
dbCreateParamInstByMasterName(cv "tphn28hpcpgv18" "PRCUTA_G" "layout" "filler_R270_12_2" list(0 850) "R270")
dbCreateParamInstByMasterName(cv "tphn28hpcpgv18" "PFILLER20_G" "layout" "filler_R270_13_1" list(0 890) "R270")
dbCreateParamInstByMasterName(cv "tphn28hpcpgv18" "PFILLER20_G" "layout" "filler_R270_13_2" list(0 910) "R270")
dbCreateParamInstByMasterName(cv "tphn28hpcpgv18" "PFILLER20_G" "layout" "filler_R270_14_1" list(0 950) "R270")
dbCreateParamInstByMasterName(cv "tphn28hpcpgv18" "PFILLER20_G" "layout" "filler_R270_14_2" list(0 970) "R270")
dbCreateParamInstByMasterName(cv "tphn28hpcpgv18" "PFILLER20_G" "layout" "filler_R270_15_1" list(0 1010) "R270")
dbCreateParamInstByMasterName(cv "tphn28hpcpgv18" "PFILLER20_G" "layout" "filler_R270_15_2" list(0 1030) "R270")
dbCreateParamInstByMasterName(cv "tphn28hpcpgv18" "PFILLER20_G" "layout" "filler_R270_16_1" list(0 1070) "R270")
dbCreateParamInstByMasterName(cv "tphn28hpcpgv18" "PFILLER20_G" "layout" "filler_R270_16_2" list(0 1090) "R270")
dbCreateParamInstByMasterName(cv "tphn28hpcpgv18" "PFILLER20_G" "layout" "filler_R270_17_1" list(0 1130) "R270")
dbCreateParamInstByMasterName(cv "tphn28hpcpgv18" "PFILLER20_G" "layout" "filler_R270_17_2" list(0 1150) "R270")

; ==================== Digital IO Features (with Inner Pad Support) ====================
dbCreatePath(cv list("M3" "drawing") list(list(1189.5 190) list(1189.5 1170)) 0.2)
dbCreatePath(cv list("M3" "drawing") list(list(1190.76 190) list(1190.76 1170)) 0.2)
dbCreatePath(cv list("M3" "drawing") list(list(130 1189.5) list(1170 1189.5)) 0.2)
dbCreatePath(cv list("M3" "drawing") list(list(130 1190.76) list(1170 1190.76)) 0.2)
dbCreatePath(cv list("M3" "drawing") list(list(110.5 850) list(110.5 1170)) 0.2)
dbCreatePath(cv list("M3" "drawing") list(list(109.24 850) list(109.24 1170)) 0.2)
dbCreatePath(cv list("M3" "drawing") list(list(130 1189.5) list(110.5 1189.5)) 0.2 "extendExtend")
dbCreatePath(cv list("M3" "drawing") list(list(110.5 1189.5) list(110.5 1170)) 0.2 "extendExtend")
dbCreatePath(cv list("M3" "drawing") list(list(130 1190.76) list(109.24 1190.76)) 0.2 "extendExtend")
dbCreatePath(cv list("M3" "drawing") list(list(109.24 1190.76) list(109.24 1170)) 0.2 "extendExtend")
dbCreatePath(cv list("M3" "drawing") list(list(1170 1189.5) list(1189.5 1189.5)) 0.2 "extendExtend")
dbCreatePath(cv list("M3" "drawing") list(list(1189.5 1189.5) list(1189.5 1170)) 0.2 "extendExtend")
dbCreatePath(cv list("M3" "drawing") list(list(1170 1190.76) list(1190.76 1190.76)) 0.2 "extendExtend")
dbCreatePath(cv list("M3" "drawing") list(list(1190.76 1190.76) list(1190.76 1170)) 0.2 "extendExtend")
dbCreatePath(cv list("M3" "drawing") list(list(110.12 1047.655) list(110.5 1047.655)) 0.2)
tech = techGetTechFile(cv)
viaParams = list(list("cutRows" 2) list("cutColumns" 4))
viaDefId = techFindViaDefByName(tech "M3_M2")
newVia = dbCreateVia(cv viaDefId list(110.12 1047.655) "R270" viaParams)
dbCreatePath(cv list("M3" "drawing") list(list(110.12 987.61) list(109.24 987.61)) 0.2)
tech = techGetTechFile(cv)
viaParams = list(list("cutRows" 2) list("cutColumns" 4))
viaDefId = techFindViaDefByName(tech "M3_M2")
newVia = dbCreateVia(cv viaDefId list(110.12 987.61) "R270" viaParams)
dbCreatePath(cv list("M3" "drawing") list(list(109.875 1159.8) list(110.5 1159.8)) 0.26)
dbCreatePath(cv list("M3" "drawing") list(list(109.875 1164.1) list(109.24 1164.1)) 0.26)
dbCreateLabel(cv list("M4" "pin") list(109.875 1168.275) "DCLK_CORE" "centerLeft" "R0" "roman" 2)
dbCreatePath(cv list("M3" "drawing") list(list(109.875 1099.8) list(110.5 1099.8)) 0.26)
dbCreatePath(cv list("M3" "drawing") list(list(109.875 1104.1) list(109.24 1104.1)) 0.26)
dbCreateLabel(cv list("M4" "pin") list(109.875 1108.275) "SYNC_CORE" "centerLeft" "R0" "roman" 2)
dbCreatePath(cv list("M3" "drawing") list(list(1190.76 200.2) list(1190.125 200.2)) 0.26)
dbCreatePath(cv list("M3" "drawing") list(list(1190.76 191.725) list(1190.125 191.725)) 0.26)
dbCreatePath(cv list("M3" "drawing") list(list(1189.5 195.9) list(1190.125 195.9)) 0.26)
dbCreateLabel(cv list("M4" "pin") list(1190.125 204.33) "SLP_CORE" "centerRight" "R0" "roman" 2)
dbCreatePath(cv list("M3" "drawing") list(list(1190.76 260.2) list(1190.125 260.2)) 0.26)
dbCreatePath(cv list("M3" "drawing") list(list(1190.76 251.725) list(1190.125 251.725)) 0.26)
dbCreatePath(cv list("M3" "drawing") list(list(1189.5 255.9) list(1190.125 255.9)) 0.26)
dbCreateLabel(cv list("M4" "pin") list(1190.125 264.33) "SDI_CORE" "centerRight" "R0" "roman" 2)
dbCreatePath(cv list("M3" "drawing") list(list(1190.76 320.2) list(1190.125 320.2)) 0.26)
dbCreatePath(cv list("M3" "drawing") list(list(1190.76 311.725) list(1190.125 311.725)) 0.26)
dbCreatePath(cv list("M3" "drawing") list(list(1189.5 315.9) list(1190.125 315.9)) 0.26)
dbCreateLabel(cv list("M4" "pin") list(1190.125 324.33) "SCK_CORE" "centerRight" "R0" "roman" 2)
dbCreatePath(cv list("M3" "drawing") list(list(1189.5 380.2) list(1190.125 380.2)) 0.26)
dbCreatePath(cv list("M3" "drawing") list(list(1190.76 375.9) list(1190.125 375.9)) 0.26)
dbCreateLabel(cv list("M4" "pin") list(1190.125 371.725) "SDO_CORE" "centerRight" "R0" "roman" 2)
dbCreatePath(cv list("M3" "drawing") list(list(1190.76 440.2) list(1190.125 440.2)) 0.26)
dbCreatePath(cv list("M3" "drawing") list(list(1190.76 431.725) list(1190.125 431.725)) 0.26)
dbCreatePath(cv list("M3" "drawing") list(list(1189.5 435.9) list(1190.125 435.9)) 0.26)
dbCreateLabel(cv list("M4" "pin") list(1190.125 444.33) "RST_CORE" "centerRight" "R0" "roman" 2)
dbCreatePath(cv list("M3" "drawing") list(list(1189.5 500.2) list(1190.125 500.2)) 0.26)
dbCreatePath(cv list("M3" "drawing") list(list(1190.76 495.9) list(1190.125 495.9)) 0.26)
dbCreateLabel(cv list("M4" "pin") list(1190.125 491.725) "D0_CORE" "centerRight" "R0" "roman" 2)
dbCreatePath(cv list("M3" "drawing") list(list(1189.5 560.2) list(1190.125 560.2)) 0.26)
dbCreatePath(cv list("M3" "drawing") list(list(1190.76 555.9) list(1190.125 555.9)) 0.26)
dbCreateLabel(cv list("M4" "pin") list(1190.125 551.725) "D1_CORE" "centerRight" "R0" "roman" 2)
dbCreatePath(cv list("M3" "drawing") list(list(1189.5 620.2) list(1190.125 620.2)) 0.26)
dbCreatePath(cv list("M3" "drawing") list(list(1190.76 615.9) list(1190.125 615.9)) 0.26)
dbCreateLabel(cv list("M4" "pin") list(1190.125 611.725) "D2_CORE" "centerRight" "R0" "roman" 2)
dbCreatePath(cv list("M3" "drawing") list(list(1189.5 680.2) list(1190.125 680.2)) 0.26)
dbCreatePath(cv list("M3" "drawing") list(list(1190.76 675.9) list(1190.125 675.9)) 0.26)
dbCreateLabel(cv list("M4" "pin") list(1190.125 671.725) "D3_CORE" "centerRight" "R0" "roman" 2)
dbCreatePath(cv list("M3" "drawing") list(list(1189.5 740.2) list(1190.125 740.2)) 0.26)
dbCreatePath(cv list("M3" "drawing") list(list(1190.76 735.9) list(1190.125 735.9)) 0.26)
dbCreateLabel(cv list("M4" "pin") list(1190.125 731.725) "D4_CORE" "centerRight" "R0" "roman" 2)
dbCreatePath(cv list("M3" "drawing") list(list(1189.5 800.2) list(1190.125 800.2)) 0.26)
dbCreatePath(cv list("M3" "drawing") list(list(1190.76 795.9) list(1190.125 795.9)) 0.26)
dbCreateLabel(cv list("M4" "pin") list(1190.125 791.725) "D5_CORE" "centerRight" "R0" "roman" 2)
dbCreatePath(cv list("M3" "drawing") list(list(1189.5 860.2) list(1190.125 860.2)) 0.26)
dbCreatePath(cv list("M3" "drawing") list(list(1190.76 855.9) list(1190.125 855.9)) 0.26)
dbCreateLabel(cv list("M4" "pin") list(1190.125 851.725) "D6_CORE" "centerRight" "R0" "roman" 2)
dbCreatePath(cv list("M3" "drawing") list(list(1189.5 920.2) list(1190.125 920.2)) 0.26)
dbCreatePath(cv list("M3" "drawing") list(list(1190.76 915.9) list(1190.125 915.9)) 0.26)
dbCreateLabel(cv list("M4" "pin") list(1190.125 911.725) "D7_CORE" "centerRight" "R0" "roman" 2)
dbCreatePath(cv list("M3" "drawing") list(list(1189.5 980.2) list(1190.125 980.2)) 0.26)
dbCreatePath(cv list("M3" "drawing") list(list(1190.76 975.9) list(1190.125 975.9)) 0.26)
dbCreateLabel(cv list("M4" "pin") list(1190.125 971.725) "D8_CORE" "centerRight" "R0" "roman" 2)
dbCreatePath(cv list("M3" "drawing") list(list(1189.5 1040.2) list(1190.125 1040.2)) 0.26)
dbCreatePath(cv list("M3" "drawing") list(list(1190.76 1035.9) list(1190.125 1035.9)) 0.26)
dbCreateLabel(cv list("M4" "pin") list(1190.125 1031.725) "D9_CORE" "centerRight" "R0" "roman" 2)
dbCreatePath(cv list("M3" "drawing") list(list(1189.5 1100.2) list(1190.125 1100.2)) 0.26)
dbCreatePath(cv list("M3" "drawing") list(list(1190.76 1095.9) list(1190.125 1095.9)) 0.26)
dbCreateLabel(cv list("M4" "pin") list(1190.125 1091.725) "D10_CORE" "centerRight" "R0" "roman" 2)
dbCreatePath(cv list("M3" "drawing") list(list(1189.5 1160.2) list(1190.125 1160.2)) 0.26)
dbCreatePath(cv list("M3" "drawing") list(list(1190.76 1155.9) list(1190.125 1155.9)) 0.26)
dbCreateLabel(cv list("M4" "pin") list(1190.125 1151.725) "D11_CORE" "centerRight" "R0" "roman" 2)
dbCreatePath(cv list("M3" "drawing") list(list(1159.8 1190.125) list(1159.8 1189.5)) 0.26)
dbCreatePath(cv list("M3" "drawing") list(list(1164.1 1190.125) list(1164.1 1190.76)) 0.26)
dbCreateLabel(cv list("M4" "pin") list(1168.275 1190.125) "D12_CORE" "centerRight" "R90" "roman" 2)
dbCreatePath(cv list("M3" "drawing") list(list(1099.8 1190.125) list(1099.8 1189.5)) 0.26)
dbCreatePath(cv list("M3" "drawing") list(list(1104.1 1190.125) list(1104.1 1190.76)) 0.26)
dbCreateLabel(cv list("M4" "pin") list(1108.275 1190.125) "D13_CORE" "centerRight" "R90" "roman" 2)
dbCreatePath(cv list("M3" "drawing") list(list(1039.8 1190.125) list(1039.8 1189.5)) 0.26)
dbCreatePath(cv list("M3" "drawing") list(list(1044.1 1190.125) list(1044.1 1190.76)) 0.26)
dbCreateLabel(cv list("M4" "pin") list(1048.275 1190.125) "D14_CORE" "centerRight" "R90" "roman" 2)
dbCreatePath(cv list("M3" "drawing") list(list(979.8 1190.125) list(979.8 1189.5)) 0.26)
dbCreatePath(cv list("M3" "drawing") list(list(984.1 1190.125) list(984.1 1190.76)) 0.26)
dbCreateLabel(cv list("M4" "pin") list(988.275 1190.125) "D15_CORE" "centerRight" "R90" "roman" 2)
dbCreatePath(cv list("M3" "drawing") list(list(919.8 1190.125) list(919.8 1190.76)) 0.26)
dbCreatePath(cv list("M3" "drawing") list(list(928.275 1190.125) list(928.275 1190.76)) 0.26)
dbCreatePath(cv list("M3" "drawing") list(list(924.1 1190.125) list(924.1 1189.5)) 0.26)
dbCreateLabel(cv list("M4" "pin") list(915.67 1190.125) "CS_CORE" "centerRight" "R90" "roman" 2)
dbCreatePath(cv list("M3" "drawing") list(list(859.8 1190.125) list(859.8 1190.76)) 0.26)
dbCreatePath(cv list("M3" "drawing") list(list(868.275 1190.125) list(868.275 1190.76)) 0.26)
dbCreatePath(cv list("M3" "drawing") list(list(864.1 1190.125) list(864.1 1189.5)) 0.26)
dbCreateLabel(cv list("M4" "pin") list(855.67 1190.125) "EN_CORE" "centerRight" "R90" "roman" 2)
dbCreatePath(cv list("M3" "drawing") list(list(799.8 1190.125) list(799.8 1190.76)) 0.26)
dbCreatePath(cv list("M3" "drawing") list(list(808.275 1190.125) list(808.275 1190.76)) 0.26)
dbCreatePath(cv list("M3" "drawing") list(list(804.1 1190.125) list(804.1 1189.5)) 0.26)
dbCreateLabel(cv list("M4" "pin") list(795.67 1190.125) "TEST_CORE" "centerRight" "R90" "roman" 2)
dbCreatePath(cv list("M3" "drawing") list(list(739.8 1190.125) list(739.8 1190.76)) 0.26)
dbCreatePath(cv list("M3" "drawing") list(list(748.275 1190.125) list(748.275 1190.76)) 0.26)
dbCreatePath(cv list("M3" "drawing") list(list(744.1 1190.125) list(744.1 1189.5)) 0.26)
dbCreateLabel(cv list("M4" "pin") list(735.67 1190.125) "RSTN_CORE" "centerRight" "R90" "roman" 2)
dbCreatePath(cv list("M3" "drawing") list(list(679.8 1190.125) list(679.8 1190.76)) 0.26)
dbCreatePath(cv list("M3" "drawing") list(list(688.275 1190.125) list(688.275 1190.76)) 0.26)
dbCreatePath(cv list("M3" "drawing") list(list(684.1 1190.125) list(684.1 1189.5)) 0.26)
dbCreateLabel(cv list("M4" "pin") list(675.67 1190.125) "MCLK_CORE" "centerRight" "R90" "roman" 2)
dbCreatePath(cv list("M3" "drawing") list(list(619.8 1190.125) list(619.8 1190.76)) 0.26)
dbCreatePath(cv list("M3" "drawing") list(list(628.275 1190.125) list(628.275 1190.76)) 0.26)
dbCreatePath(cv list("M3" "drawing") list(list(624.1 1190.125) list(624.1 1189.5)) 0.26)
dbCreateLabel(cv list("M4" "pin") list(615.67 1190.125) "SCLK_CORE" "centerRight" "R90" "roman" 2)
dbCreatePath(cv list("M3" "drawing") list(list(559.8 1190.125) list(559.8 1190.76)) 0.26)
dbCreatePath(cv list("M3" "drawing") list(list(568.275 1190.125) list(568.275 1190.76)) 0.26)
dbCreatePath(cv list("M3" "drawing") list(list(564.1 1190.125) list(564.1 1189.5)) 0.26)
dbCreateLabel(cv list("M4" "pin") list(555.67 1190.125) "LRCK_CORE" "centerRight" "R90" "roman" 2)
dbCreatePath(cv list("M3" "drawing") list(list(499.8 1190.125) list(499.8 1190.76)) 0.26)
dbCreatePath(cv list("M3" "drawing") list(list(508.275 1190.125) list(508.275 1190.76)) 0.26)
dbCreatePath(cv list("M3" "drawing") list(list(504.1 1190.125) list(504.1 1189.5)) 0.26)
dbCreateLabel(cv list("M4" "pin") list(495.67 1190.125) "DIN_CORE" "centerRight" "R90" "roman" 2)
dbCreatePath(cv list("M3" "drawing") list(list(439.8 1190.125) list(439.8 1189.5)) 0.26)
dbCreatePath(cv list("M3" "drawing") list(list(444.1 1190.125) list(444.1 1190.76)) 0.26)
dbCreateLabel(cv list("M4" "pin") list(448.275 1190.125) "DOUT_CORE" "centerRight" "R90" "roman" 2)
dbCreatePath(cv list("M3" "drawing") list(list(379.8 1190.125) list(379.8 1189.5)) 0.26)
dbCreatePath(cv list("M3" "drawing") list(list(384.1 1190.125) list(384.1 1190.76)) 0.26)
dbCreateLabel(cv list("M4" "pin") list(388.275 1190.125) "DOUT1_CORE" "centerRight" "R90" "roman" 2)
dbCreatePath(cv list("M3" "drawing") list(list(319.8 1190.125) list(319.8 1189.5)) 0.26)
dbCreatePath(cv list("M3" "drawing") list(list(324.1 1190.125) list(324.1 1190.76)) 0.26)
dbCreateLabel(cv list("M4" "pin") list(328.275 1190.125) "DOUT2_CORE" "centerRight" "R90" "roman" 2)
dbCreatePath(cv list("M3" "drawing") list(list(259.8 1190.125) list(259.8 1189.5)) 0.26)
dbCreatePath(cv list("M3" "drawing") list(list(264.1 1190.125) list(264.1 1190.76)) 0.26)
dbCreateLabel(cv list("M4" "pin") list(268.275 1190.125) "DOUT3_CORE" "centerRight" "R90" "roman" 2)
dbCreatePath(cv list("M3" "drawing") list(list(199.8 1190.125) list(199.8 1189.5)) 0.26)
dbCreatePath(cv list("M3" "drawing") list(list(204.1 1190.125) list(204.1 1190.76)) 0.26)
dbCreateLabel(cv list("M4" "pin") list(208.275 1190.125) "DOUT4_CORE" "centerRight" "R90" "roman" 2)
dbCreatePath(cv list("M3" "drawing") list(list(139.8 1190.125) list(139.8 1189.5)) 0.26)
dbCreatePath(cv list("M3" "drawing") list(list(144.1 1190.125) list(144.1 1190.76)) 0.26)
dbCreateLabel(cv list("M4" "pin") list(148.275 1190.125) "DOUT5_CORE" "centerRight" "R90" "roman" 2)
dbCreatePath(cv list("M3" "drawing") list(list(1009.8 1190.125) list(1009.8 1189.5)) 0.26)
dbCreatePath(cv list("M3" "drawing") list(list(1014.1 1190.125) list(1014.1 1190.76)) 0.26)
dbCreateLabel(cv list("M4" "pin") list(1018.275 1190.125) "D16_CORE" "centerRight" "R90" "roman" 2)
dbCreatePath(cv list("M3" "drawing") list(list(649.8 1190.125) list(649.8 1189.5)) 0.26)
dbCreatePath(cv list("M3" "drawing") list(list(654.1 1190.125) list(654.1 1190.76)) 0.26)
dbCreateLabel(cv list("M4" "pin") list(658.275 1190.125) "DCLK_CORE" "centerRight" "R90" "roman" 2)

; ==================== Pin Labels (with Inner Pad Support) ====================
dbCreateLabel(cv list("AP" "pin") list(-11 1160) "DCLK" "centerRight" "R0" "roman" 10)
dbCreateLabel(cv list("AP" "pin") list(-11 1100) "SYNC" "centerRight" "R0" "roman" 10)
dbCreateLabel(cv list("AP" "pin") list(-11 1040) "VIOL" "centerRight" "R0" "roman" 10)
dbCreateLabel(cv list("AP" "pin") list(-11 980) "GIOL" "centerRight" "R0" "roman" 10)
dbCreateLabel(cv list("AP" "pin") list(-11 920) "VIOH" "centerRight" "R0" "roman" 10)
dbCreateLabel(cv list("AP" "pin") list(-11 860) "GIOH" "centerRight" "R0" "roman" 10)
dbCreateLabel(cv list("AP" "pin") list(-11 800) "VDD3" "centerRight" "R0" "roman" 10)
dbCreateLabel(cv list("AP" "pin") list(-11 740) "IB3" "centerRight" "R0" "roman" 10)
dbCreateLabel(cv list("AP" "pin") list(-11 680) "VDD12" "centerRight" "R0" "roman" 10)
dbCreateLabel(cv list("AP" "pin") list(-11 620) "IB12" "centerRight" "R0" "roman" 10)
dbCreateLabel(cv list("AP" "pin") list(-11 560) "VDD_CDAC" "centerRight" "R0" "roman" 10)
dbCreateLabel(cv list("AP" "pin") list(-11 500) "VREFDES" "centerRight" "R0" "roman" 10)
dbCreateLabel(cv list("AP" "pin") list(-11 440) "IBREF" "centerRight" "R0" "roman" 10)
dbCreateLabel(cv list("AP" "pin") list(-11 380) "VSS" "centerRight" "R0" "roman" 10)
dbCreateLabel(cv list("AP" "pin") list(-11 320) "IBUF_IBIAS" "centerRight" "R0" "roman" 10)
dbCreateLabel(cv list("AP" "pin") list(-11 260) "VDDIB" "centerRight" "R0" "roman" 10)
dbCreateLabel(cv list("M2" "pin") list(109.9 260) "VDDIB_CORE" "centerLeft" "R0" "roman" 2)
dbCreateLabel(cv list("AP" "pin") list(-11 200) "VSSIB" "centerRight" "R0" "roman" 10)
dbCreateLabel(cv list("M2" "pin") list(109.9 200) "VSSIB_CORE" "centerLeft" "R0" "roman" 2)
dbCreateLabel(cv list("AP" "pin") list(-11 140) "VINP" "centerRight" "R0" "roman" 10)
dbCreateLabel(cv list("AP" "pin") list(140 -11) "VINN" "centerRight" "R90" "roman" 10)
dbCreateLabel(cv list("AP" "pin") list(200 -11) "VINCM" "centerRight" "R90" "roman" 10)
dbCreateLabel(cv list("AP" "pin") list(260 -11) "GND_CKB" "centerRight" "R90" "roman" 10)
dbCreateLabel(cv list("M2" "pin") list(260 109.9) "GND_CKB_CORE" "centerLeft" "R90" "roman" 2)
dbCreateLabel(cv list("AP" "pin") list(320 -11) "VDD_CKB" "centerRight" "R90" "roman" 10)
dbCreateLabel(cv list("M2" "pin") list(320 109.9) "VDD_CKB_CORE" "centerLeft" "R90" "roman" 2)
dbCreateLabel(cv list("AP" "pin") list(380 -11) "CLKP" "centerRight" "R90" "roman" 10)
dbCreateLabel(cv list("AP" "pin") list(440 -11) "CLKN" "centerRight" "R90" "roman" 10)
dbCreateLabel(cv list("AP" "pin") list(500 -11) "VDD_DAT" "centerRight" "R90" "roman" 10)
dbCreateLabel(cv list("M2" "pin") list(500 109.9) "VDD_DAT_CORE" "centerLeft" "R90" "roman" 2)
dbCreateLabel(cv list("AP" "pin") list(560 -11) "GND_DAT" "centerRight" "R90" "roman" 10)
dbCreateLabel(cv list("M2" "pin") list(560 109.9) "GND_DAT_CORE" "centerLeft" "R90" "roman" 2)
dbCreateLabel(cv list("AP" "pin") list(620 -11) "VCM" "centerRight" "R90" "roman" 10)
dbCreateLabel(cv list("AP" "pin") list(680 -11) "VSSCLK" "centerRight" "R90" "roman" 10)
dbCreateLabel(cv list("AP" "pin") list(740 -11) "VDDCLK" "centerRight" "R90" "roman" 10)
dbCreateLabel(cv list("AP" "pin") list(800 -11) "AVDD" "centerRight" "R90" "roman" 10)
dbCreateLabel(cv list("AP" "pin") list(860 -11) "AVSS" "centerRight" "R90" "roman" 10)
dbCreateLabel(cv list("AP" "pin") list(920 -11) "VDDSAR" "centerRight" "R90" "roman" 10)
dbCreateLabel(cv list("AP" "pin") list(980 -11) "VSSSAR" "centerRight" "R90" "roman" 10)
dbCreateLabel(cv list("AP" "pin") list(1040 -11) "VREFDES2" "centerRight" "R90" "roman" 10)
dbCreateLabel(cv list("AP" "pin") list(1100 -11) "IBREF2" "centerRight" "R90" "roman" 10)
dbCreateLabel(cv list("AP" "pin") list(1160 -11) "VREFDES3" "centerRight" "R90" "roman" 10)
dbCreateLabel(cv list("AP" "pin") list(1311 140) "IBREF3" "centerLeft" "R0" "roman" 10)
dbCreateLabel(cv list("AP" "pin") list(1311 200) "SLP" "centerLeft" "R0" "roman" 10)
dbCreateLabel(cv list("AP" "pin") list(1311 260) "SDI" "centerLeft" "R0" "roman" 10)
dbCreateLabel(cv list("AP" "pin") list(1311 320) "SCK" "centerLeft" "R0" "roman" 10)
dbCreateLabel(cv list("AP" "pin") list(1311 380) "SDO" "centerLeft" "R0" "roman" 10)
dbCreateLabel(cv list("AP" "pin") list(1311 440) "RST" "centerLeft" "R0" "roman" 10)
dbCreateLabel(cv list("AP" "pin") list(1311 500) "D0" "centerLeft" "R0" "roman" 10)
dbCreateLabel(cv list("AP" "pin") list(1311 560) "D1" "centerLeft" "R0" "roman" 10)
dbCreateLabel(cv list("AP" "pin") list(1311 620) "D2" "centerLeft" "R0" "roman" 10)
dbCreateLabel(cv list("AP" "pin") list(1311 680) "D3" "centerLeft" "R0" "roman" 10)
dbCreateLabel(cv list("AP" "pin") list(1311 740) "D4" "centerLeft" "R0" "roman" 10)
dbCreateLabel(cv list("AP" "pin") list(1311 800) "D5" "centerLeft" "R0" "roman" 10)
dbCreateLabel(cv list("AP" "pin") list(1311 860) "D6" "centerLeft" "R0" "roman" 10)
dbCreateLabel(cv list("AP" "pin") list(1311 920) "D7" "centerLeft" "R0" "roman" 10)
dbCreateLabel(cv list("AP" "pin") list(1311 980) "D8" "centerLeft" "R0" "roman" 10)
dbCreateLabel(cv list("AP" "pin") list(1311 1040) "D9" "centerLeft" "R0" "roman" 10)
dbCreateLabel(cv list("AP" "pin") list(1311 1100) "D10" "centerLeft" "R0" "roman" 10)
dbCreateLabel(cv list("AP" "pin") list(1311 1160) "D11" "centerLeft" "R0" "roman" 10)
dbCreateLabel(cv list("AP" "pin") list(1160 1311) "D12" "centerLeft" "R90" "roman" 10)
dbCreateLabel(cv list("AP" "pin") list(1100 1311) "D13" "centerLeft" "R90" "roman" 10)
dbCreateLabel(cv list("AP" "pin") list(1040 1311) "D14" "centerLeft" "R90" "roman" 10)
dbCreateLabel(cv list("AP" "pin") list(980 1311) "D15" "centerLeft" "R90" "roman" 10)
dbCreateLabel(cv list("AP" "pin") list(920 1311) "CS" "centerLeft" "R90" "roman" 10)
dbCreateLabel(cv list("AP" "pin") list(860 1311) "EN" "centerLeft" "R90" "roman" 10)
dbCreateLabel(cv list("AP" "pin") list(800 1311) "TEST" "centerLeft" "R90" "roman" 10)
dbCreateLabel(cv list("AP" "pin") list(740 1311) "RSTN" "centerLeft" "R90" "roman" 10)
dbCreateLabel(cv list("AP" "pin") list(680 1311) "MCLK" "centerLeft" "R90" "roman" 10)
dbCreateLabel(cv list("AP" "pin") list(620 1311) "SCLK" "centerLeft" "R90" "roman" 10)
dbCreateLabel(cv list("AP" "pin") list(560 1311) "LRCK" "centerLeft" "R90" "roman" 10)
dbCreateLabel(cv list("AP" "pin") list(500 1311) "DIN" "centerLeft" "R90" "roman" 10)
dbCreateLabel(cv list("AP" "pin") list(440 1311) "DOUT" "centerLeft" "R90" "roman" 10)
dbCreateLabel(cv list("AP" "pin") list(380 1311) "DOUT1" "centerLeft" "R90" "roman" 10)
dbCreateLabel(cv list("AP" "pin") list(320 1311) "DOUT2" "centerLeft" "R90" "roman" 10)
dbCreateLabel(cv list("AP" "pin") list(260 1311) "DOUT3" "centerLeft" "R90" "roman" 10)
dbCreateLabel(cv list("AP" "pin") list(200 1311) "DOUT4" "centerLeft" "R90" "roman" 10)
dbCreateLabel(cv list("AP" "pin") list(140 1311) "DOUT5" "centerLeft" "R90" "roman" 10)
dbCreateLabel(cv list("AP" "pin") list(950 152) "VSS_CORE" "centerLeft" "R90" "roman" 10)
dbCreateLabel(cv list("AP" "pin") list(1010 1148) "D16" "centerRight" "R90" "roman" 10)
dbCreateLabel(cv list("AP" "pin") list(830 152) "AVDD_CORE" "centerLeft" "R90" "roman" 10)
dbCreateLabel(cv list("AP" "pin") list(650 1148) "DCLK" "centerRight" "R90" "roman" 10)

dbSave(cv)
t
