pddw16sdgz_h_gMaster = dbOpenCellView("tphn28hpcpgv18" "PDDW16SDGZ_H_G" "symbol")
dbCreateInst(cv pddw16sdgz_h_gMaster "RSTN_left0" '(0 25.6875) "R270")
schCreateWire(cv "route" "full" '((1.000 25.562) (1.750 25.562)) 0 0 0 nil nil)
schCreateWireLabel(cv nil '(1.250 25.562) "VSS" "lowerLeft" "R0" "stick" 0.0625 nil)
schCreateWire(cv "route" "full" '((1.000 25.438) (1.750 25.438)) 0 0 0 nil nil)
schCreateWireLabel(cv nil '(1.250 25.438) "RSTN_CORE" "lowerLeft" "R0" "stick" 0.0625 nil)
schCreatePin(cv nil "RSTN_CORE" "inputOutput" nil '(1.750 25.438) "R180")
schCreateWire(cv "route" "full" '((1.000 25.812) (1.750 25.812)) 0 0 0 nil nil)
schCreateWireLabel(cv nil '(1.250 25.812) "IOVDDL" "lowerLeft" "R0" "stick" 0.0625 nil)
schCreateWire(cv "route" "full" '((1.000 25.938) (1.750 25.938)) 0 0 0 nil nil)
schCreateWireLabel(cv nil '(1.250 25.938) "VSS" "lowerLeft" "R0" "stick" 0.0625 nil)
schCreateWire(cv "route" "full" '((0.000 25.000) (-0.750 25.000)) 0 0 0 nil nil)
schCreateWireLabel(cv nil '(-0.250 25.000) "RSTN" "lowerRight" "R0" "stick" 0.0625 nil)
schCreatePin(cv nil "RSTN" "inputOutput" nil '(-0.750 25.000) "R0")
schCreateWire(cv "route" "full" '((1.000 25.312) (1.750 25.312)) 0 0 0 nil nil)
schCreateWireLabel(cv nil '(1.250 25.312) "POC" "lowerLeft" "R0" "stick" 0.0625 nil)
schCreateWire(cv "route" "full" '((1.000 25.125) (1.750 25.125)) 0 0 0 nil nil)
schCreateWireLabel(cv nil '(1.250 25.125) "IOVDDL" "lowerLeft" "R0" "stick" 0.0625 nil)
schCreateWire(cv "route" "full" '((1.000 24.938) (1.750 24.938)) 0 0 0 nil nil)
schCreateWireLabel(cv nil '(1.250 24.938) "VSS" "lowerLeft" "R0" "stick" 0.0625 nil)
schCreateWire(cv "route" "full" '((1.000 24.750) (1.750 24.750)) 0 0 0 nil nil)
schCreateWireLabel(cv nil '(1.250 24.750) "IOVDDH" "lowerLeft" "R0" "stick" 0.0625 nil)
schCreateWire(cv "route" "full" '((1.000 24.375) (1.750 24.375)) 0 0 0 nil nil)
schCreateWireLabel(cv nil '(1.250 24.375) "IOVSS" "lowerLeft" "R0" "stick" 0.0625 nil)
dbCreateInst(cv pddw16sdgz_h_gMaster "SCK_left1" '(0 23.6875) "R270")
schCreateWire(cv "route" "full" '((1.000 23.562) (1.750 23.562)) 0 0 0 nil nil)
schCreateWireLabel(cv nil '(1.250 23.562) "VSS" "lowerLeft" "R0" "stick" 0.0625 nil)
schCreateWire(cv "route" "full" '((1.000 23.438) (1.750 23.438)) 0 0 0 nil nil)
schCreateWireLabel(cv nil '(1.250 23.438) "SCK_CORE" "lowerLeft" "R0" "stick" 0.0625 nil)
schCreatePin(cv nil "SCK_CORE" "inputOutput" nil '(1.750 23.438) "R180")
schCreateWire(cv "route" "full" '((1.000 23.812) (1.750 23.812)) 0 0 0 nil nil)
schCreateWireLabel(cv nil '(1.250 23.812) "IOVDDL" "lowerLeft" "R0" "stick" 0.0625 nil)
schCreateWire(cv "route" "full" '((1.000 23.938) (1.750 23.938)) 0 0 0 nil nil)
schCreateWireLabel(cv nil '(1.250 23.938) "VSS" "lowerLeft" "R0" "stick" 0.0625 nil)
schCreateWire(cv "route" "full" '((0.000 23.000) (-0.750 23.000)) 0 0 0 nil nil)
schCreateWireLabel(cv nil '(-0.250 23.000) "SCK" "lowerRight" "R0" "stick" 0.0625 nil)
schCreatePin(cv nil "SCK" "inputOutput" nil '(-0.750 23.000) "R0")
schCreateWire(cv "route" "full" '((1.000 23.312) (1.750 23.312)) 0 0 0 nil nil)
schCreateWireLabel(cv nil '(1.250 23.312) "POC" "lowerLeft" "R0" "stick" 0.0625 nil)
schCreateWire(cv "route" "full" '((1.000 23.125) (1.750 23.125)) 0 0 0 nil nil)
schCreateWireLabel(cv nil '(1.250 23.125) "IOVDDL" "lowerLeft" "R0" "stick" 0.0625 nil)
schCreateWire(cv "route" "full" '((1.000 22.938) (1.750 22.938)) 0 0 0 nil nil)
schCreateWireLabel(cv nil '(1.250 22.938) "VSS" "lowerLeft" "R0" "stick" 0.0625 nil)
schCreateWire(cv "route" "full" '((1.000 22.750) (1.750 22.750)) 0 0 0 nil nil)
schCreateWireLabel(cv nil '(1.250 22.750) "IOVDDH" "lowerLeft" "R0" "stick" 0.0625 nil)
schCreateWire(cv "route" "full" '((1.000 22.375) (1.750 22.375)) 0 0 0 nil nil)
schCreateWireLabel(cv nil '(1.250 22.375) "IOVSS" "lowerLeft" "R0" "stick" 0.0625 nil)
dbCreateInst(cv pddw16sdgz_h_gMaster "SDI_left2" '(0 21.6875) "R270")
schCreateWire(cv "route" "full" '((1.000 21.562) (1.750 21.562)) 0 0 0 nil nil)
schCreateWireLabel(cv nil '(1.250 21.562) "VSS" "lowerLeft" "R0" "stick" 0.0625 nil)
schCreateWire(cv "route" "full" '((1.000 21.438) (1.750 21.438)) 0 0 0 nil nil)
schCreateWireLabel(cv nil '(1.250 21.438) "SDI_CORE" "lowerLeft" "R0" "stick" 0.0625 nil)
schCreatePin(cv nil "SDI_CORE" "inputOutput" nil '(1.750 21.438) "R180")
schCreateWire(cv "route" "full" '((1.000 21.812) (1.750 21.812)) 0 0 0 nil nil)
schCreateWireLabel(cv nil '(1.250 21.812) "IOVDDL" "lowerLeft" "R0" "stick" 0.0625 nil)
schCreateWire(cv "route" "full" '((1.000 21.938) (1.750 21.938)) 0 0 0 nil nil)
schCreateWireLabel(cv nil '(1.250 21.938) "VSS" "lowerLeft" "R0" "stick" 0.0625 nil)
schCreateWire(cv "route" "full" '((0.000 21.000) (-0.750 21.000)) 0 0 0 nil nil)
schCreateWireLabel(cv nil '(-0.250 21.000) "SDI" "lowerRight" "R0" "stick" 0.0625 nil)
schCreatePin(cv nil "SDI" "inputOutput" nil '(-0.750 21.000) "R0")
schCreateWire(cv "route" "full" '((1.000 21.312) (1.750 21.312)) 0 0 0 nil nil)
schCreateWireLabel(cv nil '(1.250 21.312) "POC" "lowerLeft" "R0" "stick" 0.0625 nil)
schCreateWire(cv "route" "full" '((1.000 21.125) (1.750 21.125)) 0 0 0 nil nil)
schCreateWireLabel(cv nil '(1.250 21.125) "IOVDDL" "lowerLeft" "R0" "stick" 0.0625 nil)
schCreateWire(cv "route" "full" '((1.000 20.938) (1.750 20.938)) 0 0 0 nil nil)
schCreateWireLabel(cv nil '(1.250 20.938) "VSS" "lowerLeft" "R0" "stick" 0.0625 nil)
schCreateWire(cv "route" "full" '((1.000 20.750) (1.750 20.750)) 0 0 0 nil nil)
schCreateWireLabel(cv nil '(1.250 20.750) "IOVDDH" "lowerLeft" "R0" "stick" 0.0625 nil)
schCreateWire(cv "route" "full" '((1.000 20.375) (1.750 20.375)) 0 0 0 nil nil)
schCreateWireLabel(cv nil '(1.250 20.375) "IOVSS" "lowerLeft" "R0" "stick" 0.0625 nil)
dbCreateInst(cv pddw16sdgz_h_gMaster "SDO_left3" '(0 19.6875) "R270")
schCreateWire(cv "route" "full" '((1.000 19.562) (1.750 19.562)) 0 0 0 nil nil)
schCreateWireLabel(cv nil '(1.250 19.562) "IOVDDL" "lowerLeft" "R0" "stick" 0.0625 nil)
noConnMaster = dbOpenCellView("basic" "noConn" "symbol")
schCreateWire(cv "route" "full" '((1.000 19.438) (1.750 19.438)) 0 0 0 nil nil)
dbCreateInst(cv noConnMaster "noConn_SDO_left3_C" '(1.750 19.438) "R90")
schCreateWire(cv "route" "full" '((1.000 19.812) (1.750 19.812)) 0 0 0 nil nil)
schCreateWireLabel(cv nil '(1.250 19.812) "VSS" "lowerLeft" "R0" "stick" 0.0625 nil)
schCreateWire(cv "route" "full" '((1.000 19.938) (1.750 19.938)) 0 0 0 nil nil)
schCreateWireLabel(cv nil '(1.250 19.938) "SDO_CORE" "lowerLeft" "R0" "stick" 0.0625 nil)
schCreatePin(cv nil "SDO_CORE" "inputOutput" nil '(1.750 19.938) "R180")
schCreateWire(cv "route" "full" '((0.000 19.000) (-0.750 19.000)) 0 0 0 nil nil)
schCreateWireLabel(cv nil '(-0.250 19.000) "SDO" "lowerRight" "R0" "stick" 0.0625 nil)
schCreatePin(cv nil "SDO" "inputOutput" nil '(-0.750 19.000) "R0")
schCreateWire(cv "route" "full" '((1.000 19.312) (1.750 19.312)) 0 0 0 nil nil)
schCreateWireLabel(cv nil '(1.250 19.312) "POC" "lowerLeft" "R0" "stick" 0.0625 nil)
schCreateWire(cv "route" "full" '((1.000 19.125) (1.750 19.125)) 0 0 0 nil nil)
schCreateWireLabel(cv nil '(1.250 19.125) "IOVDDL" "lowerLeft" "R0" "stick" 0.0625 nil)
schCreateWire(cv "route" "full" '((1.000 18.938) (1.750 18.938)) 0 0 0 nil nil)
schCreateWireLabel(cv nil '(1.250 18.938) "VSS" "lowerLeft" "R0" "stick" 0.0625 nil)
schCreateWire(cv "route" "full" '((1.000 18.750) (1.750 18.750)) 0 0 0 nil nil)
schCreateWireLabel(cv nil '(1.250 18.750) "IOVDDH" "lowerLeft" "R0" "stick" 0.0625 nil)
schCreateWire(cv "route" "full" '((1.000 18.375) (1.750 18.375)) 0 0 0 nil nil)
schCreateWireLabel(cv nil '(1.250 18.375) "IOVSS" "lowerLeft" "R0" "stick" 0.0625 nil)
dbCreateInst(cv pddw16sdgz_h_gMaster "D8_left4" '(0 17.6875) "R270")
schCreateWire(cv "route" "full" '((1.000 17.562) (1.750 17.562)) 0 0 0 nil nil)
schCreateWireLabel(cv nil '(1.250 17.562) "IOVDDL" "lowerLeft" "R0" "stick" 0.0625 nil)
schCreateWire(cv "route" "full" '((1.000 17.438) (1.750 17.438)) 0 0 0 nil nil)
dbCreateInst(cv noConnMaster "noConn_D8_left4_C" '(1.750 17.438) "R90")
schCreateWire(cv "route" "full" '((1.000 17.812) (1.750 17.812)) 0 0 0 nil nil)
schCreateWireLabel(cv nil '(1.250 17.812) "VSS" "lowerLeft" "R0" "stick" 0.0625 nil)
schCreateWire(cv "route" "full" '((1.000 17.938) (1.750 17.938)) 0 0 0 nil nil)
schCreateWireLabel(cv nil '(1.250 17.938) "D8_CORE" "lowerLeft" "R0" "stick" 0.0625 nil)
schCreatePin(cv nil "D8_CORE" "inputOutput" nil '(1.750 17.938) "R180")
schCreateWire(cv "route" "full" '((0.000 17.000) (-0.750 17.000)) 0 0 0 nil nil)
schCreateWireLabel(cv nil '(-0.250 17.000) "D8" "lowerRight" "R0" "stick" 0.0625 nil)
schCreatePin(cv nil "D8" "inputOutput" nil '(-0.750 17.000) "R0")
schCreateWire(cv "route" "full" '((1.000 17.312) (1.750 17.312)) 0 0 0 nil nil)
schCreateWireLabel(cv nil '(1.250 17.312) "POC" "lowerLeft" "R0" "stick" 0.0625 nil)
schCreateWire(cv "route" "full" '((1.000 17.125) (1.750 17.125)) 0 0 0 nil nil)
schCreateWireLabel(cv nil '(1.250 17.125) "IOVDDL" "lowerLeft" "R0" "stick" 0.0625 nil)
schCreateWire(cv "route" "full" '((1.000 16.938) (1.750 16.938)) 0 0 0 nil nil)
schCreateWireLabel(cv nil '(1.250 16.938) "VSS" "lowerLeft" "R0" "stick" 0.0625 nil)
schCreateWire(cv "route" "full" '((1.000 16.750) (1.750 16.750)) 0 0 0 nil nil)
schCreateWireLabel(cv nil '(1.250 16.750) "IOVDDH" "lowerLeft" "R0" "stick" 0.0625 nil)
schCreateWire(cv "route" "full" '((1.000 16.375) (1.750 16.375)) 0 0 0 nil nil)
schCreateWireLabel(cv nil '(1.250 16.375) "IOVSS" "lowerLeft" "R0" "stick" 0.0625 nil)
dbCreateInst(cv pddw16sdgz_h_gMaster "D7_left5" '(0 15.6875) "R270")
schCreateWire(cv "route" "full" '((1.000 15.562) (1.750 15.562)) 0 0 0 nil nil)
schCreateWireLabel(cv nil '(1.250 15.562) "IOVDDL" "lowerLeft" "R0" "stick" 0.0625 nil)
schCreateWire(cv "route" "full" '((1.000 15.438) (1.750 15.438)) 0 0 0 nil nil)
dbCreateInst(cv noConnMaster "noConn_D7_left5_C" '(1.750 15.438) "R90")
schCreateWire(cv "route" "full" '((1.000 15.812) (1.750 15.812)) 0 0 0 nil nil)
schCreateWireLabel(cv nil '(1.250 15.812) "VSS" "lowerLeft" "R0" "stick" 0.0625 nil)
schCreateWire(cv "route" "full" '((1.000 15.938) (1.750 15.938)) 0 0 0 nil nil)
schCreateWireLabel(cv nil '(1.250 15.938) "D7_CORE" "lowerLeft" "R0" "stick" 0.0625 nil)
schCreatePin(cv nil "D7_CORE" "inputOutput" nil '(1.750 15.938) "R180")
schCreateWire(cv "route" "full" '((0.000 14.999) (-0.750 14.999)) 0 0 0 nil nil)
schCreateWireLabel(cv nil '(-0.250 14.999) "D7" "lowerRight" "R0" "stick" 0.0625 nil)
schCreatePin(cv nil "D7" "inputOutput" nil '(-0.750 14.999) "R0")
schCreateWire(cv "route" "full" '((1.000 15.312) (1.750 15.312)) 0 0 0 nil nil)
schCreateWireLabel(cv nil '(1.250 15.312) "POC" "lowerLeft" "R0" "stick" 0.0625 nil)
schCreateWire(cv "route" "full" '((1.000 15.126) (1.750 15.126)) 0 0 0 nil nil)
schCreateWireLabel(cv nil '(1.250 15.126) "IOVDDL" "lowerLeft" "R0" "stick" 0.0625 nil)
schCreateWire(cv "route" "full" '((1.000 14.938) (1.750 14.938)) 0 0 0 nil nil)
schCreateWireLabel(cv nil '(1.250 14.938) "VSS" "lowerLeft" "R0" "stick" 0.0625 nil)
schCreateWire(cv "route" "full" '((1.000 14.749) (1.750 14.749)) 0 0 0 nil nil)
schCreateWireLabel(cv nil '(1.250 14.749) "IOVDDH" "lowerLeft" "R0" "stick" 0.0625 nil)
schCreateWire(cv "route" "full" '((1.000 14.376) (1.750 14.376)) 0 0 0 nil nil)
schCreateWireLabel(cv nil '(1.250 14.376) "IOVSS" "lowerLeft" "R0" "stick" 0.0625 nil)
dbCreateInst(cv pddw16sdgz_h_gMaster "D6_left6" '(0 13.6875) "R270")
schCreateWire(cv "route" "full" '((1.000 13.562) (1.750 13.562)) 0 0 0 nil nil)
schCreateWireLabel(cv nil '(1.250 13.562) "IOVDDL" "lowerLeft" "R0" "stick" 0.0625 nil)
schCreateWire(cv "route" "full" '((1.000 13.438) (1.750 13.438)) 0 0 0 nil nil)
dbCreateInst(cv noConnMaster "noConn_D6_left6_C" '(1.750 13.438) "R90")
schCreateWire(cv "route" "full" '((1.000 13.812) (1.750 13.812)) 0 0 0 nil nil)
schCreateWireLabel(cv nil '(1.250 13.812) "VSS" "lowerLeft" "R0" "stick" 0.0625 nil)
schCreateWire(cv "route" "full" '((1.000 13.938) (1.750 13.938)) 0 0 0 nil nil)
schCreateWireLabel(cv nil '(1.250 13.938) "D6_CORE" "lowerLeft" "R0" "stick" 0.0625 nil)
schCreatePin(cv nil "D6_CORE" "inputOutput" nil '(1.750 13.938) "R180")
schCreateWire(cv "route" "full" '((0.000 12.999) (-0.750 12.999)) 0 0 0 nil nil)
schCreateWireLabel(cv nil '(-0.250 12.999) "D6" "lowerRight" "R0" "stick" 0.0625 nil)
schCreatePin(cv nil "D6" "inputOutput" nil '(-0.750 12.999) "R0")
schCreateWire(cv "route" "full" '((1.000 13.312) (1.750 13.312)) 0 0 0 nil nil)
schCreateWireLabel(cv nil '(1.250 13.312) "POC" "lowerLeft" "R0" "stick" 0.0625 nil)
schCreateWire(cv "route" "full" '((1.000 13.126) (1.750 13.126)) 0 0 0 nil nil)
schCreateWireLabel(cv nil '(1.250 13.126) "IOVDDL" "lowerLeft" "R0" "stick" 0.0625 nil)
schCreateWire(cv "route" "full" '((1.000 12.938) (1.750 12.938)) 0 0 0 nil nil)
schCreateWireLabel(cv nil '(1.250 12.938) "VSS" "lowerLeft" "R0" "stick" 0.0625 nil)
schCreateWire(cv "route" "full" '((1.000 12.749) (1.750 12.749)) 0 0 0 nil nil)
schCreateWireLabel(cv nil '(1.250 12.749) "IOVDDH" "lowerLeft" "R0" "stick" 0.0625 nil)
schCreateWire(cv "route" "full" '((1.000 12.376) (1.750 12.376)) 0 0 0 nil nil)
schCreateWireLabel(cv nil '(1.250 12.376) "IOVSS" "lowerLeft" "R0" "stick" 0.0625 nil)
dbCreateInst(cv pddw16sdgz_h_gMaster "D5_left7" '(0 11.6875) "R270")
schCreateWire(cv "route" "full" '((1.000 11.562) (1.750 11.562)) 0 0 0 nil nil)
schCreateWireLabel(cv nil '(1.250 11.562) "IOVDDL" "lowerLeft" "R0" "stick" 0.0625 nil)
schCreateWire(cv "route" "full" '((1.000 11.438) (1.750 11.438)) 0 0 0 nil nil)
dbCreateInst(cv noConnMaster "noConn_D5_left7_C" '(1.750 11.438) "R90")
schCreateWire(cv "route" "full" '((1.000 11.812) (1.750 11.812)) 0 0 0 nil nil)
schCreateWireLabel(cv nil '(1.250 11.812) "VSS" "lowerLeft" "R0" "stick" 0.0625 nil)
schCreateWire(cv "route" "full" '((1.000 11.938) (1.750 11.938)) 0 0 0 nil nil)
schCreateWireLabel(cv nil '(1.250 11.938) "D5_CORE" "lowerLeft" "R0" "stick" 0.0625 nil)
schCreatePin(cv nil "D5_CORE" "inputOutput" nil '(1.750 11.938) "R180")
schCreateWire(cv "route" "full" '((0.000 10.999) (-0.750 10.999)) 0 0 0 nil nil)
schCreateWireLabel(cv nil '(-0.250 10.999) "D5" "lowerRight" "R0" "stick" 0.0625 nil)
schCreatePin(cv nil "D5" "inputOutput" nil '(-0.750 10.999) "R0")
schCreateWire(cv "route" "full" '((1.000 11.312) (1.750 11.312)) 0 0 0 nil nil)
schCreateWireLabel(cv nil '(1.250 11.312) "POC" "lowerLeft" "R0" "stick" 0.0625 nil)
schCreateWire(cv "route" "full" '((1.000 11.126) (1.750 11.126)) 0 0 0 nil nil)
schCreateWireLabel(cv nil '(1.250 11.126) "IOVDDL" "lowerLeft" "R0" "stick" 0.0625 nil)
schCreateWire(cv "route" "full" '((1.000 10.938) (1.750 10.938)) 0 0 0 nil nil)
schCreateWireLabel(cv nil '(1.250 10.938) "VSS" "lowerLeft" "R0" "stick" 0.0625 nil)
schCreateWire(cv "route" "full" '((1.000 10.749) (1.750 10.749)) 0 0 0 nil nil)
schCreateWireLabel(cv nil '(1.250 10.749) "IOVDDH" "lowerLeft" "R0" "stick" 0.0625 nil)
schCreateWire(cv "route" "full" '((1.000 10.376) (1.750 10.376)) 0 0 0 nil nil)
schCreateWireLabel(cv nil '(1.250 10.376) "IOVSS" "lowerLeft" "R0" "stick" 0.0625 nil)
dbCreateInst(cv pddw16sdgz_h_gMaster "D4_left8" '(0 9.6875) "R270")
schCreateWire(cv "route" "full" '((1.000 9.562) (1.750 9.562)) 0 0 0 nil nil)
schCreateWireLabel(cv nil '(1.250 9.562) "IOVDDL" "lowerLeft" "R0" "stick" 0.0625 nil)
schCreateWire(cv "route" "full" '((1.000 9.438) (1.750 9.438)) 0 0 0 nil nil)
dbCreateInst(cv noConnMaster "noConn_D4_left8_C" '(1.750 9.438) "R90")
schCreateWire(cv "route" "full" '((1.000 9.812) (1.750 9.812)) 0 0 0 nil nil)
schCreateWireLabel(cv nil '(1.250 9.812) "VSS" "lowerLeft" "R0" "stick" 0.0625 nil)
schCreateWire(cv "route" "full" '((1.000 9.938) (1.750 9.938)) 0 0 0 nil nil)
schCreateWireLabel(cv nil '(1.250 9.938) "D4_CORE" "lowerLeft" "R0" "stick" 0.0625 nil)
schCreatePin(cv nil "D4_CORE" "inputOutput" nil '(1.750 9.938) "R180")
schCreateWire(cv "route" "full" '((0.000 8.999) (-0.750 8.999)) 0 0 0 nil nil)
schCreateWireLabel(cv nil '(-0.250 8.999) "D4" "lowerRight" "R0" "stick" 0.0625 nil)
schCreatePin(cv nil "D4" "inputOutput" nil '(-0.750 8.999) "R0")
schCreateWire(cv "route" "full" '((1.000 9.312) (1.750 9.312)) 0 0 0 nil nil)
schCreateWireLabel(cv nil '(1.250 9.312) "POC" "lowerLeft" "R0" "stick" 0.0625 nil)
schCreateWire(cv "route" "full" '((1.000 9.126) (1.750 9.126)) 0 0 0 nil nil)
schCreateWireLabel(cv nil '(1.250 9.126) "IOVDDL" "lowerLeft" "R0" "stick" 0.0625 nil)
schCreateWire(cv "route" "full" '((1.000 8.938) (1.750 8.938)) 0 0 0 nil nil)
schCreateWireLabel(cv nil '(1.250 8.938) "VSS" "lowerLeft" "R0" "stick" 0.0625 nil)
schCreateWire(cv "route" "full" '((1.000 8.749) (1.750 8.749)) 0 0 0 nil nil)
schCreateWireLabel(cv nil '(1.250 8.749) "IOVDDH" "lowerLeft" "R0" "stick" 0.0625 nil)
schCreateWire(cv "route" "full" '((1.000 8.376) (1.750 8.376)) 0 0 0 nil nil)
schCreateWireLabel(cv nil '(1.250 8.376) "IOVSS" "lowerLeft" "R0" "stick" 0.0625 nil)
dbCreateInst(cv pddw16sdgz_h_gMaster "D3_left9" '(0 7.6875) "R270")
schCreateWire(cv "route" "full" '((1.000 7.562) (1.750 7.562)) 0 0 0 nil nil)
schCreateWireLabel(cv nil '(1.250 7.562) "IOVDDL" "lowerLeft" "R0" "stick" 0.0625 nil)
schCreateWire(cv "route" "full" '((1.000 7.438) (1.750 7.438)) 0 0 0 nil nil)
dbCreateInst(cv noConnMaster "noConn_D3_left9_C" '(1.750 7.438) "R90")
schCreateWire(cv "route" "full" '((1.000 7.812) (1.750 7.812)) 0 0 0 nil nil)
schCreateWireLabel(cv nil '(1.250 7.812) "VSS" "lowerLeft" "R0" "stick" 0.0625 nil)
schCreateWire(cv "route" "full" '((1.000 7.938) (1.750 7.938)) 0 0 0 nil nil)
schCreateWireLabel(cv nil '(1.250 7.938) "D3_CORE" "lowerLeft" "R0" "stick" 0.0625 nil)
schCreatePin(cv nil "D3_CORE" "inputOutput" nil '(1.750 7.938) "R180")
schCreateWire(cv "route" "full" '((0.000 7.000) (-0.750 7.000)) 0 0 0 nil nil)
schCreateWireLabel(cv nil '(-0.250 7.000) "D3" "lowerRight" "R0" "stick" 0.0625 nil)
schCreatePin(cv nil "D3" "inputOutput" nil '(-0.750 7.000) "R0")
schCreateWire(cv "route" "full" '((1.000 7.312) (1.750 7.312)) 0 0 0 nil nil)
schCreateWireLabel(cv nil '(1.250 7.312) "POC" "lowerLeft" "R0" "stick" 0.0625 nil)
schCreateWire(cv "route" "full" '((1.000 7.125) (1.750 7.125)) 0 0 0 nil nil)
schCreateWireLabel(cv nil '(1.250 7.125) "IOVDDL" "lowerLeft" "R0" "stick" 0.0625 nil)
schCreateWire(cv "route" "full" '((1.000 6.938) (1.750 6.938)) 0 0 0 nil nil)
schCreateWireLabel(cv nil '(1.250 6.938) "VSS" "lowerLeft" "R0" "stick" 0.0625 nil)
schCreateWire(cv "route" "full" '((1.000 6.750) (1.750 6.750)) 0 0 0 nil nil)
schCreateWireLabel(cv nil '(1.250 6.750) "IOVDDH" "lowerLeft" "R0" "stick" 0.0625 nil)
schCreateWire(cv "route" "full" '((1.000 6.375) (1.750 6.375)) 0 0 0 nil nil)
schCreateWireLabel(cv nil '(1.250 6.375) "IOVSS" "lowerLeft" "R0" "stick" 0.0625 nil)
dbCreateInst(cv pddw16sdgz_h_gMaster "D2_left10" '(0 5.6875) "R270")
schCreateWire(cv "route" "full" '((1.000 5.562) (1.750 5.562)) 0 0 0 nil nil)
schCreateWireLabel(cv nil '(1.250 5.562) "IOVDDL" "lowerLeft" "R0" "stick" 0.0625 nil)
schCreateWire(cv "route" "full" '((1.000 5.438) (1.750 5.438)) 0 0 0 nil nil)
dbCreateInst(cv noConnMaster "noConn_D2_left10_C" '(1.750 5.438) "R90")
schCreateWire(cv "route" "full" '((1.000 5.812) (1.750 5.812)) 0 0 0 nil nil)
schCreateWireLabel(cv nil '(1.250 5.812) "VSS" "lowerLeft" "R0" "stick" 0.0625 nil)
schCreateWire(cv "route" "full" '((1.000 5.938) (1.750 5.938)) 0 0 0 nil nil)
schCreateWireLabel(cv nil '(1.250 5.938) "D2_CORE" "lowerLeft" "R0" "stick" 0.0625 nil)
schCreatePin(cv nil "D2_CORE" "inputOutput" nil '(1.750 5.938) "R180")
schCreateWire(cv "route" "full" '((0.000 5.000) (-0.750 5.000)) 0 0 0 nil nil)
schCreateWireLabel(cv nil '(-0.250 5.000) "D2" "lowerRight" "R0" "stick" 0.0625 nil)
schCreatePin(cv nil "D2" "inputOutput" nil '(-0.750 5.000) "R0")
schCreateWire(cv "route" "full" '((1.000 5.312) (1.750 5.312)) 0 0 0 nil nil)
schCreateWireLabel(cv nil '(1.250 5.312) "POC" "lowerLeft" "R0" "stick" 0.0625 nil)
schCreateWire(cv "route" "full" '((1.000 5.125) (1.750 5.125)) 0 0 0 nil nil)
schCreateWireLabel(cv nil '(1.250 5.125) "IOVDDL" "lowerLeft" "R0" "stick" 0.0625 nil)
schCreateWire(cv "route" "full" '((1.000 4.938) (1.750 4.938)) 0 0 0 nil nil)
schCreateWireLabel(cv nil '(1.250 4.938) "VSS" "lowerLeft" "R0" "stick" 0.0625 nil)
schCreateWire(cv "route" "full" '((1.000 4.750) (1.750 4.750)) 0 0 0 nil nil)
schCreateWireLabel(cv nil '(1.250 4.750) "IOVDDH" "lowerLeft" "R0" "stick" 0.0625 nil)
schCreateWire(cv "route" "full" '((1.000 4.375) (1.750 4.375)) 0 0 0 nil nil)
schCreateWireLabel(cv nil '(1.250 4.375) "IOVSS" "lowerLeft" "R0" "stick" 0.0625 nil)
dbCreateInst(cv pddw16sdgz_h_gMaster "D1_left11" '(0 3.6875) "R270")
schCreateWire(cv "route" "full" '((1.000 3.562) (1.750 3.562)) 0 0 0 nil nil)
schCreateWireLabel(cv nil '(1.250 3.562) "IOVDDL" "lowerLeft" "R0" "stick" 0.0625 nil)
schCreateWire(cv "route" "full" '((1.000 3.438) (1.750 3.438)) 0 0 0 nil nil)
dbCreateInst(cv noConnMaster "noConn_D1_left11_C" '(1.750 3.438) "R90")
schCreateWire(cv "route" "full" '((1.000 3.812) (1.750 3.812)) 0 0 0 nil nil)
schCreateWireLabel(cv nil '(1.250 3.812) "VSS" "lowerLeft" "R0" "stick" 0.0625 nil)
schCreateWire(cv "route" "full" '((1.000 3.938) (1.750 3.938)) 0 0 0 nil nil)
schCreateWireLabel(cv nil '(1.250 3.938) "D1_CORE" "lowerLeft" "R0" "stick" 0.0625 nil)
schCreatePin(cv nil "D1_CORE" "inputOutput" nil '(1.750 3.938) "R180")
schCreateWire(cv "route" "full" '((0.000 3.000) (-0.750 3.000)) 0 0 0 nil nil)
schCreateWireLabel(cv nil '(-0.250 3.000) "D1" "lowerRight" "R0" "stick" 0.0625 nil)
schCreatePin(cv nil "D1" "inputOutput" nil '(-0.750 3.000) "R0")
schCreateWire(cv "route" "full" '((1.000 3.312) (1.750 3.312)) 0 0 0 nil nil)
schCreateWireLabel(cv nil '(1.250 3.312) "POC" "lowerLeft" "R0" "stick" 0.0625 nil)
schCreateWire(cv "route" "full" '((1.000 3.125) (1.750 3.125)) 0 0 0 nil nil)
schCreateWireLabel(cv nil '(1.250 3.125) "IOVDDL" "lowerLeft" "R0" "stick" 0.0625 nil)
schCreateWire(cv "route" "full" '((1.000 2.938) (1.750 2.938)) 0 0 0 nil nil)
schCreateWireLabel(cv nil '(1.250 2.938) "VSS" "lowerLeft" "R0" "stick" 0.0625 nil)
schCreateWire(cv "route" "full" '((1.000 2.750) (1.750 2.750)) 0 0 0 nil nil)
schCreateWireLabel(cv nil '(1.250 2.750) "IOVDDH" "lowerLeft" "R0" "stick" 0.0625 nil)
schCreateWire(cv "route" "full" '((1.000 2.375) (1.750 2.375)) 0 0 0 nil nil)
schCreateWireLabel(cv nil '(1.250 2.375) "IOVSS" "lowerLeft" "R0" "stick" 0.0625 nil)
pddw16sdgz_v_gMaster = dbOpenCellView("tphn28hpcpgv18" "PDDW16SDGZ_V_G" "symbol")
dbCreateInst(cv pddw16sdgz_v_gMaster "D0_bottom0" '(2.3125 0) "R0")
schCreateWire(cv "route" "full" '((2.438 1.000) (2.438 1.750)) 0 0 0 nil nil)
schCreateWireLabel(cv nil '(2.438 1.250) "IOVDDL" "lowerLeft" "R90" "stick" 0.0625 nil)
schCreateWire(cv "route" "full" '((2.562 1.000) (2.562 1.750)) 0 0 0 nil nil)
dbCreateInst(cv noConnMaster "noConn_D0_bottom0_C" '(2.562 1.750) "R180")
schCreateWire(cv "route" "full" '((2.188 1.000) (2.188 1.750)) 0 0 0 nil nil)
schCreateWireLabel(cv nil '(2.188 1.250) "VSS" "lowerLeft" "R90" "stick" 0.0625 nil)
schCreateWire(cv "route" "full" '((2.062 1.000) (2.062 1.750)) 0 0 0 nil nil)
schCreateWireLabel(cv nil '(2.062 1.250) "D0_CORE" "lowerLeft" "R90" "stick" 0.0625 nil)
schCreatePin(cv nil "D0_CORE" "inputOutput" nil '(2.062 1.750) "R270")
schCreateWire(cv "route" "full" '((3.000 0.000) (3.000 -0.750)) 0 0 0 nil nil)
schCreateWireLabel(cv nil '(3.000 -0.250) "D0" "lowerRight" "R90" "stick" 0.0625 nil)
schCreatePin(cv nil "D0" "inputOutput" nil '(3.000 -0.750) "R90")
schCreateWire(cv "route" "full" '((2.688 1.000) (2.688 1.750)) 0 0 0 nil nil)
schCreateWireLabel(cv nil '(2.688 1.250) "POC" "lowerLeft" "R90" "stick" 0.0625 nil)
schCreateWire(cv "route" "full" '((2.875 1.000) (2.875 1.750)) 0 0 0 nil nil)
schCreateWireLabel(cv nil '(2.875 1.250) "IOVDDL" "lowerLeft" "R90" "stick" 0.0625 nil)
schCreateWire(cv "route" "full" '((3.062 1.000) (3.062 1.750)) 0 0 0 nil nil)
schCreateWireLabel(cv nil '(3.062 1.250) "VSS" "lowerLeft" "R90" "stick" 0.0625 nil)
schCreateWire(cv "route" "full" '((3.250 1.000) (3.250 1.750)) 0 0 0 nil nil)
schCreateWireLabel(cv nil '(3.250 1.250) "IOVDDH" "lowerLeft" "R90" "stick" 0.0625 nil)
schCreateWire(cv "route" "full" '((3.625 1.000) (3.625 1.750)) 0 0 0 nil nil)
schCreateWireLabel(cv nil '(3.625 1.250) "IOVSS" "lowerLeft" "R90" "stick" 0.0625 nil)
dbCreateInst(cv pddw16sdgz_v_gMaster "SLP_bottom1" '(4.3125 0) "R0")
schCreateWire(cv "route" "full" '((4.438 1.000) (4.438 1.750)) 0 0 0 nil nil)
schCreateWireLabel(cv nil '(4.438 1.250) "VSS" "lowerLeft" "R90" "stick" 0.0625 nil)
schCreateWire(cv "route" "full" '((4.562 1.000) (4.562 1.750)) 0 0 0 nil nil)
schCreateWireLabel(cv nil '(4.562 1.250) "SLP_CORE" "lowerLeft" "R90" "stick" 0.0625 nil)
schCreatePin(cv nil "SLP_CORE" "inputOutput" nil '(4.562 1.750) "R270")
schCreateWire(cv "route" "full" '((4.188 1.000) (4.188 1.750)) 0 0 0 nil nil)
schCreateWireLabel(cv nil '(4.188 1.250) "IOVDDL" "lowerLeft" "R90" "stick" 0.0625 nil)
schCreateWire(cv "route" "full" '((4.062 1.000) (4.062 1.750)) 0 0 0 nil nil)
schCreateWireLabel(cv nil '(4.062 1.250) "VSS" "lowerLeft" "R90" "stick" 0.0625 nil)
schCreateWire(cv "route" "full" '((5.000 0.000) (5.000 -0.750)) 0 0 0 nil nil)
schCreateWireLabel(cv nil '(5.000 -0.250) "SLP" "lowerRight" "R90" "stick" 0.0625 nil)
schCreatePin(cv nil "SLP" "inputOutput" nil '(5.000 -0.750) "R90")
schCreateWire(cv "route" "full" '((4.688 1.000) (4.688 1.750)) 0 0 0 nil nil)
schCreateWireLabel(cv nil '(4.688 1.250) "POC" "lowerLeft" "R90" "stick" 0.0625 nil)
schCreateWire(cv "route" "full" '((4.875 1.000) (4.875 1.750)) 0 0 0 nil nil)
schCreateWireLabel(cv nil '(4.875 1.250) "IOVDDL" "lowerLeft" "R90" "stick" 0.0625 nil)
schCreateWire(cv "route" "full" '((5.062 1.000) (5.062 1.750)) 0 0 0 nil nil)
schCreateWireLabel(cv nil '(5.062 1.250) "VSS" "lowerLeft" "R90" "stick" 0.0625 nil)
schCreateWire(cv "route" "full" '((5.250 1.000) (5.250 1.750)) 0 0 0 nil nil)
schCreateWireLabel(cv nil '(5.250 1.250) "IOVDDH" "lowerLeft" "R90" "stick" 0.0625 nil)
schCreateWire(cv "route" "full" '((5.625 1.000) (5.625 1.750)) 0 0 0 nil nil)
schCreateWireLabel(cv nil '(5.625 1.250) "IOVSS" "lowerLeft" "R90" "stick" 0.0625 nil)
pvdd2poc_v_gMaster = dbOpenCellView("tphn28hpcpgv18" "PVDD2POC_V_G" "symbol")
dbCreateInst(cv pvdd2poc_v_gMaster "IOVDDH_bottom2" '(6.0 0) "R0")
schCreateWire(cv "route" "full" '((6.375 1.000) (6.375 1.750)) 0 0 0 nil nil)
schCreateWireLabel(cv nil '(6.375 1.250) "POC" "lowerLeft" "R90" "stick" 0.0625 nil)
schCreateWire(cv "route" "full" '((6.562 1.000) (6.562 1.750)) 0 0 0 nil nil)
schCreateWireLabel(cv nil '(6.562 1.250) "IOVDDL" "lowerLeft" "R90" "stick" 0.0625 nil)
schCreateWire(cv "route" "full" '((6.750 1.000) (6.750 1.750)) 0 0 0 nil nil)
schCreateWireLabel(cv nil '(6.750 1.250) "VSS" "lowerLeft" "R90" "stick" 0.0625 nil)
schCreateWire(cv "route" "full" '((7.000 0.000) (7.000 -0.750)) 0 0 0 nil nil)
schCreateWireLabel(cv nil '(7.000 -0.250) "IOVDDH" "lowerRight" "R90" "stick" 0.0625 nil)
schCreatePin(cv nil "IOVDDH" "inputOutput" nil '(7.000 -0.750) "R90")
schCreateWire(cv "route" "full" '((7.312 1.000) (7.312 1.750)) 0 0 0 nil nil)
schCreateWireLabel(cv nil '(7.312 1.250) "IOVSS" "lowerLeft" "R90" "stick" 0.0625 nil)
pvss2dgz_v_gMaster = dbOpenCellView("tphn28hpcpgv18" "PVSS2DGZ_V_G" "symbol")
dbCreateInst(cv pvss2dgz_v_gMaster "IOVSS_bottom3" '(8.0 0) "R0")
schCreateWire(cv "route" "full" '((8.375 1.000) (8.375 1.750)) 0 0 0 nil nil)
schCreateWireLabel(cv nil '(8.375 1.250) "POC" "lowerLeft" "R90" "stick" 0.0625 nil)
schCreateWire(cv "route" "full" '((8.562 1.000) (8.562 1.750)) 0 0 0 nil nil)
schCreateWireLabel(cv nil '(8.562 1.250) "IOVDDL" "lowerLeft" "R90" "stick" 0.0625 nil)
schCreateWire(cv "route" "full" '((8.750 1.000) (8.750 1.750)) 0 0 0 nil nil)
schCreateWireLabel(cv nil '(8.750 1.250) "VSS" "lowerLeft" "R90" "stick" 0.0625 nil)
schCreateWire(cv "route" "full" '((8.938 1.000) (8.938 1.750)) 0 0 0 nil nil)
schCreateWireLabel(cv nil '(8.938 1.250) "IOVDDH" "lowerLeft" "R90" "stick" 0.0625 nil)
schCreateWire(cv "route" "full" '((9.000 0.000) (9.000 -0.750)) 0 0 0 nil nil)
schCreateWireLabel(cv nil '(9.000 -0.250) "IOVSS" "lowerRight" "R90" "stick" 0.0625 nil)
schCreatePin(cv nil "IOVSS" "inputOutput" nil '(9.000 -0.750) "R90")
pvdd1dgz_v_gMaster = dbOpenCellView("tphn28hpcpgv18" "PVDD1DGZ_V_G" "symbol")
dbCreateInst(cv pvdd1dgz_v_gMaster "IOVDDL_bottom4" '(10.0 0) "R0")
schCreateWire(cv "route" "full" '((10.375 1.000) (10.375 1.750)) 0 0 0 nil nil)
schCreateWireLabel(cv nil '(10.375 1.250) "POC" "lowerLeft" "R90" "stick" 0.0625 nil)
schCreateWire(cv "route" "full" '((11.000 0.000) (11.000 -0.750)) 0 0 0 nil nil)
schCreateWireLabel(cv nil '(11.000 -0.250) "IOVDDL" "lowerRight" "R90" "stick" 0.0625 nil)
schCreatePin(cv nil "IOVDDL" "inputOutput" nil '(11.000 -0.750) "R90")
schCreateWire(cv "route" "full" '((10.750 1.000) (10.750 1.750)) 0 0 0 nil nil)
schCreateWireLabel(cv nil '(10.750 1.250) "VSS" "lowerLeft" "R90" "stick" 0.0625 nil)
schCreateWire(cv "route" "full" '((10.938 1.000) (10.938 1.750)) 0 0 0 nil nil)
schCreateWireLabel(cv nil '(10.938 1.250) "IOVDDH" "lowerLeft" "R90" "stick" 0.0625 nil)
schCreateWire(cv "route" "full" '((11.312 1.000) (11.312 1.750)) 0 0 0 nil nil)
schCreateWireLabel(cv nil '(11.312 1.250) "IOVSS" "lowerLeft" "R90" "stick" 0.0625 nil)
pvss1dgz_v_gMaster = dbOpenCellView("tphn28hpcpgv18" "PVSS1DGZ_V_G" "symbol")
dbCreateInst(cv pvss1dgz_v_gMaster "VSS_bottom5" '(12.0 0) "R0")
schCreateWire(cv "route" "full" '((12.375 1.000) (12.375 1.750)) 0 0 0 nil nil)
schCreateWireLabel(cv nil '(12.375 1.250) "POC" "lowerLeft" "R90" "stick" 0.0625 nil)
schCreateWire(cv "route" "full" '((12.562 1.000) (12.562 1.750)) 0 0 0 nil nil)
schCreateWireLabel(cv nil '(12.562 1.250) "IOVDDL" "lowerLeft" "R90" "stick" 0.0625 nil)
schCreateWire(cv "route" "full" '((13.000 0.000) (13.000 -0.750)) 0 0 0 nil nil)
schCreateWireLabel(cv nil '(13.000 -0.250) "VSS" "lowerRight" "R90" "stick" 0.0625 nil)
schCreatePin(cv nil "VSS" "inputOutput" nil '(13.000 -0.750) "R90")
schCreateWire(cv "route" "full" '((12.938 1.000) (12.938 1.750)) 0 0 0 nil nil)
schCreateWireLabel(cv nil '(12.938 1.250) "IOVDDH" "lowerLeft" "R90" "stick" 0.0625 nil)
schCreateWire(cv "route" "full" '((13.312 1.000) (13.312 1.750)) 0 0 0 nil nil)
schCreateWireLabel(cv nil '(13.312 1.250) "IOVSS" "lowerLeft" "R90" "stick" 0.0625 nil)
pvss3ac_v_gMaster = dbOpenCellView("tphn28hpcpgv18" "PVSS3AC_V_G" "symbol")
dbCreateInst(cv pvss3ac_v_gMaster "DVSS_bottom6" '(15.1875 0) "R0")
schCreateWire(cv "route" "full" '((14.999 0.000) (14.999 -0.750)) 0 0 0 nil nil)
schCreateWireLabel(cv nil '(14.999 -0.250) "DVSS" "lowerRight" "R90" "stick" 0.0625 nil)
schCreatePin(cv nil "DVSS" "inputOutput" nil '(14.999 -0.750) "R90")
schCreateWire(cv "route" "full" '((15.312 0.875) (15.312 1.625)) 0 0 0 nil nil)
schCreateWireLabel(cv nil '(15.312 1.125) "VSS" "lowerLeft" "R90" "stick" 0.0625 nil)
schCreateWire(cv "route" "full" '((14.562 0.875) (14.562 1.625)) 0 0 0 nil nil)
schCreateWireLabel(cv nil '(14.562 1.125) "DVSS_CORE" "lowerLeft" "R90" "stick" 0.0625 nil)
schCreatePin(cv nil "DVSS_CORE" "inputOutput" nil '(14.562 1.625) "R270")
schCreateWire(cv "route" "full" '((14.938 0.875) (14.938 1.625)) 0 0 0 nil nil)
schCreateWireLabel(cv nil '(14.938 1.125) "DVDD" "lowerLeft" "R90" "stick" 0.0625 nil)
pvdd3ac_v_gMaster = dbOpenCellView("tphn28hpcpgv18" "PVDD3AC_V_G" "symbol")
dbCreateInst(cv pvdd3ac_v_gMaster "DVDD_bottom7" '(17.1875 0) "R0")
schCreateWire(cv "route" "full" '((16.562 0.875) (16.562 1.625)) 0 0 0 nil nil)
schCreateWireLabel(cv nil '(16.562 1.125) "DVDD_CORE" "lowerLeft" "R90" "stick" 0.0625 nil)
schCreatePin(cv nil "DVDD_CORE" "inputOutput" nil '(16.562 1.625) "R270")
schCreateWire(cv "route" "full" '((16.938 0.875) (16.938 1.625)) 0 0 0 nil nil)
schCreateWireLabel(cv nil '(16.938 1.125) "DVSS" "lowerLeft" "R90" "stick" 0.0625 nil)
schCreateWire(cv "route" "full" '((17.312 0.875) (17.312 1.625)) 0 0 0 nil nil)
schCreateWireLabel(cv nil '(17.312 1.125) "VSS" "lowerLeft" "R90" "stick" 0.0625 nil)
schCreateWire(cv "route" "full" '((17.000 0.000) (17.000 -0.750)) 0 0 0 nil nil)
schCreateWireLabel(cv nil '(17.000 -0.250) "DVDD" "lowerRight" "R90" "stick" 0.0625 nil)
schCreatePin(cv nil "DVDD" "inputOutput" nil '(17.000 -0.750) "R90")
pvdd1ac_v_gMaster = dbOpenCellView("tphn28hpcpgv18" "PVDD1AC_V_G" "symbol")
dbCreateInst(cv pvdd1ac_v_gMaster "VCALB_bottom8" '(19.1875 0) "R0")
schCreateWire(cv "route" "full" '((18.938 0.875) (18.938 1.625)) 0 0 0 nil nil)
schCreateWireLabel(cv nil '(18.938 1.125) "DVSS" "lowerLeft" "R90" "stick" 0.0625 nil)
schCreateWire(cv "route" "full" '((19.312 0.875) (19.312 1.625)) 0 0 0 nil nil)
schCreateWireLabel(cv nil '(19.312 1.125) "VSS" "lowerLeft" "R90" "stick" 0.0625 nil)
schCreateWire(cv "route" "full" '((19.000 0.000) (19.000 -0.750)) 0 0 0 nil nil)
schCreateWireLabel(cv nil '(19.000 -0.250) "VCALB" "lowerRight" "R90" "stick" 0.0625 nil)
schCreatePin(cv nil "VCALB" "inputOutput" nil '(19.000 -0.750) "R90")
schCreateWire(cv "route" "full" '((18.562 0.875) (18.562 1.625)) 0 0 0 nil nil)
schCreateWireLabel(cv nil '(18.562 1.125) "DVDD" "lowerLeft" "R90" "stick" 0.0625 nil)
dbCreateInst(cv pvdd1ac_v_gMaster "VCALF_bottom9" '(21.1875 0) "R0")
schCreateWire(cv "route" "full" '((20.938 0.875) (20.938 1.625)) 0 0 0 nil nil)
schCreateWireLabel(cv nil '(20.938 1.125) "DVSS" "lowerLeft" "R90" "stick" 0.0625 nil)
schCreateWire(cv "route" "full" '((21.312 0.875) (21.312 1.625)) 0 0 0 nil nil)
schCreateWireLabel(cv nil '(21.312 1.125) "VSS" "lowerLeft" "R90" "stick" 0.0625 nil)
schCreateWire(cv "route" "full" '((21.000 0.000) (21.000 -0.750)) 0 0 0 nil nil)
schCreateWireLabel(cv nil '(21.000 -0.250) "VCALF" "lowerRight" "R90" "stick" 0.0625 nil)
schCreatePin(cv nil "VCALF" "inputOutput" nil '(21.000 -0.750) "R90")
schCreateWire(cv "route" "full" '((20.562 0.875) (20.562 1.625)) 0 0 0 nil nil)
schCreateWireLabel(cv nil '(20.562 1.125) "DVDD" "lowerLeft" "R90" "stick" 0.0625 nil)
pdb3ac_v_gMaster = dbOpenCellView("tphn28hpcpgv18" "PDB3AC_V_G" "symbol")
dbCreateInst(cv pdb3ac_v_gMaster "IBIAS3N_bottom10" '(23.1875 0) "R0")
schCreateWire(cv "route" "full" '((23.000 0.000) (23.000 -0.750)) 0 0 0 nil nil)
schCreateWireLabel(cv nil '(23.000 -0.250) "IBIAS3N" "lowerRight" "R90" "stick" 0.0625 nil)
schCreatePin(cv nil "IBIAS3N" "inputOutput" nil '(23.000 -0.750) "R90")
schCreateWire(cv "route" "full" '((22.938 0.875) (22.938 1.625)) 0 0 0 nil nil)
schCreateWireLabel(cv nil '(22.938 1.125) "AVSS" "lowerLeft" "R90" "stick" 0.0625 nil)
schCreateWire(cv "route" "full" '((23.312 0.875) (23.312 1.625)) 0 0 0 nil nil)
schCreateWireLabel(cv nil '(23.312 1.125) "VSS" "lowerLeft" "R90" "stick" 0.0625 nil)
schCreateWire(cv "route" "full" '((22.562 0.875) (22.562 1.625)) 0 0 0 nil nil)
schCreateWireLabel(cv nil '(22.562 1.125) "AVDD" "lowerLeft" "R90" "stick" 0.0625 nil)
dbCreateInst(cv pdb3ac_v_gMaster "IBIAS2N_bottom11" '(25.1875 0) "R0")
schCreateWire(cv "route" "full" '((25.000 0.000) (25.000 -0.750)) 0 0 0 nil nil)
schCreateWireLabel(cv nil '(25.000 -0.250) "IBIAS2N" "lowerRight" "R90" "stick" 0.0625 nil)
schCreatePin(cv nil "IBIAS2N" "inputOutput" nil '(25.000 -0.750) "R90")
schCreateWire(cv "route" "full" '((24.938 0.875) (24.938 1.625)) 0 0 0 nil nil)
schCreateWireLabel(cv nil '(24.938 1.125) "AVSS" "lowerLeft" "R90" "stick" 0.0625 nil)
schCreateWire(cv "route" "full" '((25.312 0.875) (25.312 1.625)) 0 0 0 nil nil)
schCreateWireLabel(cv nil '(25.312 1.125) "VSS" "lowerLeft" "R90" "stick" 0.0625 nil)
schCreateWire(cv "route" "full" '((24.562 0.875) (24.562 1.625)) 0 0 0 nil nil)
schCreateWireLabel(cv nil '(24.562 1.125) "AVDD" "lowerLeft" "R90" "stick" 0.0625 nil)
pdb3ac_h_gMaster = dbOpenCellView("tphn28hpcpgv18" "PDB3AC_H_G" "symbol")
dbCreateInst(cv pdb3ac_h_gMaster "VAMP_right0" '(28.0 3.1875) "R90")
schCreateWire(cv "route" "full" '((28.000 2.999) (28.750 2.999)) 0 0 0 nil nil)
schCreateWireLabel(cv nil '(28.250 2.999) "VAMP" "lowerLeft" "R0" "stick" 0.0625 nil)
schCreatePin(cv nil "VAMP" "inputOutput" nil '(28.750 2.999) "R180")
schCreateWire(cv "route" "full" '((27.125 2.938) (26.375 2.938)) 0 0 0 nil nil)
schCreateWireLabel(cv nil '(26.875 2.938) "AVSS" "lowerRight" "R0" "stick" 0.0625 nil)
schCreateWire(cv "route" "full" '((27.125 3.312) (26.375 3.312)) 0 0 0 nil nil)
schCreateWireLabel(cv nil '(26.875 3.312) "VSS" "lowerRight" "R0" "stick" 0.0625 nil)
schCreateWire(cv "route" "full" '((27.125 2.562) (26.375 2.562)) 0 0 0 nil nil)
schCreateWireLabel(cv nil '(26.875 2.562) "AVDD" "lowerRight" "R0" "stick" 0.0625 nil)
dbCreateInst(cv pdb3ac_h_gMaster "IBIAS1P_right1" '(28.0 5.1875) "R90")
schCreateWire(cv "route" "full" '((28.000 5.000) (28.750 5.000)) 0 0 0 nil nil)
schCreateWireLabel(cv nil '(28.250 5.000) "IBIAS1P" "lowerLeft" "R0" "stick" 0.0625 nil)
schCreatePin(cv nil "IBIAS1P" "inputOutput" nil '(28.750 5.000) "R180")
schCreateWire(cv "route" "full" '((27.125 4.938) (26.375 4.938)) 0 0 0 nil nil)
schCreateWireLabel(cv nil '(26.875 4.938) "AVSS" "lowerRight" "R0" "stick" 0.0625 nil)
schCreateWire(cv "route" "full" '((27.125 5.312) (26.375 5.312)) 0 0 0 nil nil)
schCreateWireLabel(cv nil '(26.875 5.312) "VSS" "lowerRight" "R0" "stick" 0.0625 nil)
schCreateWire(cv "route" "full" '((27.125 4.562) (26.375 4.562)) 0 0 0 nil nil)
schCreateWireLabel(cv nil '(26.875 4.562) "AVDD" "lowerRight" "R0" "stick" 0.0625 nil)
dbCreateInst(cv pdb3ac_h_gMaster "VCM_right2" '(28.0 7.1875) "R90")
schCreateWire(cv "route" "full" '((28.000 7.000) (28.750 7.000)) 0 0 0 nil nil)
schCreateWireLabel(cv nil '(28.250 7.000) "VCM" "lowerLeft" "R0" "stick" 0.0625 nil)
schCreatePin(cv nil "VCM" "inputOutput" nil '(28.750 7.000) "R180")
schCreateWire(cv "route" "full" '((27.125 6.938) (26.375 6.938)) 0 0 0 nil nil)
schCreateWireLabel(cv nil '(26.875 6.938) "AVSS" "lowerRight" "R0" "stick" 0.0625 nil)
schCreateWire(cv "route" "full" '((27.125 7.312) (26.375 7.312)) 0 0 0 nil nil)
schCreateWireLabel(cv nil '(26.875 7.312) "VSS" "lowerRight" "R0" "stick" 0.0625 nil)
schCreateWire(cv "route" "full" '((27.125 6.562) (26.375 6.562)) 0 0 0 nil nil)
schCreateWireLabel(cv nil '(26.875 6.562) "AVDD" "lowerRight" "R0" "stick" 0.0625 nil)
pvdd3ac_h_gMaster = dbOpenCellView("tphn28hpcpgv18" "PVDD3AC_H_G" "symbol")
dbCreateInst(cv pvdd3ac_h_gMaster "AVDD_right3" '(28.0 9.1875) "R90")
schCreateWire(cv "route" "full" '((27.125 8.562) (26.375 8.562)) 0 0 0 nil nil)
schCreateWireLabel(cv nil '(26.875 8.562) "AVDD_CORE" "lowerRight" "R0" "stick" 0.0625 nil)
schCreatePin(cv nil "AVDD_CORE" "inputOutput" nil '(26.375 8.562) "R0")
schCreateWire(cv "route" "full" '((27.125 8.938) (26.375 8.938)) 0 0 0 nil nil)
schCreateWireLabel(cv nil '(26.875 8.938) "AVSS" "lowerRight" "R0" "stick" 0.0625 nil)
schCreateWire(cv "route" "full" '((27.125 9.312) (26.375 9.312)) 0 0 0 nil nil)
schCreateWireLabel(cv nil '(26.875 9.312) "VSS" "lowerRight" "R0" "stick" 0.0625 nil)
schCreateWire(cv "route" "full" '((28.000 8.999) (28.750 8.999)) 0 0 0 nil nil)
schCreateWireLabel(cv nil '(28.250 8.999) "AVDD" "lowerLeft" "R0" "stick" 0.0625 nil)
schCreatePin(cv nil "AVDD" "inputOutput" nil '(28.750 8.999) "R180")
pvss3ac_h_gMaster = dbOpenCellView("tphn28hpcpgv18" "PVSS3AC_H_G" "symbol")
dbCreateInst(cv pvss3ac_h_gMaster "AVSS_right4" '(28.0 11.1875) "R90")
schCreateWire(cv "route" "full" '((28.000 10.999) (28.750 10.999)) 0 0 0 nil nil)
schCreateWireLabel(cv nil '(28.250 10.999) "AVSS" "lowerLeft" "R0" "stick" 0.0625 nil)
schCreatePin(cv nil "AVSS" "inputOutput" nil '(28.750 10.999) "R180")
schCreateWire(cv "route" "full" '((27.125 11.312) (26.375 11.312)) 0 0 0 nil nil)
schCreateWireLabel(cv nil '(26.875 11.312) "VSS" "lowerRight" "R0" "stick" 0.0625 nil)
schCreateWire(cv "route" "full" '((27.125 10.562) (26.375 10.562)) 0 0 0 nil nil)
schCreateWireLabel(cv nil '(26.875 10.562) "AVSS_CORE" "lowerRight" "R0" "stick" 0.0625 nil)
schCreatePin(cv nil "AVSS_CORE" "inputOutput" nil '(26.375 10.562) "R0")
schCreateWire(cv "route" "full" '((27.125 10.938) (26.375 10.938)) 0 0 0 nil nil)
schCreateWireLabel(cv nil '(26.875 10.938) "AVDD" "lowerRight" "R0" "stick" 0.0625 nil)
dbCreateInst(cv pdb3ac_h_gMaster "VINN_right5" '(28.0 13.1875) "R90")
schCreateWire(cv "route" "full" '((28.000 12.999) (28.750 12.999)) 0 0 0 nil nil)
schCreateWireLabel(cv nil '(28.250 12.999) "VINN" "lowerLeft" "R0" "stick" 0.0625 nil)
schCreatePin(cv nil "VINN" "inputOutput" nil '(28.750 12.999) "R180")
schCreateWire(cv "route" "full" '((27.125 12.938) (26.375 12.938)) 0 0 0 nil nil)
schCreateWireLabel(cv nil '(26.875 12.938) "AVSS" "lowerRight" "R0" "stick" 0.0625 nil)
schCreateWire(cv "route" "full" '((27.125 13.312) (26.375 13.312)) 0 0 0 nil nil)
schCreateWireLabel(cv nil '(26.875 13.312) "VSS" "lowerRight" "R0" "stick" 0.0625 nil)
schCreateWire(cv "route" "full" '((27.125 12.562) (26.375 12.562)) 0 0 0 nil nil)
schCreateWireLabel(cv nil '(26.875 12.562) "AVDD" "lowerRight" "R0" "stick" 0.0625 nil)
dbCreateInst(cv pdb3ac_h_gMaster "VINP_right6" '(28.0 15.1875) "R90")
schCreateWire(cv "route" "full" '((28.000 14.999) (28.750 14.999)) 0 0 0 nil nil)
schCreateWireLabel(cv nil '(28.250 14.999) "VINP" "lowerLeft" "R0" "stick" 0.0625 nil)
schCreatePin(cv nil "VINP" "inputOutput" nil '(28.750 14.999) "R180")
schCreateWire(cv "route" "full" '((27.125 14.938) (26.375 14.938)) 0 0 0 nil nil)
schCreateWireLabel(cv nil '(26.875 14.938) "AVSS" "lowerRight" "R0" "stick" 0.0625 nil)
schCreateWire(cv "route" "full" '((27.125 15.312) (26.375 15.312)) 0 0 0 nil nil)
schCreateWireLabel(cv nil '(26.875 15.312) "VSS" "lowerRight" "R0" "stick" 0.0625 nil)
schCreateWire(cv "route" "full" '((27.125 14.562) (26.375 14.562)) 0 0 0 nil nil)
schCreateWireLabel(cv nil '(26.875 14.562) "AVDD" "lowerRight" "R0" "stick" 0.0625 nil)
pvdd1ac_h_gMaster = dbOpenCellView("tphn28hpcpgv18" "PVDD1AC_H_G" "symbol")
dbCreateInst(cv pvdd1ac_h_gMaster "AVDDBUF_right7" '(28.0 17.1875) "R90")
schCreateWire(cv "route" "full" '((27.125 16.938) (26.375 16.938)) 0 0 0 nil nil)
schCreateWireLabel(cv nil '(26.875 16.938) "AVSS" "lowerRight" "R0" "stick" 0.0625 nil)
schCreateWire(cv "route" "full" '((27.125 17.312) (26.375 17.312)) 0 0 0 nil nil)
schCreateWireLabel(cv nil '(26.875 17.312) "VSS" "lowerRight" "R0" "stick" 0.0625 nil)
schCreateWire(cv "route" "full" '((28.000 17.000) (28.750 17.000)) 0 0 0 nil nil)
schCreateWireLabel(cv nil '(28.250 17.000) "AVDDBUF" "lowerLeft" "R0" "stick" 0.0625 nil)
schCreatePin(cv nil "AVDDBUF" "inputOutput" nil '(28.750 17.000) "R180")
schCreateWire(cv "route" "full" '((27.125 16.562) (26.375 16.562)) 0 0 0 nil nil)
schCreateWireLabel(cv nil '(26.875 16.562) "AVDD" "lowerRight" "R0" "stick" 0.0625 nil)
dbCreateInst(cv pdb3ac_h_gMaster "IBUF1P_right8" '(28.0 19.1875) "R90")
schCreateWire(cv "route" "full" '((28.000 19.000) (28.750 19.000)) 0 0 0 nil nil)
schCreateWireLabel(cv nil '(28.250 19.000) "IBUF1P" "lowerLeft" "R0" "stick" 0.0625 nil)
schCreatePin(cv nil "IBUF1P" "inputOutput" nil '(28.750 19.000) "R180")
schCreateWire(cv "route" "full" '((27.125 18.938) (26.375 18.938)) 0 0 0 nil nil)
schCreateWireLabel(cv nil '(26.875 18.938) "AVSS" "lowerRight" "R0" "stick" 0.0625 nil)
schCreateWire(cv "route" "full" '((27.125 19.312) (26.375 19.312)) 0 0 0 nil nil)
schCreateWireLabel(cv nil '(26.875 19.312) "VSS" "lowerRight" "R0" "stick" 0.0625 nil)
schCreateWire(cv "route" "full" '((27.125 18.562) (26.375 18.562)) 0 0 0 nil nil)
schCreateWireLabel(cv nil '(26.875 18.562) "AVDD" "lowerRight" "R0" "stick" 0.0625 nil)
dbCreateInst(cv pdb3ac_h_gMaster "IBUF2N_right9" '(28.0 21.1875) "R90")
schCreateWire(cv "route" "full" '((28.000 21.000) (28.750 21.000)) 0 0 0 nil nil)
schCreateWireLabel(cv nil '(28.250 21.000) "IBUF2N" "lowerLeft" "R0" "stick" 0.0625 nil)
schCreatePin(cv nil "IBUF2N" "inputOutput" nil '(28.750 21.000) "R180")
schCreateWire(cv "route" "full" '((27.125 20.938) (26.375 20.938)) 0 0 0 nil nil)
schCreateWireLabel(cv nil '(26.875 20.938) "AVSS" "lowerRight" "R0" "stick" 0.0625 nil)
schCreateWire(cv "route" "full" '((27.125 21.312) (26.375 21.312)) 0 0 0 nil nil)
schCreateWireLabel(cv nil '(26.875 21.312) "VSS" "lowerRight" "R0" "stick" 0.0625 nil)
schCreateWire(cv "route" "full" '((27.125 20.562) (26.375 20.562)) 0 0 0 nil nil)
schCreateWireLabel(cv nil '(26.875 20.562) "AVDD" "lowerRight" "R0" "stick" 0.0625 nil)
dbCreateInst(cv pdb3ac_h_gMaster "IBUF3N_right10" '(28.0 23.1875) "R90")
schCreateWire(cv "route" "full" '((28.000 23.000) (28.750 23.000)) 0 0 0 nil nil)
schCreateWireLabel(cv nil '(28.250 23.000) "IBUF3N" "lowerLeft" "R0" "stick" 0.0625 nil)
schCreatePin(cv nil "IBUF3N" "inputOutput" nil '(28.750 23.000) "R180")
schCreateWire(cv "route" "full" '((27.125 22.938) (26.375 22.938)) 0 0 0 nil nil)
schCreateWireLabel(cv nil '(26.875 22.938) "AVSS" "lowerRight" "R0" "stick" 0.0625 nil)
schCreateWire(cv "route" "full" '((27.125 23.312) (26.375 23.312)) 0 0 0 nil nil)
schCreateWireLabel(cv nil '(26.875 23.312) "VSS" "lowerRight" "R0" "stick" 0.0625 nil)
schCreateWire(cv "route" "full" '((27.125 22.562) (26.375 22.562)) 0 0 0 nil nil)
schCreateWireLabel(cv nil '(26.875 22.562) "AVDD" "lowerRight" "R0" "stick" 0.0625 nil)
dbCreateInst(cv pvdd1ac_h_gMaster "IBVREF_right11" '(28.0 25.1875) "R90")
schCreateWire(cv "route" "full" '((27.125 24.938) (26.375 24.938)) 0 0 0 nil nil)
schCreateWireLabel(cv nil '(26.875 24.938) "AVSS" "lowerRight" "R0" "stick" 0.0625 nil)
schCreateWire(cv "route" "full" '((27.125 25.312) (26.375 25.312)) 0 0 0 nil nil)
schCreateWireLabel(cv nil '(26.875 25.312) "VSS" "lowerRight" "R0" "stick" 0.0625 nil)
schCreateWire(cv "route" "full" '((28.000 25.000) (28.750 25.000)) 0 0 0 nil nil)
schCreateWireLabel(cv nil '(28.250 25.000) "IBVREF" "lowerLeft" "R0" "stick" 0.0625 nil)
schCreatePin(cv nil "IBVREF" "inputOutput" nil '(28.750 25.000) "R180")
schCreateWire(cv "route" "full" '((27.125 24.562) (26.375 24.562)) 0 0 0 nil nil)
schCreateWireLabel(cv nil '(26.875 24.562) "AVDD" "lowerRight" "R0" "stick" 0.0625 nil)
dbCreateInst(cv pvdd1ac_v_gMaster "CBVDD_top0" '(24.8125 28.0) "R180")
schCreateWire(cv "route" "full" '((25.062 27.125) (25.062 26.375)) 0 0 0 nil nil)
schCreateWireLabel(cv nil '(25.062 26.875) "AVSS" "lowerRight" "R90" "stick" 0.0625 nil)
schCreateWire(cv "route" "full" '((24.688 27.125) (24.688 26.375)) 0 0 0 nil nil)
schCreateWireLabel(cv nil '(24.688 26.875) "VSS" "lowerRight" "R90" "stick" 0.0625 nil)
schCreateWire(cv "route" "full" '((25.000 28.000) (25.000 28.750)) 0 0 0 nil nil)
schCreateWireLabel(cv nil '(25.000 28.250) "CBVDD" "lowerLeft" "R90" "stick" 0.0625 nil)
schCreatePin(cv nil "CBVDD" "inputOutput" nil '(25.000 28.750) "R270")
schCreateWire(cv "route" "full" '((25.438 27.125) (25.438 26.375)) 0 0 0 nil nil)
schCreateWireLabel(cv nil '(25.438 26.875) "AVDD" "lowerRight" "R90" "stick" 0.0625 nil)
dbCreateInst(cv pvss3ac_v_gMaster "CKVSS_top1" '(22.8125 28.0) "R180")
schCreateWire(cv "route" "full" '((23.000 28.000) (23.000 28.750)) 0 0 0 nil nil)
schCreateWireLabel(cv nil '(23.000 28.250) "CKVSS" "lowerLeft" "R90" "stick" 0.0625 nil)
schCreatePin(cv nil "CKVSS" "inputOutput" nil '(23.000 28.750) "R270")
schCreateWire(cv "route" "full" '((22.688 27.125) (22.688 26.375)) 0 0 0 nil nil)
schCreateWireLabel(cv nil '(22.688 26.875) "VSS" "lowerRight" "R90" "stick" 0.0625 nil)
schCreateWire(cv "route" "full" '((23.438 27.125) (23.438 26.375)) 0 0 0 nil nil)
schCreateWireLabel(cv nil '(23.438 26.875) "CKVSS_CORE" "lowerRight" "R90" "stick" 0.0625 nil)
schCreatePin(cv nil "CKVSS_CORE" "inputOutput" nil '(23.438 26.375) "R90")
schCreateWire(cv "route" "full" '((23.062 27.125) (23.062 26.375)) 0 0 0 nil nil)
schCreateWireLabel(cv nil '(23.062 26.875) "CKVDD" "lowerRight" "R90" "stick" 0.0625 nil)
dbCreateInst(cv pdb3ac_v_gMaster "CLKINN_top2" '(20.8125 28.0) "R180")
schCreateWire(cv "route" "full" '((21.000 28.000) (21.000 28.750)) 0 0 0 nil nil)
schCreateWireLabel(cv nil '(21.000 28.250) "CLKINN" "lowerLeft" "R90" "stick" 0.0625 nil)
schCreatePin(cv nil "CLKINN" "inputOutput" nil '(21.000 28.750) "R270")
schCreateWire(cv "route" "full" '((21.062 27.125) (21.062 26.375)) 0 0 0 nil nil)
schCreateWireLabel(cv nil '(21.062 26.875) "CKVSS" "lowerRight" "R90" "stick" 0.0625 nil)
schCreateWire(cv "route" "full" '((20.688 27.125) (20.688 26.375)) 0 0 0 nil nil)
schCreateWireLabel(cv nil '(20.688 26.875) "VSS" "lowerRight" "R90" "stick" 0.0625 nil)
schCreateWire(cv "route" "full" '((21.438 27.125) (21.438 26.375)) 0 0 0 nil nil)
schCreateWireLabel(cv nil '(21.438 26.875) "CKVDD" "lowerRight" "R90" "stick" 0.0625 nil)
dbCreateInst(cv pdb3ac_v_gMaster "CLKINP_top3" '(18.8125 28.0) "R180")
schCreateWire(cv "route" "full" '((19.000 28.000) (19.000 28.750)) 0 0 0 nil nil)
schCreateWireLabel(cv nil '(19.000 28.250) "CLKINP" "lowerLeft" "R90" "stick" 0.0625 nil)
schCreatePin(cv nil "CLKINP" "inputOutput" nil '(19.000 28.750) "R270")
schCreateWire(cv "route" "full" '((19.062 27.125) (19.062 26.375)) 0 0 0 nil nil)
schCreateWireLabel(cv nil '(19.062 26.875) "CKVSS" "lowerRight" "R90" "stick" 0.0625 nil)
schCreateWire(cv "route" "full" '((18.688 27.125) (18.688 26.375)) 0 0 0 nil nil)
schCreateWireLabel(cv nil '(18.688 26.875) "VSS" "lowerRight" "R90" "stick" 0.0625 nil)
schCreateWire(cv "route" "full" '((19.438 27.125) (19.438 26.375)) 0 0 0 nil nil)
schCreateWireLabel(cv nil '(19.438 26.875) "CKVDD" "lowerRight" "R90" "stick" 0.0625 nil)
dbCreateInst(cv pvdd3ac_v_gMaster "CKVDD_top4" '(16.8125 28.0) "R180")
schCreateWire(cv "route" "full" '((17.438 27.125) (17.438 26.375)) 0 0 0 nil nil)
schCreateWireLabel(cv nil '(17.438 26.875) "CKVDD_CORE" "lowerRight" "R90" "stick" 0.0625 nil)
schCreatePin(cv nil "CKVDD_CORE" "inputOutput" nil '(17.438 26.375) "R90")
schCreateWire(cv "route" "full" '((17.062 27.125) (17.062 26.375)) 0 0 0 nil nil)
schCreateWireLabel(cv nil '(17.062 26.875) "CKVSS" "lowerRight" "R90" "stick" 0.0625 nil)
schCreateWire(cv "route" "full" '((16.688 27.125) (16.688 26.375)) 0 0 0 nil nil)
schCreateWireLabel(cv nil '(16.688 26.875) "VSS" "lowerRight" "R90" "stick" 0.0625 nil)
schCreateWire(cv "route" "full" '((17.000 28.000) (17.000 28.750)) 0 0 0 nil nil)
schCreateWireLabel(cv nil '(17.000 28.250) "CKVDD" "lowerLeft" "R90" "stick" 0.0625 nil)
schCreatePin(cv nil "CKVDD" "inputOutput" nil '(17.000 28.750) "R270")
dbCreateInst(cv pvss3ac_v_gMaster "RVSS_top5" '(14.8125 28.0) "R180")
schCreateWire(cv "route" "full" '((15.001 28.000) (15.001 28.750)) 0 0 0 nil nil)
schCreateWireLabel(cv nil '(15.001 28.250) "RVSS" "lowerLeft" "R90" "stick" 0.0625 nil)
schCreatePin(cv nil "RVSS" "inputOutput" nil '(15.001 28.750) "R270")
schCreateWire(cv "route" "full" '((14.688 27.125) (14.688 26.375)) 0 0 0 nil nil)
schCreateWireLabel(cv nil '(14.688 26.875) "VSS" "lowerRight" "R90" "stick" 0.0625 nil)
schCreateWire(cv "route" "full" '((15.438 27.125) (15.438 26.375)) 0 0 0 nil nil)
schCreateWireLabel(cv nil '(15.438 26.875) "RVSS_CORE" "lowerRight" "R90" "stick" 0.0625 nil)
schCreatePin(cv nil "RVSS_CORE" "inputOutput" nil '(15.438 26.375) "R90")
schCreateWire(cv "route" "full" '((15.062 27.125) (15.062 26.375)) 0 0 0 nil nil)
schCreateWireLabel(cv nil '(15.062 26.875) "RVDD" "lowerRight" "R90" "stick" 0.0625 nil)
dbCreateInst(cv pdb3ac_v_gMaster "REFIN_top6" '(12.8125 28.0) "R180")
schCreateWire(cv "route" "full" '((13.001 28.000) (13.001 28.750)) 0 0 0 nil nil)
schCreateWireLabel(cv nil '(13.001 28.250) "REFIN" "lowerLeft" "R90" "stick" 0.0625 nil)
schCreatePin(cv nil "REFIN" "inputOutput" nil '(13.001 28.750) "R270")
schCreateWire(cv "route" "full" '((13.062 27.125) (13.062 26.375)) 0 0 0 nil nil)
schCreateWireLabel(cv nil '(13.062 26.875) "RVSS" "lowerRight" "R90" "stick" 0.0625 nil)
schCreateWire(cv "route" "full" '((12.688 27.125) (12.688 26.375)) 0 0 0 nil nil)
schCreateWireLabel(cv nil '(12.688 26.875) "VSS" "lowerRight" "R90" "stick" 0.0625 nil)
schCreateWire(cv "route" "full" '((13.438 27.125) (13.438 26.375)) 0 0 0 nil nil)
schCreateWireLabel(cv nil '(13.438 26.875) "RVDD" "lowerRight" "R90" "stick" 0.0625 nil)
dbCreateInst(cv pdb3ac_v_gMaster "IBIAS_REF_top7" '(10.8125 28.0) "R180")
schCreateWire(cv "route" "full" '((11.001 28.000) (11.001 28.750)) 0 0 0 nil nil)
schCreateWireLabel(cv nil '(11.001 28.250) "IBIAS_REF" "lowerLeft" "R90" "stick" 0.0625 nil)
schCreatePin(cv nil "IBIAS_REF" "inputOutput" nil '(11.001 28.750) "R270")
schCreateWire(cv "route" "full" '((11.062 27.125) (11.062 26.375)) 0 0 0 nil nil)
schCreateWireLabel(cv nil '(11.062 26.875) "RVSS" "lowerRight" "R90" "stick" 0.0625 nil)
schCreateWire(cv "route" "full" '((10.688 27.125) (10.688 26.375)) 0 0 0 nil nil)
schCreateWireLabel(cv nil '(10.688 26.875) "VSS" "lowerRight" "R90" "stick" 0.0625 nil)
schCreateWire(cv "route" "full" '((11.438 27.125) (11.438 26.375)) 0 0 0 nil nil)
schCreateWireLabel(cv nil '(11.438 26.875) "RVDD" "lowerRight" "R90" "stick" 0.0625 nil)
dbCreateInst(cv pvdd3ac_v_gMaster "RVDD_top8" '(8.8125 28.0) "R180")
schCreateWire(cv "route" "full" '((9.438 27.125) (9.438 26.375)) 0 0 0 nil nil)
schCreateWireLabel(cv nil '(9.438 26.875) "RVDD_CORE" "lowerRight" "R90" "stick" 0.0625 nil)
schCreatePin(cv nil "RVDD_CORE" "inputOutput" nil '(9.438 26.375) "R90")
schCreateWire(cv "route" "full" '((9.062 27.125) (9.062 26.375)) 0 0 0 nil nil)
schCreateWireLabel(cv nil '(9.062 26.875) "RVSS" "lowerRight" "R90" "stick" 0.0625 nil)
schCreateWire(cv "route" "full" '((8.688 27.125) (8.688 26.375)) 0 0 0 nil nil)
schCreateWireLabel(cv nil '(8.688 26.875) "VSS" "lowerRight" "R90" "stick" 0.0625 nil)
schCreateWire(cv "route" "full" '((9.001 28.000) (9.001 28.750)) 0 0 0 nil nil)
schCreateWireLabel(cv nil '(9.001 28.250) "RVDD" "lowerLeft" "R90" "stick" 0.0625 nil)
schCreatePin(cv nil "RVDD" "inputOutput" nil '(9.001 28.750) "R270")
dbCreateInst(cv pvdd1ac_v_gMaster "RVDDH_top9" '(6.8125 28.0) "R180")
schCreateWire(cv "route" "full" '((7.062 27.125) (7.062 26.375)) 0 0 0 nil nil)
schCreateWireLabel(cv nil '(7.062 26.875) "RVSS" "lowerRight" "R90" "stick" 0.0625 nil)
schCreateWire(cv "route" "full" '((6.688 27.125) (6.688 26.375)) 0 0 0 nil nil)
schCreateWireLabel(cv nil '(6.688 26.875) "VSS" "lowerRight" "R90" "stick" 0.0625 nil)
schCreateWire(cv "route" "full" '((7.000 28.000) (7.000 28.750)) 0 0 0 nil nil)
schCreateWireLabel(cv nil '(7.000 28.250) "RVDDH" "lowerLeft" "R90" "stick" 0.0625 nil)
schCreatePin(cv nil "RVDDH" "inputOutput" nil '(7.000 28.750) "R270")
schCreateWire(cv "route" "full" '((7.438 27.125) (7.438 26.375)) 0 0 0 nil nil)
schCreateWireLabel(cv nil '(7.438 26.875) "RVDD" "lowerRight" "R90" "stick" 0.0625 nil)
dbCreateInst(cv pdb3ac_v_gMaster "IBIAS_top10" '(4.8125 28.0) "R180")
schCreateWire(cv "route" "full" '((5.000 28.000) (5.000 28.750)) 0 0 0 nil nil)
schCreateWireLabel(cv nil '(5.000 28.250) "IBIAS" "lowerLeft" "R90" "stick" 0.0625 nil)
schCreatePin(cv nil "IBIAS" "inputOutput" nil '(5.000 28.750) "R270")
schCreateWire(cv "route" "full" '((5.062 27.125) (5.062 26.375)) 0 0 0 nil nil)
schCreateWireLabel(cv nil '(5.062 26.875) "RVSS" "lowerRight" "R90" "stick" 0.0625 nil)
schCreateWire(cv "route" "full" '((4.688 27.125) (4.688 26.375)) 0 0 0 nil nil)
schCreateWireLabel(cv nil '(4.688 26.875) "VSS" "lowerRight" "R90" "stick" 0.0625 nil)
schCreateWire(cv "route" "full" '((5.438 27.125) (5.438 26.375)) 0 0 0 nil nil)
schCreateWireLabel(cv nil '(5.438 26.875) "RVDD" "lowerRight" "R90" "stick" 0.0625 nil)
dbCreateInst(cv pdb3ac_v_gMaster "IBIAS2_top11" '(2.8125 28.0) "R180")
schCreateWire(cv "route" "full" '((3.001 28.000) (3.001 28.750)) 0 0 0 nil nil)
schCreateWireLabel(cv nil '(3.001 28.250) "IBIAS2" "lowerLeft" "R90" "stick" 0.0625 nil)
schCreatePin(cv nil "IBIAS2" "inputOutput" nil '(3.001 28.750) "R270")
schCreateWire(cv "route" "full" '((3.062 27.125) (3.062 26.375)) 0 0 0 nil nil)
schCreateWireLabel(cv nil '(3.062 26.875) "RVSS" "lowerRight" "R90" "stick" 0.0625 nil)
schCreateWire(cv "route" "full" '((2.688 27.125) (2.688 26.375)) 0 0 0 nil nil)
schCreateWireLabel(cv nil '(2.688 26.875) "VSS" "lowerRight" "R90" "stick" 0.0625 nil)
schCreateWire(cv "route" "full" '((3.438 27.125) (3.438 26.375)) 0 0 0 nil nil)
schCreateWireLabel(cv nil '(3.438 26.875) "RVDD" "lowerRight" "R90" "stick" 0.0625 nil)
schCheck(cv)
dbSave(cv)
t
