pddw16sdgz_h_gMaster = dbOpenCellView("tphn28hpcpgv18" "PDDW16SDGZ_H_G" "symbol")
dbCreateInst(cv pddw16sdgz_h_gMaster "D0_left0" '(0 17.6875) "R270")
schCreateWire(cv "route" "full" '((1.000 17.562) (1.750 17.562)) 0 0 0 nil nil)
schCreateWireLabel(cv nil '(1.250 17.562) "VIOL" "lowerLeft" "R0" "stick" 0.0625 nil)
noConnMaster = dbOpenCellView("basic" "noConn" "symbol")
schCreateWire(cv "route" "full" '((1.000 17.438) (1.750 17.438)) 0 0 0 nil nil)
dbCreateInst(cv noConnMaster "noConn_D0_left0_C" '(1.750 17.438) "R90")
schCreateWire(cv "route" "full" '((1.000 17.812) (1.750 17.812)) 0 0 0 nil nil)
schCreateWireLabel(cv nil '(1.250 17.812) "GIOL" "lowerLeft" "R0" "stick" 0.0625 nil)
schCreateWire(cv "route" "full" '((1.000 17.938) (1.750 17.938)) 0 0 0 nil nil)
schCreateWireLabel(cv nil '(1.250 17.938) "D0_CORE" "lowerLeft" "R0" "stick" 0.0625 nil)
schCreatePin(cv nil "D0_CORE" "inputOutput" nil '(1.750 17.938) "R180")
schCreateWire(cv "route" "full" '((0.000 17.000) (-0.750 17.000)) 0 0 0 nil nil)
schCreateWireLabel(cv nil '(-0.250 17.000) "D0" "lowerRight" "R0" "stick" 0.0625 nil)
schCreatePin(cv nil "D0" "inputOutput" nil '(-0.750 17.000) "R0")
schCreateWire(cv "route" "full" '((1.000 17.312) (1.750 17.312)) 0 0 0 nil nil)
schCreateWireLabel(cv nil '(1.250 17.312) "POC" "lowerLeft" "R0" "stick" 0.0625 nil)
schCreateWire(cv "route" "full" '((1.000 17.125) (1.750 17.125)) 0 0 0 nil nil)
schCreateWireLabel(cv nil '(1.250 17.125) "VIOL" "lowerLeft" "R0" "stick" 0.0625 nil)
schCreateWire(cv "route" "full" '((1.000 16.938) (1.750 16.938)) 0 0 0 nil nil)
schCreateWireLabel(cv nil '(1.250 16.938) "GIOL" "lowerLeft" "R0" "stick" 0.0625 nil)
schCreateWire(cv "route" "full" '((1.000 16.750) (1.750 16.750)) 0 0 0 nil nil)
schCreateWireLabel(cv nil '(1.250 16.750) "VIOH" "lowerLeft" "R0" "stick" 0.0625 nil)
schCreateWire(cv "route" "full" '((1.000 16.375) (1.750 16.375)) 0 0 0 nil nil)
schCreateWireLabel(cv nil '(1.250 16.375) "GIOH" "lowerLeft" "R0" "stick" 0.0625 nil)
dbCreateInst(cv pddw16sdgz_h_gMaster "D1_left1" '(0 15.6875) "R270")
schCreateWire(cv "route" "full" '((1.000 15.562) (1.750 15.562)) 0 0 0 nil nil)
schCreateWireLabel(cv nil '(1.250 15.562) "VIOL" "lowerLeft" "R0" "stick" 0.0625 nil)
schCreateWire(cv "route" "full" '((1.000 15.438) (1.750 15.438)) 0 0 0 nil nil)
dbCreateInst(cv noConnMaster "noConn_D1_left1_C" '(1.750 15.438) "R90")
schCreateWire(cv "route" "full" '((1.000 15.812) (1.750 15.812)) 0 0 0 nil nil)
schCreateWireLabel(cv nil '(1.250 15.812) "GIOL" "lowerLeft" "R0" "stick" 0.0625 nil)
schCreateWire(cv "route" "full" '((1.000 15.938) (1.750 15.938)) 0 0 0 nil nil)
schCreateWireLabel(cv nil '(1.250 15.938) "D1_CORE" "lowerLeft" "R0" "stick" 0.0625 nil)
schCreatePin(cv nil "D1_CORE" "inputOutput" nil '(1.750 15.938) "R180")
schCreateWire(cv "route" "full" '((0.000 14.999) (-0.750 14.999)) 0 0 0 nil nil)
schCreateWireLabel(cv nil '(-0.250 14.999) "D1" "lowerRight" "R0" "stick" 0.0625 nil)
schCreatePin(cv nil "D1" "inputOutput" nil '(-0.750 14.999) "R0")
schCreateWire(cv "route" "full" '((1.000 15.312) (1.750 15.312)) 0 0 0 nil nil)
schCreateWireLabel(cv nil '(1.250 15.312) "POC" "lowerLeft" "R0" "stick" 0.0625 nil)
schCreateWire(cv "route" "full" '((1.000 15.126) (1.750 15.126)) 0 0 0 nil nil)
schCreateWireLabel(cv nil '(1.250 15.126) "VIOL" "lowerLeft" "R0" "stick" 0.0625 nil)
schCreateWire(cv "route" "full" '((1.000 14.938) (1.750 14.938)) 0 0 0 nil nil)
schCreateWireLabel(cv nil '(1.250 14.938) "GIOL" "lowerLeft" "R0" "stick" 0.0625 nil)
schCreateWire(cv "route" "full" '((1.000 14.749) (1.750 14.749)) 0 0 0 nil nil)
schCreateWireLabel(cv nil '(1.250 14.749) "VIOH" "lowerLeft" "R0" "stick" 0.0625 nil)
schCreateWire(cv "route" "full" '((1.000 14.376) (1.750 14.376)) 0 0 0 nil nil)
schCreateWireLabel(cv nil '(1.250 14.376) "GIOH" "lowerLeft" "R0" "stick" 0.0625 nil)
dbCreateInst(cv pddw16sdgz_h_gMaster "D2_left2" '(0 13.6875) "R270")
schCreateWire(cv "route" "full" '((1.000 13.562) (1.750 13.562)) 0 0 0 nil nil)
schCreateWireLabel(cv nil '(1.250 13.562) "VIOL" "lowerLeft" "R0" "stick" 0.0625 nil)
schCreateWire(cv "route" "full" '((1.000 13.438) (1.750 13.438)) 0 0 0 nil nil)
dbCreateInst(cv noConnMaster "noConn_D2_left2_C" '(1.750 13.438) "R90")
schCreateWire(cv "route" "full" '((1.000 13.812) (1.750 13.812)) 0 0 0 nil nil)
schCreateWireLabel(cv nil '(1.250 13.812) "GIOL" "lowerLeft" "R0" "stick" 0.0625 nil)
schCreateWire(cv "route" "full" '((1.000 13.938) (1.750 13.938)) 0 0 0 nil nil)
schCreateWireLabel(cv nil '(1.250 13.938) "D2_CORE" "lowerLeft" "R0" "stick" 0.0625 nil)
schCreatePin(cv nil "D2_CORE" "inputOutput" nil '(1.750 13.938) "R180")
schCreateWire(cv "route" "full" '((0.000 12.999) (-0.750 12.999)) 0 0 0 nil nil)
schCreateWireLabel(cv nil '(-0.250 12.999) "D2" "lowerRight" "R0" "stick" 0.0625 nil)
schCreatePin(cv nil "D2" "inputOutput" nil '(-0.750 12.999) "R0")
schCreateWire(cv "route" "full" '((1.000 13.312) (1.750 13.312)) 0 0 0 nil nil)
schCreateWireLabel(cv nil '(1.250 13.312) "POC" "lowerLeft" "R0" "stick" 0.0625 nil)
schCreateWire(cv "route" "full" '((1.000 13.126) (1.750 13.126)) 0 0 0 nil nil)
schCreateWireLabel(cv nil '(1.250 13.126) "VIOL" "lowerLeft" "R0" "stick" 0.0625 nil)
schCreateWire(cv "route" "full" '((1.000 12.938) (1.750 12.938)) 0 0 0 nil nil)
schCreateWireLabel(cv nil '(1.250 12.938) "GIOL" "lowerLeft" "R0" "stick" 0.0625 nil)
schCreateWire(cv "route" "full" '((1.000 12.749) (1.750 12.749)) 0 0 0 nil nil)
schCreateWireLabel(cv nil '(1.250 12.749) "VIOH" "lowerLeft" "R0" "stick" 0.0625 nil)
schCreateWire(cv "route" "full" '((1.000 12.376) (1.750 12.376)) 0 0 0 nil nil)
schCreateWireLabel(cv nil '(1.250 12.376) "GIOH" "lowerLeft" "R0" "stick" 0.0625 nil)
dbCreateInst(cv pddw16sdgz_h_gMaster "D3_left3" '(0 11.6875) "R270")
schCreateWire(cv "route" "full" '((1.000 11.562) (1.750 11.562)) 0 0 0 nil nil)
schCreateWireLabel(cv nil '(1.250 11.562) "VIOL" "lowerLeft" "R0" "stick" 0.0625 nil)
schCreateWire(cv "route" "full" '((1.000 11.438) (1.750 11.438)) 0 0 0 nil nil)
dbCreateInst(cv noConnMaster "noConn_D3_left3_C" '(1.750 11.438) "R90")
schCreateWire(cv "route" "full" '((1.000 11.812) (1.750 11.812)) 0 0 0 nil nil)
schCreateWireLabel(cv nil '(1.250 11.812) "GIOL" "lowerLeft" "R0" "stick" 0.0625 nil)
schCreateWire(cv "route" "full" '((1.000 11.938) (1.750 11.938)) 0 0 0 nil nil)
schCreateWireLabel(cv nil '(1.250 11.938) "D3_CORE" "lowerLeft" "R0" "stick" 0.0625 nil)
schCreatePin(cv nil "D3_CORE" "inputOutput" nil '(1.750 11.938) "R180")
schCreateWire(cv "route" "full" '((0.000 10.999) (-0.750 10.999)) 0 0 0 nil nil)
schCreateWireLabel(cv nil '(-0.250 10.999) "D3" "lowerRight" "R0" "stick" 0.0625 nil)
schCreatePin(cv nil "D3" "inputOutput" nil '(-0.750 10.999) "R0")
schCreateWire(cv "route" "full" '((1.000 11.312) (1.750 11.312)) 0 0 0 nil nil)
schCreateWireLabel(cv nil '(1.250 11.312) "POC" "lowerLeft" "R0" "stick" 0.0625 nil)
schCreateWire(cv "route" "full" '((1.000 11.126) (1.750 11.126)) 0 0 0 nil nil)
schCreateWireLabel(cv nil '(1.250 11.126) "VIOL" "lowerLeft" "R0" "stick" 0.0625 nil)
schCreateWire(cv "route" "full" '((1.000 10.938) (1.750 10.938)) 0 0 0 nil nil)
schCreateWireLabel(cv nil '(1.250 10.938) "GIOL" "lowerLeft" "R0" "stick" 0.0625 nil)
schCreateWire(cv "route" "full" '((1.000 10.749) (1.750 10.749)) 0 0 0 nil nil)
schCreateWireLabel(cv nil '(1.250 10.749) "VIOH" "lowerLeft" "R0" "stick" 0.0625 nil)
schCreateWire(cv "route" "full" '((1.000 10.376) (1.750 10.376)) 0 0 0 nil nil)
schCreateWireLabel(cv nil '(1.250 10.376) "GIOH" "lowerLeft" "R0" "stick" 0.0625 nil)
dbCreateInst(cv pddw16sdgz_h_gMaster "D4_left4" '(0 9.6875) "R270")
schCreateWire(cv "route" "full" '((1.000 9.562) (1.750 9.562)) 0 0 0 nil nil)
schCreateWireLabel(cv nil '(1.250 9.562) "VIOL" "lowerLeft" "R0" "stick" 0.0625 nil)
schCreateWire(cv "route" "full" '((1.000 9.438) (1.750 9.438)) 0 0 0 nil nil)
dbCreateInst(cv noConnMaster "noConn_D4_left4_C" '(1.750 9.438) "R90")
schCreateWire(cv "route" "full" '((1.000 9.812) (1.750 9.812)) 0 0 0 nil nil)
schCreateWireLabel(cv nil '(1.250 9.812) "GIOL" "lowerLeft" "R0" "stick" 0.0625 nil)
schCreateWire(cv "route" "full" '((1.000 9.938) (1.750 9.938)) 0 0 0 nil nil)
schCreateWireLabel(cv nil '(1.250 9.938) "D4_CORE" "lowerLeft" "R0" "stick" 0.0625 nil)
schCreatePin(cv nil "D4_CORE" "inputOutput" nil '(1.750 9.938) "R180")
schCreateWire(cv "route" "full" '((0.000 8.999) (-0.750 8.999)) 0 0 0 nil nil)
schCreateWireLabel(cv nil '(-0.250 8.999) "D4" "lowerRight" "R0" "stick" 0.0625 nil)
schCreatePin(cv nil "D4" "inputOutput" nil '(-0.750 8.999) "R0")
schCreateWire(cv "route" "full" '((1.000 9.312) (1.750 9.312)) 0 0 0 nil nil)
schCreateWireLabel(cv nil '(1.250 9.312) "POC" "lowerLeft" "R0" "stick" 0.0625 nil)
schCreateWire(cv "route" "full" '((1.000 9.126) (1.750 9.126)) 0 0 0 nil nil)
schCreateWireLabel(cv nil '(1.250 9.126) "VIOL" "lowerLeft" "R0" "stick" 0.0625 nil)
schCreateWire(cv "route" "full" '((1.000 8.938) (1.750 8.938)) 0 0 0 nil nil)
schCreateWireLabel(cv nil '(1.250 8.938) "GIOL" "lowerLeft" "R0" "stick" 0.0625 nil)
schCreateWire(cv "route" "full" '((1.000 8.749) (1.750 8.749)) 0 0 0 nil nil)
schCreateWireLabel(cv nil '(1.250 8.749) "VIOH" "lowerLeft" "R0" "stick" 0.0625 nil)
schCreateWire(cv "route" "full" '((1.000 8.376) (1.750 8.376)) 0 0 0 nil nil)
schCreateWireLabel(cv nil '(1.250 8.376) "GIOH" "lowerLeft" "R0" "stick" 0.0625 nil)
dbCreateInst(cv pddw16sdgz_h_gMaster "D5_left5" '(0 7.6875) "R270")
schCreateWire(cv "route" "full" '((1.000 7.562) (1.750 7.562)) 0 0 0 nil nil)
schCreateWireLabel(cv nil '(1.250 7.562) "VIOL" "lowerLeft" "R0" "stick" 0.0625 nil)
schCreateWire(cv "route" "full" '((1.000 7.438) (1.750 7.438)) 0 0 0 nil nil)
dbCreateInst(cv noConnMaster "noConn_D5_left5_C" '(1.750 7.438) "R90")
schCreateWire(cv "route" "full" '((1.000 7.812) (1.750 7.812)) 0 0 0 nil nil)
schCreateWireLabel(cv nil '(1.250 7.812) "GIOL" "lowerLeft" "R0" "stick" 0.0625 nil)
schCreateWire(cv "route" "full" '((1.000 7.938) (1.750 7.938)) 0 0 0 nil nil)
schCreateWireLabel(cv nil '(1.250 7.938) "D5_CORE" "lowerLeft" "R0" "stick" 0.0625 nil)
schCreatePin(cv nil "D5_CORE" "inputOutput" nil '(1.750 7.938) "R180")
schCreateWire(cv "route" "full" '((0.000 7.000) (-0.750 7.000)) 0 0 0 nil nil)
schCreateWireLabel(cv nil '(-0.250 7.000) "D5" "lowerRight" "R0" "stick" 0.0625 nil)
schCreatePin(cv nil "D5" "inputOutput" nil '(-0.750 7.000) "R0")
schCreateWire(cv "route" "full" '((1.000 7.312) (1.750 7.312)) 0 0 0 nil nil)
schCreateWireLabel(cv nil '(1.250 7.312) "POC" "lowerLeft" "R0" "stick" 0.0625 nil)
schCreateWire(cv "route" "full" '((1.000 7.125) (1.750 7.125)) 0 0 0 nil nil)
schCreateWireLabel(cv nil '(1.250 7.125) "VIOL" "lowerLeft" "R0" "stick" 0.0625 nil)
schCreateWire(cv "route" "full" '((1.000 6.938) (1.750 6.938)) 0 0 0 nil nil)
schCreateWireLabel(cv nil '(1.250 6.938) "GIOL" "lowerLeft" "R0" "stick" 0.0625 nil)
schCreateWire(cv "route" "full" '((1.000 6.750) (1.750 6.750)) 0 0 0 nil nil)
schCreateWireLabel(cv nil '(1.250 6.750) "VIOH" "lowerLeft" "R0" "stick" 0.0625 nil)
schCreateWire(cv "route" "full" '((1.000 6.375) (1.750 6.375)) 0 0 0 nil nil)
schCreateWireLabel(cv nil '(1.250 6.375) "GIOH" "lowerLeft" "R0" "stick" 0.0625 nil)
dbCreateInst(cv pddw16sdgz_h_gMaster "D6_left6" '(0 5.6875) "R270")
schCreateWire(cv "route" "full" '((1.000 5.562) (1.750 5.562)) 0 0 0 nil nil)
schCreateWireLabel(cv nil '(1.250 5.562) "VIOL" "lowerLeft" "R0" "stick" 0.0625 nil)
schCreateWire(cv "route" "full" '((1.000 5.438) (1.750 5.438)) 0 0 0 nil nil)
dbCreateInst(cv noConnMaster "noConn_D6_left6_C" '(1.750 5.438) "R90")
schCreateWire(cv "route" "full" '((1.000 5.812) (1.750 5.812)) 0 0 0 nil nil)
schCreateWireLabel(cv nil '(1.250 5.812) "GIOL" "lowerLeft" "R0" "stick" 0.0625 nil)
schCreateWire(cv "route" "full" '((1.000 5.938) (1.750 5.938)) 0 0 0 nil nil)
schCreateWireLabel(cv nil '(1.250 5.938) "D6_CORE" "lowerLeft" "R0" "stick" 0.0625 nil)
schCreatePin(cv nil "D6_CORE" "inputOutput" nil '(1.750 5.938) "R180")
schCreateWire(cv "route" "full" '((0.000 5.000) (-0.750 5.000)) 0 0 0 nil nil)
schCreateWireLabel(cv nil '(-0.250 5.000) "D6" "lowerRight" "R0" "stick" 0.0625 nil)
schCreatePin(cv nil "D6" "inputOutput" nil '(-0.750 5.000) "R0")
schCreateWire(cv "route" "full" '((1.000 5.312) (1.750 5.312)) 0 0 0 nil nil)
schCreateWireLabel(cv nil '(1.250 5.312) "POC" "lowerLeft" "R0" "stick" 0.0625 nil)
schCreateWire(cv "route" "full" '((1.000 5.125) (1.750 5.125)) 0 0 0 nil nil)
schCreateWireLabel(cv nil '(1.250 5.125) "VIOL" "lowerLeft" "R0" "stick" 0.0625 nil)
schCreateWire(cv "route" "full" '((1.000 4.938) (1.750 4.938)) 0 0 0 nil nil)
schCreateWireLabel(cv nil '(1.250 4.938) "GIOL" "lowerLeft" "R0" "stick" 0.0625 nil)
schCreateWire(cv "route" "full" '((1.000 4.750) (1.750 4.750)) 0 0 0 nil nil)
schCreateWireLabel(cv nil '(1.250 4.750) "VIOH" "lowerLeft" "R0" "stick" 0.0625 nil)
schCreateWire(cv "route" "full" '((1.000 4.375) (1.750 4.375)) 0 0 0 nil nil)
schCreateWireLabel(cv nil '(1.250 4.375) "GIOH" "lowerLeft" "R0" "stick" 0.0625 nil)
dbCreateInst(cv pddw16sdgz_h_gMaster "D7_left7" '(0 3.6875) "R270")
schCreateWire(cv "route" "full" '((1.000 3.562) (1.750 3.562)) 0 0 0 nil nil)
schCreateWireLabel(cv nil '(1.250 3.562) "VIOL" "lowerLeft" "R0" "stick" 0.0625 nil)
schCreateWire(cv "route" "full" '((1.000 3.438) (1.750 3.438)) 0 0 0 nil nil)
dbCreateInst(cv noConnMaster "noConn_D7_left7_C" '(1.750 3.438) "R90")
schCreateWire(cv "route" "full" '((1.000 3.812) (1.750 3.812)) 0 0 0 nil nil)
schCreateWireLabel(cv nil '(1.250 3.812) "GIOL" "lowerLeft" "R0" "stick" 0.0625 nil)
schCreateWire(cv "route" "full" '((1.000 3.938) (1.750 3.938)) 0 0 0 nil nil)
schCreateWireLabel(cv nil '(1.250 3.938) "D7_CORE" "lowerLeft" "R0" "stick" 0.0625 nil)
schCreatePin(cv nil "D7_CORE" "inputOutput" nil '(1.750 3.938) "R180")
schCreateWire(cv "route" "full" '((0.000 3.000) (-0.750 3.000)) 0 0 0 nil nil)
schCreateWireLabel(cv nil '(-0.250 3.000) "D7" "lowerRight" "R0" "stick" 0.0625 nil)
schCreatePin(cv nil "D7" "inputOutput" nil '(-0.750 3.000) "R0")
schCreateWire(cv "route" "full" '((1.000 3.312) (1.750 3.312)) 0 0 0 nil nil)
schCreateWireLabel(cv nil '(1.250 3.312) "POC" "lowerLeft" "R0" "stick" 0.0625 nil)
schCreateWire(cv "route" "full" '((1.000 3.125) (1.750 3.125)) 0 0 0 nil nil)
schCreateWireLabel(cv nil '(1.250 3.125) "VIOL" "lowerLeft" "R0" "stick" 0.0625 nil)
schCreateWire(cv "route" "full" '((1.000 2.938) (1.750 2.938)) 0 0 0 nil nil)
schCreateWireLabel(cv nil '(1.250 2.938) "GIOL" "lowerLeft" "R0" "stick" 0.0625 nil)
schCreateWire(cv "route" "full" '((1.000 2.750) (1.750 2.750)) 0 0 0 nil nil)
schCreateWireLabel(cv nil '(1.250 2.750) "VIOH" "lowerLeft" "R0" "stick" 0.0625 nil)
schCreateWire(cv "route" "full" '((1.000 2.375) (1.750 2.375)) 0 0 0 nil nil)
schCreateWireLabel(cv nil '(1.250 2.375) "GIOH" "lowerLeft" "R0" "stick" 0.0625 nil)
pddw16sdgz_v_gMaster = dbOpenCellView("tphn28hpcpgv18" "PDDW16SDGZ_V_G" "symbol")
dbCreateInst(cv pddw16sdgz_v_gMaster "D8_bottom0" '(2.3125 0) "R0")
schCreateWire(cv "route" "full" '((2.438 1.000) (2.438 1.750)) 0 0 0 nil nil)
schCreateWireLabel(cv nil '(2.438 1.250) "VIOL" "lowerLeft" "R90" "stick" 0.0625 nil)
schCreateWire(cv "route" "full" '((2.562 1.000) (2.562 1.750)) 0 0 0 nil nil)
dbCreateInst(cv noConnMaster "noConn_D8_bottom0_C" '(2.562 1.750) "R180")
schCreateWire(cv "route" "full" '((2.188 1.000) (2.188 1.750)) 0 0 0 nil nil)
schCreateWireLabel(cv nil '(2.188 1.250) "GIOL" "lowerLeft" "R90" "stick" 0.0625 nil)
schCreateWire(cv "route" "full" '((2.062 1.000) (2.062 1.750)) 0 0 0 nil nil)
schCreateWireLabel(cv nil '(2.062 1.250) "D8_CORE" "lowerLeft" "R90" "stick" 0.0625 nil)
schCreatePin(cv nil "D8_CORE" "inputOutput" nil '(2.062 1.750) "R270")
schCreateWire(cv "route" "full" '((3.000 0.000) (3.000 -0.750)) 0 0 0 nil nil)
schCreateWireLabel(cv nil '(3.000 -0.250) "D8" "lowerRight" "R90" "stick" 0.0625 nil)
schCreatePin(cv nil "D8" "inputOutput" nil '(3.000 -0.750) "R90")
schCreateWire(cv "route" "full" '((2.688 1.000) (2.688 1.750)) 0 0 0 nil nil)
schCreateWireLabel(cv nil '(2.688 1.250) "POC" "lowerLeft" "R90" "stick" 0.0625 nil)
schCreateWire(cv "route" "full" '((2.875 1.000) (2.875 1.750)) 0 0 0 nil nil)
schCreateWireLabel(cv nil '(2.875 1.250) "VIOL" "lowerLeft" "R90" "stick" 0.0625 nil)
schCreateWire(cv "route" "full" '((3.062 1.000) (3.062 1.750)) 0 0 0 nil nil)
schCreateWireLabel(cv nil '(3.062 1.250) "GIOL" "lowerLeft" "R90" "stick" 0.0625 nil)
schCreateWire(cv "route" "full" '((3.250 1.000) (3.250 1.750)) 0 0 0 nil nil)
schCreateWireLabel(cv nil '(3.250 1.250) "VIOH" "lowerLeft" "R90" "stick" 0.0625 nil)
schCreateWire(cv "route" "full" '((3.625 1.000) (3.625 1.750)) 0 0 0 nil nil)
schCreateWireLabel(cv nil '(3.625 1.250) "GIOH" "lowerLeft" "R90" "stick" 0.0625 nil)
dbCreateInst(cv pddw16sdgz_v_gMaster "D9_bottom1" '(4.3125 0) "R0")
schCreateWire(cv "route" "full" '((4.438 1.000) (4.438 1.750)) 0 0 0 nil nil)
schCreateWireLabel(cv nil '(4.438 1.250) "VIOL" "lowerLeft" "R90" "stick" 0.0625 nil)
schCreateWire(cv "route" "full" '((4.562 1.000) (4.562 1.750)) 0 0 0 nil nil)
dbCreateInst(cv noConnMaster "noConn_D9_bottom1_C" '(4.562 1.750) "R180")
schCreateWire(cv "route" "full" '((4.188 1.000) (4.188 1.750)) 0 0 0 nil nil)
schCreateWireLabel(cv nil '(4.188 1.250) "GIOL" "lowerLeft" "R90" "stick" 0.0625 nil)
schCreateWire(cv "route" "full" '((4.062 1.000) (4.062 1.750)) 0 0 0 nil nil)
schCreateWireLabel(cv nil '(4.062 1.250) "D9_CORE" "lowerLeft" "R90" "stick" 0.0625 nil)
schCreatePin(cv nil "D9_CORE" "inputOutput" nil '(4.062 1.750) "R270")
schCreateWire(cv "route" "full" '((5.000 0.000) (5.000 -0.750)) 0 0 0 nil nil)
schCreateWireLabel(cv nil '(5.000 -0.250) "D9" "lowerRight" "R90" "stick" 0.0625 nil)
schCreatePin(cv nil "D9" "inputOutput" nil '(5.000 -0.750) "R90")
schCreateWire(cv "route" "full" '((4.688 1.000) (4.688 1.750)) 0 0 0 nil nil)
schCreateWireLabel(cv nil '(4.688 1.250) "POC" "lowerLeft" "R90" "stick" 0.0625 nil)
schCreateWire(cv "route" "full" '((4.875 1.000) (4.875 1.750)) 0 0 0 nil nil)
schCreateWireLabel(cv nil '(4.875 1.250) "VIOL" "lowerLeft" "R90" "stick" 0.0625 nil)
schCreateWire(cv "route" "full" '((5.062 1.000) (5.062 1.750)) 0 0 0 nil nil)
schCreateWireLabel(cv nil '(5.062 1.250) "GIOL" "lowerLeft" "R90" "stick" 0.0625 nil)
schCreateWire(cv "route" "full" '((5.250 1.000) (5.250 1.750)) 0 0 0 nil nil)
schCreateWireLabel(cv nil '(5.250 1.250) "VIOH" "lowerLeft" "R90" "stick" 0.0625 nil)
schCreateWire(cv "route" "full" '((5.625 1.000) (5.625 1.750)) 0 0 0 nil nil)
schCreateWireLabel(cv nil '(5.625 1.250) "GIOH" "lowerLeft" "R90" "stick" 0.0625 nil)
dbCreateInst(cv pddw16sdgz_v_gMaster "D10_bottom2" '(6.3125 0) "R0")
schCreateWire(cv "route" "full" '((6.438 1.000) (6.438 1.750)) 0 0 0 nil nil)
schCreateWireLabel(cv nil '(6.438 1.250) "VIOL" "lowerLeft" "R90" "stick" 0.0625 nil)
schCreateWire(cv "route" "full" '((6.562 1.000) (6.562 1.750)) 0 0 0 nil nil)
dbCreateInst(cv noConnMaster "noConn_D10_bottom2_C" '(6.562 1.750) "R180")
schCreateWire(cv "route" "full" '((6.188 1.000) (6.188 1.750)) 0 0 0 nil nil)
schCreateWireLabel(cv nil '(6.188 1.250) "GIOL" "lowerLeft" "R90" "stick" 0.0625 nil)
schCreateWire(cv "route" "full" '((6.062 1.000) (6.062 1.750)) 0 0 0 nil nil)
schCreateWireLabel(cv nil '(6.062 1.250) "D10_CORE" "lowerLeft" "R90" "stick" 0.0625 nil)
schCreatePin(cv nil "D10_CORE" "inputOutput" nil '(6.062 1.750) "R270")
schCreateWire(cv "route" "full" '((7.000 0.000) (7.000 -0.750)) 0 0 0 nil nil)
schCreateWireLabel(cv nil '(7.000 -0.250) "D10" "lowerRight" "R90" "stick" 0.0625 nil)
schCreatePin(cv nil "D10" "inputOutput" nil '(7.000 -0.750) "R90")
schCreateWire(cv "route" "full" '((6.688 1.000) (6.688 1.750)) 0 0 0 nil nil)
schCreateWireLabel(cv nil '(6.688 1.250) "POC" "lowerLeft" "R90" "stick" 0.0625 nil)
schCreateWire(cv "route" "full" '((6.875 1.000) (6.875 1.750)) 0 0 0 nil nil)
schCreateWireLabel(cv nil '(6.875 1.250) "VIOL" "lowerLeft" "R90" "stick" 0.0625 nil)
schCreateWire(cv "route" "full" '((7.062 1.000) (7.062 1.750)) 0 0 0 nil nil)
schCreateWireLabel(cv nil '(7.062 1.250) "GIOL" "lowerLeft" "R90" "stick" 0.0625 nil)
schCreateWire(cv "route" "full" '((7.250 1.000) (7.250 1.750)) 0 0 0 nil nil)
schCreateWireLabel(cv nil '(7.250 1.250) "VIOH" "lowerLeft" "R90" "stick" 0.0625 nil)
schCreateWire(cv "route" "full" '((7.625 1.000) (7.625 1.750)) 0 0 0 nil nil)
schCreateWireLabel(cv nil '(7.625 1.250) "GIOH" "lowerLeft" "R90" "stick" 0.0625 nil)
dbCreateInst(cv pddw16sdgz_v_gMaster "D11_bottom3" '(8.3125 0) "R0")
schCreateWire(cv "route" "full" '((8.438 1.000) (8.438 1.750)) 0 0 0 nil nil)
schCreateWireLabel(cv nil '(8.438 1.250) "VIOL" "lowerLeft" "R90" "stick" 0.0625 nil)
schCreateWire(cv "route" "full" '((8.562 1.000) (8.562 1.750)) 0 0 0 nil nil)
dbCreateInst(cv noConnMaster "noConn_D11_bottom3_C" '(8.562 1.750) "R180")
schCreateWire(cv "route" "full" '((8.188 1.000) (8.188 1.750)) 0 0 0 nil nil)
schCreateWireLabel(cv nil '(8.188 1.250) "GIOL" "lowerLeft" "R90" "stick" 0.0625 nil)
schCreateWire(cv "route" "full" '((8.062 1.000) (8.062 1.750)) 0 0 0 nil nil)
schCreateWireLabel(cv nil '(8.062 1.250) "D11_CORE" "lowerLeft" "R90" "stick" 0.0625 nil)
schCreatePin(cv nil "D11_CORE" "inputOutput" nil '(8.062 1.750) "R270")
schCreateWire(cv "route" "full" '((9.001 0.000) (9.001 -0.750)) 0 0 0 nil nil)
schCreateWireLabel(cv nil '(9.001 -0.250) "D11" "lowerRight" "R90" "stick" 0.0625 nil)
schCreatePin(cv nil "D11" "inputOutput" nil '(9.001 -0.750) "R90")
schCreateWire(cv "route" "full" '((8.688 1.000) (8.688 1.750)) 0 0 0 nil nil)
schCreateWireLabel(cv nil '(8.688 1.250) "POC" "lowerLeft" "R90" "stick" 0.0625 nil)
schCreateWire(cv "route" "full" '((8.874 1.000) (8.874 1.750)) 0 0 0 nil nil)
schCreateWireLabel(cv nil '(8.874 1.250) "VIOL" "lowerLeft" "R90" "stick" 0.0625 nil)
schCreateWire(cv "route" "full" '((9.062 1.000) (9.062 1.750)) 0 0 0 nil nil)
schCreateWireLabel(cv nil '(9.062 1.250) "GIOL" "lowerLeft" "R90" "stick" 0.0625 nil)
schCreateWire(cv "route" "full" '((9.251 1.000) (9.251 1.750)) 0 0 0 nil nil)
schCreateWireLabel(cv nil '(9.251 1.250) "VIOH" "lowerLeft" "R90" "stick" 0.0625 nil)
schCreateWire(cv "route" "full" '((9.624 1.000) (9.624 1.750)) 0 0 0 nil nil)
schCreateWireLabel(cv nil '(9.624 1.250) "GIOH" "lowerLeft" "R90" "stick" 0.0625 nil)
dbCreateInst(cv pddw16sdgz_v_gMaster "D12_bottom4" '(10.3125 0) "R0")
schCreateWire(cv "route" "full" '((10.438 1.000) (10.438 1.750)) 0 0 0 nil nil)
schCreateWireLabel(cv nil '(10.438 1.250) "VIOL" "lowerLeft" "R90" "stick" 0.0625 nil)
schCreateWire(cv "route" "full" '((10.562 1.000) (10.562 1.750)) 0 0 0 nil nil)
dbCreateInst(cv noConnMaster "noConn_D12_bottom4_C" '(10.562 1.750) "R180")
schCreateWire(cv "route" "full" '((10.188 1.000) (10.188 1.750)) 0 0 0 nil nil)
schCreateWireLabel(cv nil '(10.188 1.250) "GIOL" "lowerLeft" "R90" "stick" 0.0625 nil)
schCreateWire(cv "route" "full" '((10.062 1.000) (10.062 1.750)) 0 0 0 nil nil)
schCreateWireLabel(cv nil '(10.062 1.250) "D12_CORE" "lowerLeft" "R90" "stick" 0.0625 nil)
schCreatePin(cv nil "D12_CORE" "inputOutput" nil '(10.062 1.750) "R270")
schCreateWire(cv "route" "full" '((11.001 0.000) (11.001 -0.750)) 0 0 0 nil nil)
schCreateWireLabel(cv nil '(11.001 -0.250) "D12" "lowerRight" "R90" "stick" 0.0625 nil)
schCreatePin(cv nil "D12" "inputOutput" nil '(11.001 -0.750) "R90")
schCreateWire(cv "route" "full" '((10.688 1.000) (10.688 1.750)) 0 0 0 nil nil)
schCreateWireLabel(cv nil '(10.688 1.250) "POC" "lowerLeft" "R90" "stick" 0.0625 nil)
schCreateWire(cv "route" "full" '((10.874 1.000) (10.874 1.750)) 0 0 0 nil nil)
schCreateWireLabel(cv nil '(10.874 1.250) "VIOL" "lowerLeft" "R90" "stick" 0.0625 nil)
schCreateWire(cv "route" "full" '((11.062 1.000) (11.062 1.750)) 0 0 0 nil nil)
schCreateWireLabel(cv nil '(11.062 1.250) "GIOL" "lowerLeft" "R90" "stick" 0.0625 nil)
schCreateWire(cv "route" "full" '((11.251 1.000) (11.251 1.750)) 0 0 0 nil nil)
schCreateWireLabel(cv nil '(11.251 1.250) "VIOH" "lowerLeft" "R90" "stick" 0.0625 nil)
schCreateWire(cv "route" "full" '((11.624 1.000) (11.624 1.750)) 0 0 0 nil nil)
schCreateWireLabel(cv nil '(11.624 1.250) "GIOH" "lowerLeft" "R90" "stick" 0.0625 nil)
dbCreateInst(cv pddw16sdgz_v_gMaster "D13_bottom5" '(12.3125 0) "R0")
schCreateWire(cv "route" "full" '((12.438 1.000) (12.438 1.750)) 0 0 0 nil nil)
schCreateWireLabel(cv nil '(12.438 1.250) "VIOL" "lowerLeft" "R90" "stick" 0.0625 nil)
schCreateWire(cv "route" "full" '((12.562 1.000) (12.562 1.750)) 0 0 0 nil nil)
dbCreateInst(cv noConnMaster "noConn_D13_bottom5_C" '(12.562 1.750) "R180")
schCreateWire(cv "route" "full" '((12.188 1.000) (12.188 1.750)) 0 0 0 nil nil)
schCreateWireLabel(cv nil '(12.188 1.250) "GIOL" "lowerLeft" "R90" "stick" 0.0625 nil)
schCreateWire(cv "route" "full" '((12.062 1.000) (12.062 1.750)) 0 0 0 nil nil)
schCreateWireLabel(cv nil '(12.062 1.250) "D13_CORE" "lowerLeft" "R90" "stick" 0.0625 nil)
schCreatePin(cv nil "D13_CORE" "inputOutput" nil '(12.062 1.750) "R270")
schCreateWire(cv "route" "full" '((13.001 0.000) (13.001 -0.750)) 0 0 0 nil nil)
schCreateWireLabel(cv nil '(13.001 -0.250) "D13" "lowerRight" "R90" "stick" 0.0625 nil)
schCreatePin(cv nil "D13" "inputOutput" nil '(13.001 -0.750) "R90")
schCreateWire(cv "route" "full" '((12.688 1.000) (12.688 1.750)) 0 0 0 nil nil)
schCreateWireLabel(cv nil '(12.688 1.250) "POC" "lowerLeft" "R90" "stick" 0.0625 nil)
schCreateWire(cv "route" "full" '((12.874 1.000) (12.874 1.750)) 0 0 0 nil nil)
schCreateWireLabel(cv nil '(12.874 1.250) "VIOL" "lowerLeft" "R90" "stick" 0.0625 nil)
schCreateWire(cv "route" "full" '((13.062 1.000) (13.062 1.750)) 0 0 0 nil nil)
schCreateWireLabel(cv nil '(13.062 1.250) "GIOL" "lowerLeft" "R90" "stick" 0.0625 nil)
schCreateWire(cv "route" "full" '((13.251 1.000) (13.251 1.750)) 0 0 0 nil nil)
schCreateWireLabel(cv nil '(13.251 1.250) "VIOH" "lowerLeft" "R90" "stick" 0.0625 nil)
schCreateWire(cv "route" "full" '((13.624 1.000) (13.624 1.750)) 0 0 0 nil nil)
schCreateWireLabel(cv nil '(13.624 1.250) "GIOH" "lowerLeft" "R90" "stick" 0.0625 nil)
dbCreateInst(cv pddw16sdgz_v_gMaster "D14_bottom6" '(14.3125 0) "R0")
schCreateWire(cv "route" "full" '((14.438 1.000) (14.438 1.750)) 0 0 0 nil nil)
schCreateWireLabel(cv nil '(14.438 1.250) "VIOL" "lowerLeft" "R90" "stick" 0.0625 nil)
schCreateWire(cv "route" "full" '((14.562 1.000) (14.562 1.750)) 0 0 0 nil nil)
dbCreateInst(cv noConnMaster "noConn_D14_bottom6_C" '(14.562 1.750) "R180")
schCreateWire(cv "route" "full" '((14.188 1.000) (14.188 1.750)) 0 0 0 nil nil)
schCreateWireLabel(cv nil '(14.188 1.250) "GIOL" "lowerLeft" "R90" "stick" 0.0625 nil)
schCreateWire(cv "route" "full" '((14.062 1.000) (14.062 1.750)) 0 0 0 nil nil)
schCreateWireLabel(cv nil '(14.062 1.250) "D14_CORE" "lowerLeft" "R90" "stick" 0.0625 nil)
schCreatePin(cv nil "D14_CORE" "inputOutput" nil '(14.062 1.750) "R270")
schCreateWire(cv "route" "full" '((15.001 0.000) (15.001 -0.750)) 0 0 0 nil nil)
schCreateWireLabel(cv nil '(15.001 -0.250) "D14" "lowerRight" "R90" "stick" 0.0625 nil)
schCreatePin(cv nil "D14" "inputOutput" nil '(15.001 -0.750) "R90")
schCreateWire(cv "route" "full" '((14.688 1.000) (14.688 1.750)) 0 0 0 nil nil)
schCreateWireLabel(cv nil '(14.688 1.250) "POC" "lowerLeft" "R90" "stick" 0.0625 nil)
schCreateWire(cv "route" "full" '((14.874 1.000) (14.874 1.750)) 0 0 0 nil nil)
schCreateWireLabel(cv nil '(14.874 1.250) "VIOL" "lowerLeft" "R90" "stick" 0.0625 nil)
schCreateWire(cv "route" "full" '((15.062 1.000) (15.062 1.750)) 0 0 0 nil nil)
schCreateWireLabel(cv nil '(15.062 1.250) "GIOL" "lowerLeft" "R90" "stick" 0.0625 nil)
schCreateWire(cv "route" "full" '((15.251 1.000) (15.251 1.750)) 0 0 0 nil nil)
schCreateWireLabel(cv nil '(15.251 1.250) "VIOH" "lowerLeft" "R90" "stick" 0.0625 nil)
schCreateWire(cv "route" "full" '((15.624 1.000) (15.624 1.750)) 0 0 0 nil nil)
schCreateWireLabel(cv nil '(15.624 1.250) "GIOH" "lowerLeft" "R90" "stick" 0.0625 nil)
dbCreateInst(cv pddw16sdgz_v_gMaster "D15_bottom7" '(16.3125 0) "R0")
schCreateWire(cv "route" "full" '((16.438 1.000) (16.438 1.750)) 0 0 0 nil nil)
schCreateWireLabel(cv nil '(16.438 1.250) "VIOL" "lowerLeft" "R90" "stick" 0.0625 nil)
schCreateWire(cv "route" "full" '((16.562 1.000) (16.562 1.750)) 0 0 0 nil nil)
dbCreateInst(cv noConnMaster "noConn_D15_bottom7_C" '(16.562 1.750) "R180")
schCreateWire(cv "route" "full" '((16.188 1.000) (16.188 1.750)) 0 0 0 nil nil)
schCreateWireLabel(cv nil '(16.188 1.250) "GIOL" "lowerLeft" "R90" "stick" 0.0625 nil)
schCreateWire(cv "route" "full" '((16.062 1.000) (16.062 1.750)) 0 0 0 nil nil)
schCreateWireLabel(cv nil '(16.062 1.250) "D15_CORE" "lowerLeft" "R90" "stick" 0.0625 nil)
schCreatePin(cv nil "D15_CORE" "inputOutput" nil '(16.062 1.750) "R270")
schCreateWire(cv "route" "full" '((17.000 0.000) (17.000 -0.750)) 0 0 0 nil nil)
schCreateWireLabel(cv nil '(17.000 -0.250) "D15" "lowerRight" "R90" "stick" 0.0625 nil)
schCreatePin(cv nil "D15" "inputOutput" nil '(17.000 -0.750) "R90")
schCreateWire(cv "route" "full" '((16.688 1.000) (16.688 1.750)) 0 0 0 nil nil)
schCreateWireLabel(cv nil '(16.688 1.250) "POC" "lowerLeft" "R90" "stick" 0.0625 nil)
schCreateWire(cv "route" "full" '((16.875 1.000) (16.875 1.750)) 0 0 0 nil nil)
schCreateWireLabel(cv nil '(16.875 1.250) "VIOL" "lowerLeft" "R90" "stick" 0.0625 nil)
schCreateWire(cv "route" "full" '((17.062 1.000) (17.062 1.750)) 0 0 0 nil nil)
schCreateWireLabel(cv nil '(17.062 1.250) "GIOL" "lowerLeft" "R90" "stick" 0.0625 nil)
schCreateWire(cv "route" "full" '((17.250 1.000) (17.250 1.750)) 0 0 0 nil nil)
schCreateWireLabel(cv nil '(17.250 1.250) "VIOH" "lowerLeft" "R90" "stick" 0.0625 nil)
schCreateWire(cv "route" "full" '((17.625 1.000) (17.625 1.750)) 0 0 0 nil nil)
schCreateWireLabel(cv nil '(17.625 1.250) "GIOH" "lowerLeft" "R90" "stick" 0.0625 nil)
dbCreateInst(cv pddw16sdgz_h_gMaster "D16_right0" '(20.0 2.3125) "R90")
schCreateWire(cv "route" "full" '((19.000 2.438) (18.250 2.438)) 0 0 0 nil nil)
schCreateWireLabel(cv nil '(18.750 2.438) "VIOL" "lowerRight" "R0" "stick" 0.0625 nil)
schCreateWire(cv "route" "full" '((19.000 2.562) (18.250 2.562)) 0 0 0 nil nil)
dbCreateInst(cv noConnMaster "noConn_D16_right0_C" '(18.250 2.562) "R270")
schCreateWire(cv "route" "full" '((19.000 2.188) (18.250 2.188)) 0 0 0 nil nil)
schCreateWireLabel(cv nil '(18.750 2.188) "GIOL" "lowerRight" "R0" "stick" 0.0625 nil)
schCreateWire(cv "route" "full" '((19.000 2.062) (18.250 2.062)) 0 0 0 nil nil)
schCreateWireLabel(cv nil '(18.750 2.062) "D16_CORE" "lowerRight" "R0" "stick" 0.0625 nil)
schCreatePin(cv nil "D16_CORE" "inputOutput" nil '(18.250 2.062) "R0")
schCreateWire(cv "route" "full" '((20.000 3.000) (20.750 3.000)) 0 0 0 nil nil)
schCreateWireLabel(cv nil '(20.250 3.000) "D16" "lowerLeft" "R0" "stick" 0.0625 nil)
schCreatePin(cv nil "D16" "inputOutput" nil '(20.750 3.000) "R180")
schCreateWire(cv "route" "full" '((19.000 2.688) (18.250 2.688)) 0 0 0 nil nil)
schCreateWireLabel(cv nil '(18.750 2.688) "POC" "lowerRight" "R0" "stick" 0.0625 nil)
schCreateWire(cv "route" "full" '((19.000 2.875) (18.250 2.875)) 0 0 0 nil nil)
schCreateWireLabel(cv nil '(18.750 2.875) "VIOL" "lowerRight" "R0" "stick" 0.0625 nil)
schCreateWire(cv "route" "full" '((19.000 3.062) (18.250 3.062)) 0 0 0 nil nil)
schCreateWireLabel(cv nil '(18.750 3.062) "GIOL" "lowerRight" "R0" "stick" 0.0625 nil)
schCreateWire(cv "route" "full" '((19.000 3.250) (18.250 3.250)) 0 0 0 nil nil)
schCreateWireLabel(cv nil '(18.750 3.250) "VIOH" "lowerRight" "R0" "stick" 0.0625 nil)
schCreateWire(cv "route" "full" '((19.000 3.625) (18.250 3.625)) 0 0 0 nil nil)
schCreateWireLabel(cv nil '(18.750 3.625) "GIOH" "lowerRight" "R0" "stick" 0.0625 nil)
dbCreateInst(cv pddw16sdgz_h_gMaster "D17_right1" '(20.0 4.3125) "R90")
schCreateWire(cv "route" "full" '((19.000 4.438) (18.250 4.438)) 0 0 0 nil nil)
schCreateWireLabel(cv nil '(18.750 4.438) "VIOL" "lowerRight" "R0" "stick" 0.0625 nil)
schCreateWire(cv "route" "full" '((19.000 4.562) (18.250 4.562)) 0 0 0 nil nil)
dbCreateInst(cv noConnMaster "noConn_D17_right1_C" '(18.250 4.562) "R270")
schCreateWire(cv "route" "full" '((19.000 4.188) (18.250 4.188)) 0 0 0 nil nil)
schCreateWireLabel(cv nil '(18.750 4.188) "GIOL" "lowerRight" "R0" "stick" 0.0625 nil)
schCreateWire(cv "route" "full" '((19.000 4.062) (18.250 4.062)) 0 0 0 nil nil)
schCreateWireLabel(cv nil '(18.750 4.062) "D17_CORE" "lowerRight" "R0" "stick" 0.0625 nil)
schCreatePin(cv nil "D17_CORE" "inputOutput" nil '(18.250 4.062) "R0")
schCreateWire(cv "route" "full" '((20.000 5.000) (20.750 5.000)) 0 0 0 nil nil)
schCreateWireLabel(cv nil '(20.250 5.000) "D17" "lowerLeft" "R0" "stick" 0.0625 nil)
schCreatePin(cv nil "D17" "inputOutput" nil '(20.750 5.000) "R180")
schCreateWire(cv "route" "full" '((19.000 4.688) (18.250 4.688)) 0 0 0 nil nil)
schCreateWireLabel(cv nil '(18.750 4.688) "POC" "lowerRight" "R0" "stick" 0.0625 nil)
schCreateWire(cv "route" "full" '((19.000 4.875) (18.250 4.875)) 0 0 0 nil nil)
schCreateWireLabel(cv nil '(18.750 4.875) "VIOL" "lowerRight" "R0" "stick" 0.0625 nil)
schCreateWire(cv "route" "full" '((19.000 5.062) (18.250 5.062)) 0 0 0 nil nil)
schCreateWireLabel(cv nil '(18.750 5.062) "GIOL" "lowerRight" "R0" "stick" 0.0625 nil)
schCreateWire(cv "route" "full" '((19.000 5.250) (18.250 5.250)) 0 0 0 nil nil)
schCreateWireLabel(cv nil '(18.750 5.250) "VIOH" "lowerRight" "R0" "stick" 0.0625 nil)
schCreateWire(cv "route" "full" '((19.000 5.625) (18.250 5.625)) 0 0 0 nil nil)
schCreateWireLabel(cv nil '(18.750 5.625) "GIOH" "lowerRight" "R0" "stick" 0.0625 nil)
dbCreateInst(cv pddw16sdgz_h_gMaster "D18_right2" '(20.0 6.3125) "R90")
schCreateWire(cv "route" "full" '((19.000 6.438) (18.250 6.438)) 0 0 0 nil nil)
schCreateWireLabel(cv nil '(18.750 6.438) "VIOL" "lowerRight" "R0" "stick" 0.0625 nil)
schCreateWire(cv "route" "full" '((19.000 6.562) (18.250 6.562)) 0 0 0 nil nil)
dbCreateInst(cv noConnMaster "noConn_D18_right2_C" '(18.250 6.562) "R270")
schCreateWire(cv "route" "full" '((19.000 6.188) (18.250 6.188)) 0 0 0 nil nil)
schCreateWireLabel(cv nil '(18.750 6.188) "GIOL" "lowerRight" "R0" "stick" 0.0625 nil)
schCreateWire(cv "route" "full" '((19.000 6.062) (18.250 6.062)) 0 0 0 nil nil)
schCreateWireLabel(cv nil '(18.750 6.062) "D18_CORE" "lowerRight" "R0" "stick" 0.0625 nil)
schCreatePin(cv nil "D18_CORE" "inputOutput" nil '(18.250 6.062) "R0")
schCreateWire(cv "route" "full" '((20.000 7.000) (20.750 7.000)) 0 0 0 nil nil)
schCreateWireLabel(cv nil '(20.250 7.000) "D18" "lowerLeft" "R0" "stick" 0.0625 nil)
schCreatePin(cv nil "D18" "inputOutput" nil '(20.750 7.000) "R180")
schCreateWire(cv "route" "full" '((19.000 6.688) (18.250 6.688)) 0 0 0 nil nil)
schCreateWireLabel(cv nil '(18.750 6.688) "POC" "lowerRight" "R0" "stick" 0.0625 nil)
schCreateWire(cv "route" "full" '((19.000 6.875) (18.250 6.875)) 0 0 0 nil nil)
schCreateWireLabel(cv nil '(18.750 6.875) "VIOL" "lowerRight" "R0" "stick" 0.0625 nil)
schCreateWire(cv "route" "full" '((19.000 7.062) (18.250 7.062)) 0 0 0 nil nil)
schCreateWireLabel(cv nil '(18.750 7.062) "GIOL" "lowerRight" "R0" "stick" 0.0625 nil)
schCreateWire(cv "route" "full" '((19.000 7.250) (18.250 7.250)) 0 0 0 nil nil)
schCreateWireLabel(cv nil '(18.750 7.250) "VIOH" "lowerRight" "R0" "stick" 0.0625 nil)
schCreateWire(cv "route" "full" '((19.000 7.625) (18.250 7.625)) 0 0 0 nil nil)
schCreateWireLabel(cv nil '(18.750 7.625) "GIOH" "lowerRight" "R0" "stick" 0.0625 nil)
dbCreateInst(cv pddw16sdgz_h_gMaster "D19_right3" '(20.0 8.3125) "R90")
schCreateWire(cv "route" "full" '((19.000 8.438) (18.250 8.438)) 0 0 0 nil nil)
schCreateWireLabel(cv nil '(18.750 8.438) "VIOL" "lowerRight" "R0" "stick" 0.0625 nil)
schCreateWire(cv "route" "full" '((19.000 8.562) (18.250 8.562)) 0 0 0 nil nil)
dbCreateInst(cv noConnMaster "noConn_D19_right3_C" '(18.250 8.562) "R270")
schCreateWire(cv "route" "full" '((19.000 8.188) (18.250 8.188)) 0 0 0 nil nil)
schCreateWireLabel(cv nil '(18.750 8.188) "GIOL" "lowerRight" "R0" "stick" 0.0625 nil)
schCreateWire(cv "route" "full" '((19.000 8.062) (18.250 8.062)) 0 0 0 nil nil)
schCreateWireLabel(cv nil '(18.750 8.062) "D19_CORE" "lowerRight" "R0" "stick" 0.0625 nil)
schCreatePin(cv nil "D19_CORE" "inputOutput" nil '(18.250 8.062) "R0")
schCreateWire(cv "route" "full" '((20.000 9.001) (20.750 9.001)) 0 0 0 nil nil)
schCreateWireLabel(cv nil '(20.250 9.001) "D19" "lowerLeft" "R0" "stick" 0.0625 nil)
schCreatePin(cv nil "D19" "inputOutput" nil '(20.750 9.001) "R180")
schCreateWire(cv "route" "full" '((19.000 8.688) (18.250 8.688)) 0 0 0 nil nil)
schCreateWireLabel(cv nil '(18.750 8.688) "POC" "lowerRight" "R0" "stick" 0.0625 nil)
schCreateWire(cv "route" "full" '((19.000 8.874) (18.250 8.874)) 0 0 0 nil nil)
schCreateWireLabel(cv nil '(18.750 8.874) "VIOL" "lowerRight" "R0" "stick" 0.0625 nil)
schCreateWire(cv "route" "full" '((19.000 9.062) (18.250 9.062)) 0 0 0 nil nil)
schCreateWireLabel(cv nil '(18.750 9.062) "GIOL" "lowerRight" "R0" "stick" 0.0625 nil)
schCreateWire(cv "route" "full" '((19.000 9.251) (18.250 9.251)) 0 0 0 nil nil)
schCreateWireLabel(cv nil '(18.750 9.251) "VIOH" "lowerRight" "R0" "stick" 0.0625 nil)
schCreateWire(cv "route" "full" '((19.000 9.624) (18.250 9.624)) 0 0 0 nil nil)
schCreateWireLabel(cv nil '(18.750 9.624) "GIOH" "lowerRight" "R0" "stick" 0.0625 nil)
dbCreateInst(cv pddw16sdgz_h_gMaster "D20_right4" '(20.0 10.3125) "R90")
schCreateWire(cv "route" "full" '((19.000 10.438) (18.250 10.438)) 0 0 0 nil nil)
schCreateWireLabel(cv nil '(18.750 10.438) "VIOL" "lowerRight" "R0" "stick" 0.0625 nil)
schCreateWire(cv "route" "full" '((19.000 10.562) (18.250 10.562)) 0 0 0 nil nil)
dbCreateInst(cv noConnMaster "noConn_D20_right4_C" '(18.250 10.562) "R270")
schCreateWire(cv "route" "full" '((19.000 10.188) (18.250 10.188)) 0 0 0 nil nil)
schCreateWireLabel(cv nil '(18.750 10.188) "GIOL" "lowerRight" "R0" "stick" 0.0625 nil)
schCreateWire(cv "route" "full" '((19.000 10.062) (18.250 10.062)) 0 0 0 nil nil)
schCreateWireLabel(cv nil '(18.750 10.062) "D20_CORE" "lowerRight" "R0" "stick" 0.0625 nil)
schCreatePin(cv nil "D20_CORE" "inputOutput" nil '(18.250 10.062) "R0")
schCreateWire(cv "route" "full" '((20.000 11.001) (20.750 11.001)) 0 0 0 nil nil)
schCreateWireLabel(cv nil '(20.250 11.001) "D20" "lowerLeft" "R0" "stick" 0.0625 nil)
schCreatePin(cv nil "D20" "inputOutput" nil '(20.750 11.001) "R180")
schCreateWire(cv "route" "full" '((19.000 10.688) (18.250 10.688)) 0 0 0 nil nil)
schCreateWireLabel(cv nil '(18.750 10.688) "POC" "lowerRight" "R0" "stick" 0.0625 nil)
schCreateWire(cv "route" "full" '((19.000 10.874) (18.250 10.874)) 0 0 0 nil nil)
schCreateWireLabel(cv nil '(18.750 10.874) "VIOL" "lowerRight" "R0" "stick" 0.0625 nil)
schCreateWire(cv "route" "full" '((19.000 11.062) (18.250 11.062)) 0 0 0 nil nil)
schCreateWireLabel(cv nil '(18.750 11.062) "GIOL" "lowerRight" "R0" "stick" 0.0625 nil)
schCreateWire(cv "route" "full" '((19.000 11.251) (18.250 11.251)) 0 0 0 nil nil)
schCreateWireLabel(cv nil '(18.750 11.251) "VIOH" "lowerRight" "R0" "stick" 0.0625 nil)
schCreateWire(cv "route" "full" '((19.000 11.624) (18.250 11.624)) 0 0 0 nil nil)
schCreateWireLabel(cv nil '(18.750 11.624) "GIOH" "lowerRight" "R0" "stick" 0.0625 nil)
dbCreateInst(cv pddw16sdgz_h_gMaster "D21_right5" '(20.0 12.3125) "R90")
schCreateWire(cv "route" "full" '((19.000 12.438) (18.250 12.438)) 0 0 0 nil nil)
schCreateWireLabel(cv nil '(18.750 12.438) "VIOL" "lowerRight" "R0" "stick" 0.0625 nil)
schCreateWire(cv "route" "full" '((19.000 12.562) (18.250 12.562)) 0 0 0 nil nil)
dbCreateInst(cv noConnMaster "noConn_D21_right5_C" '(18.250 12.562) "R270")
schCreateWire(cv "route" "full" '((19.000 12.188) (18.250 12.188)) 0 0 0 nil nil)
schCreateWireLabel(cv nil '(18.750 12.188) "GIOL" "lowerRight" "R0" "stick" 0.0625 nil)
schCreateWire(cv "route" "full" '((19.000 12.062) (18.250 12.062)) 0 0 0 nil nil)
schCreateWireLabel(cv nil '(18.750 12.062) "D21_CORE" "lowerRight" "R0" "stick" 0.0625 nil)
schCreatePin(cv nil "D21_CORE" "inputOutput" nil '(18.250 12.062) "R0")
schCreateWire(cv "route" "full" '((20.000 13.001) (20.750 13.001)) 0 0 0 nil nil)
schCreateWireLabel(cv nil '(20.250 13.001) "D21" "lowerLeft" "R0" "stick" 0.0625 nil)
schCreatePin(cv nil "D21" "inputOutput" nil '(20.750 13.001) "R180")
schCreateWire(cv "route" "full" '((19.000 12.688) (18.250 12.688)) 0 0 0 nil nil)
schCreateWireLabel(cv nil '(18.750 12.688) "POC" "lowerRight" "R0" "stick" 0.0625 nil)
schCreateWire(cv "route" "full" '((19.000 12.874) (18.250 12.874)) 0 0 0 nil nil)
schCreateWireLabel(cv nil '(18.750 12.874) "VIOL" "lowerRight" "R0" "stick" 0.0625 nil)
schCreateWire(cv "route" "full" '((19.000 13.062) (18.250 13.062)) 0 0 0 nil nil)
schCreateWireLabel(cv nil '(18.750 13.062) "GIOL" "lowerRight" "R0" "stick" 0.0625 nil)
schCreateWire(cv "route" "full" '((19.000 13.251) (18.250 13.251)) 0 0 0 nil nil)
schCreateWireLabel(cv nil '(18.750 13.251) "VIOH" "lowerRight" "R0" "stick" 0.0625 nil)
schCreateWire(cv "route" "full" '((19.000 13.624) (18.250 13.624)) 0 0 0 nil nil)
schCreateWireLabel(cv nil '(18.750 13.624) "GIOH" "lowerRight" "R0" "stick" 0.0625 nil)
dbCreateInst(cv pddw16sdgz_h_gMaster "D22_right6" '(20.0 14.3125) "R90")
schCreateWire(cv "route" "full" '((19.000 14.438) (18.250 14.438)) 0 0 0 nil nil)
schCreateWireLabel(cv nil '(18.750 14.438) "VIOL" "lowerRight" "R0" "stick" 0.0625 nil)
schCreateWire(cv "route" "full" '((19.000 14.562) (18.250 14.562)) 0 0 0 nil nil)
dbCreateInst(cv noConnMaster "noConn_D22_right6_C" '(18.250 14.562) "R270")
schCreateWire(cv "route" "full" '((19.000 14.188) (18.250 14.188)) 0 0 0 nil nil)
schCreateWireLabel(cv nil '(18.750 14.188) "GIOL" "lowerRight" "R0" "stick" 0.0625 nil)
schCreateWire(cv "route" "full" '((19.000 14.062) (18.250 14.062)) 0 0 0 nil nil)
schCreateWireLabel(cv nil '(18.750 14.062) "D22_CORE" "lowerRight" "R0" "stick" 0.0625 nil)
schCreatePin(cv nil "D22_CORE" "inputOutput" nil '(18.250 14.062) "R0")
schCreateWire(cv "route" "full" '((20.000 15.001) (20.750 15.001)) 0 0 0 nil nil)
schCreateWireLabel(cv nil '(20.250 15.001) "D22" "lowerLeft" "R0" "stick" 0.0625 nil)
schCreatePin(cv nil "D22" "inputOutput" nil '(20.750 15.001) "R180")
schCreateWire(cv "route" "full" '((19.000 14.688) (18.250 14.688)) 0 0 0 nil nil)
schCreateWireLabel(cv nil '(18.750 14.688) "POC" "lowerRight" "R0" "stick" 0.0625 nil)
schCreateWire(cv "route" "full" '((19.000 14.874) (18.250 14.874)) 0 0 0 nil nil)
schCreateWireLabel(cv nil '(18.750 14.874) "VIOL" "lowerRight" "R0" "stick" 0.0625 nil)
schCreateWire(cv "route" "full" '((19.000 15.062) (18.250 15.062)) 0 0 0 nil nil)
schCreateWireLabel(cv nil '(18.750 15.062) "GIOL" "lowerRight" "R0" "stick" 0.0625 nil)
schCreateWire(cv "route" "full" '((19.000 15.251) (18.250 15.251)) 0 0 0 nil nil)
schCreateWireLabel(cv nil '(18.750 15.251) "VIOH" "lowerRight" "R0" "stick" 0.0625 nil)
schCreateWire(cv "route" "full" '((19.000 15.624) (18.250 15.624)) 0 0 0 nil nil)
schCreateWireLabel(cv nil '(18.750 15.624) "GIOH" "lowerRight" "R0" "stick" 0.0625 nil)
dbCreateInst(cv pddw16sdgz_h_gMaster "D23_right7" '(20.0 16.3125) "R90")
schCreateWire(cv "route" "full" '((19.000 16.438) (18.250 16.438)) 0 0 0 nil nil)
schCreateWireLabel(cv nil '(18.750 16.438) "VIOL" "lowerRight" "R0" "stick" 0.0625 nil)
schCreateWire(cv "route" "full" '((19.000 16.562) (18.250 16.562)) 0 0 0 nil nil)
dbCreateInst(cv noConnMaster "noConn_D23_right7_C" '(18.250 16.562) "R270")
schCreateWire(cv "route" "full" '((19.000 16.188) (18.250 16.188)) 0 0 0 nil nil)
schCreateWireLabel(cv nil '(18.750 16.188) "GIOL" "lowerRight" "R0" "stick" 0.0625 nil)
schCreateWire(cv "route" "full" '((19.000 16.062) (18.250 16.062)) 0 0 0 nil nil)
schCreateWireLabel(cv nil '(18.750 16.062) "D23_CORE" "lowerRight" "R0" "stick" 0.0625 nil)
schCreatePin(cv nil "D23_CORE" "inputOutput" nil '(18.250 16.062) "R0")
schCreateWire(cv "route" "full" '((20.000 17.000) (20.750 17.000)) 0 0 0 nil nil)
schCreateWireLabel(cv nil '(20.250 17.000) "D23" "lowerLeft" "R0" "stick" 0.0625 nil)
schCreatePin(cv nil "D23" "inputOutput" nil '(20.750 17.000) "R180")
schCreateWire(cv "route" "full" '((19.000 16.688) (18.250 16.688)) 0 0 0 nil nil)
schCreateWireLabel(cv nil '(18.750 16.688) "POC" "lowerRight" "R0" "stick" 0.0625 nil)
schCreateWire(cv "route" "full" '((19.000 16.875) (18.250 16.875)) 0 0 0 nil nil)
schCreateWireLabel(cv nil '(18.750 16.875) "VIOL" "lowerRight" "R0" "stick" 0.0625 nil)
schCreateWire(cv "route" "full" '((19.000 17.062) (18.250 17.062)) 0 0 0 nil nil)
schCreateWireLabel(cv nil '(18.750 17.062) "GIOL" "lowerRight" "R0" "stick" 0.0625 nil)
schCreateWire(cv "route" "full" '((19.000 17.250) (18.250 17.250)) 0 0 0 nil nil)
schCreateWireLabel(cv nil '(18.750 17.250) "VIOH" "lowerRight" "R0" "stick" 0.0625 nil)
schCreateWire(cv "route" "full" '((19.000 17.625) (18.250 17.625)) 0 0 0 nil nil)
schCreateWireLabel(cv nil '(18.750 17.625) "GIOH" "lowerRight" "R0" "stick" 0.0625 nil)
dbCreateInst(cv pddw16sdgz_v_gMaster "D24_top0" '(17.6875 20.0) "R180")
schCreateWire(cv "route" "full" '((17.562 19.000) (17.562 18.250)) 0 0 0 nil nil)
schCreateWireLabel(cv nil '(17.562 18.750) "VIOL" "lowerRight" "R90" "stick" 0.0625 nil)
schCreateWire(cv "route" "full" '((17.438 19.000) (17.438 18.250)) 0 0 0 nil nil)
dbCreateInst(cv noConnMaster "noConn_D24_top0_C" '(17.438 18.250) "R0")
schCreateWire(cv "route" "full" '((17.812 19.000) (17.812 18.250)) 0 0 0 nil nil)
schCreateWireLabel(cv nil '(17.812 18.750) "GIOL" "lowerRight" "R90" "stick" 0.0625 nil)
schCreateWire(cv "route" "full" '((17.938 19.000) (17.938 18.250)) 0 0 0 nil nil)
schCreateWireLabel(cv nil '(17.938 18.750) "D24_CORE" "lowerRight" "R90" "stick" 0.0625 nil)
schCreatePin(cv nil "D24_CORE" "inputOutput" nil '(17.938 18.250) "R90")
schCreateWire(cv "route" "full" '((17.000 20.000) (17.000 20.750)) 0 0 0 nil nil)
schCreateWireLabel(cv nil '(17.000 20.250) "D24" "lowerLeft" "R90" "stick" 0.0625 nil)
schCreatePin(cv nil "D24" "inputOutput" nil '(17.000 20.750) "R270")
schCreateWire(cv "route" "full" '((17.312 19.000) (17.312 18.250)) 0 0 0 nil nil)
schCreateWireLabel(cv nil '(17.312 18.750) "POC" "lowerRight" "R90" "stick" 0.0625 nil)
schCreateWire(cv "route" "full" '((17.125 19.000) (17.125 18.250)) 0 0 0 nil nil)
schCreateWireLabel(cv nil '(17.125 18.750) "VIOL" "lowerRight" "R90" "stick" 0.0625 nil)
schCreateWire(cv "route" "full" '((16.938 19.000) (16.938 18.250)) 0 0 0 nil nil)
schCreateWireLabel(cv nil '(16.938 18.750) "GIOL" "lowerRight" "R90" "stick" 0.0625 nil)
schCreateWire(cv "route" "full" '((16.750 19.000) (16.750 18.250)) 0 0 0 nil nil)
schCreateWireLabel(cv nil '(16.750 18.750) "VIOH" "lowerRight" "R90" "stick" 0.0625 nil)
schCreateWire(cv "route" "full" '((16.375 19.000) (16.375 18.250)) 0 0 0 nil nil)
schCreateWireLabel(cv nil '(16.375 18.750) "GIOH" "lowerRight" "R90" "stick" 0.0625 nil)
dbCreateInst(cv pddw16sdgz_v_gMaster "D25_top1" '(15.6875 20.0) "R180")
schCreateWire(cv "route" "full" '((15.562 19.000) (15.562 18.250)) 0 0 0 nil nil)
schCreateWireLabel(cv nil '(15.562 18.750) "VIOL" "lowerRight" "R90" "stick" 0.0625 nil)
schCreateWire(cv "route" "full" '((15.438 19.000) (15.438 18.250)) 0 0 0 nil nil)
dbCreateInst(cv noConnMaster "noConn_D25_top1_C" '(15.438 18.250) "R0")
schCreateWire(cv "route" "full" '((15.812 19.000) (15.812 18.250)) 0 0 0 nil nil)
schCreateWireLabel(cv nil '(15.812 18.750) "GIOL" "lowerRight" "R90" "stick" 0.0625 nil)
schCreateWire(cv "route" "full" '((15.938 19.000) (15.938 18.250)) 0 0 0 nil nil)
schCreateWireLabel(cv nil '(15.938 18.750) "D25_CORE" "lowerRight" "R90" "stick" 0.0625 nil)
schCreatePin(cv nil "D25_CORE" "inputOutput" nil '(15.938 18.250) "R90")
schCreateWire(cv "route" "full" '((14.999 20.000) (14.999 20.750)) 0 0 0 nil nil)
schCreateWireLabel(cv nil '(14.999 20.250) "D25" "lowerLeft" "R90" "stick" 0.0625 nil)
schCreatePin(cv nil "D25" "inputOutput" nil '(14.999 20.750) "R270")
schCreateWire(cv "route" "full" '((15.312 19.000) (15.312 18.250)) 0 0 0 nil nil)
schCreateWireLabel(cv nil '(15.312 18.750) "POC" "lowerRight" "R90" "stick" 0.0625 nil)
schCreateWire(cv "route" "full" '((15.126 19.000) (15.126 18.250)) 0 0 0 nil nil)
schCreateWireLabel(cv nil '(15.126 18.750) "VIOL" "lowerRight" "R90" "stick" 0.0625 nil)
schCreateWire(cv "route" "full" '((14.938 19.000) (14.938 18.250)) 0 0 0 nil nil)
schCreateWireLabel(cv nil '(14.938 18.750) "GIOL" "lowerRight" "R90" "stick" 0.0625 nil)
schCreateWire(cv "route" "full" '((14.749 19.000) (14.749 18.250)) 0 0 0 nil nil)
schCreateWireLabel(cv nil '(14.749 18.750) "VIOH" "lowerRight" "R90" "stick" 0.0625 nil)
schCreateWire(cv "route" "full" '((14.376 19.000) (14.376 18.250)) 0 0 0 nil nil)
schCreateWireLabel(cv nil '(14.376 18.750) "GIOH" "lowerRight" "R90" "stick" 0.0625 nil)
dbCreateInst(cv pddw16sdgz_v_gMaster "D26_top2" '(13.6875 20.0) "R180")
schCreateWire(cv "route" "full" '((13.562 19.000) (13.562 18.250)) 0 0 0 nil nil)
schCreateWireLabel(cv nil '(13.562 18.750) "VIOL" "lowerRight" "R90" "stick" 0.0625 nil)
schCreateWire(cv "route" "full" '((13.438 19.000) (13.438 18.250)) 0 0 0 nil nil)
dbCreateInst(cv noConnMaster "noConn_D26_top2_C" '(13.438 18.250) "R0")
schCreateWire(cv "route" "full" '((13.812 19.000) (13.812 18.250)) 0 0 0 nil nil)
schCreateWireLabel(cv nil '(13.812 18.750) "GIOL" "lowerRight" "R90" "stick" 0.0625 nil)
schCreateWire(cv "route" "full" '((13.938 19.000) (13.938 18.250)) 0 0 0 nil nil)
schCreateWireLabel(cv nil '(13.938 18.750) "D26_CORE" "lowerRight" "R90" "stick" 0.0625 nil)
schCreatePin(cv nil "D26_CORE" "inputOutput" nil '(13.938 18.250) "R90")
schCreateWire(cv "route" "full" '((12.999 20.000) (12.999 20.750)) 0 0 0 nil nil)
schCreateWireLabel(cv nil '(12.999 20.250) "D26" "lowerLeft" "R90" "stick" 0.0625 nil)
schCreatePin(cv nil "D26" "inputOutput" nil '(12.999 20.750) "R270")
schCreateWire(cv "route" "full" '((13.312 19.000) (13.312 18.250)) 0 0 0 nil nil)
schCreateWireLabel(cv nil '(13.312 18.750) "POC" "lowerRight" "R90" "stick" 0.0625 nil)
schCreateWire(cv "route" "full" '((13.126 19.000) (13.126 18.250)) 0 0 0 nil nil)
schCreateWireLabel(cv nil '(13.126 18.750) "VIOL" "lowerRight" "R90" "stick" 0.0625 nil)
schCreateWire(cv "route" "full" '((12.938 19.000) (12.938 18.250)) 0 0 0 nil nil)
schCreateWireLabel(cv nil '(12.938 18.750) "GIOL" "lowerRight" "R90" "stick" 0.0625 nil)
schCreateWire(cv "route" "full" '((12.749 19.000) (12.749 18.250)) 0 0 0 nil nil)
schCreateWireLabel(cv nil '(12.749 18.750) "VIOH" "lowerRight" "R90" "stick" 0.0625 nil)
schCreateWire(cv "route" "full" '((12.376 19.000) (12.376 18.250)) 0 0 0 nil nil)
schCreateWireLabel(cv nil '(12.376 18.750) "GIOH" "lowerRight" "R90" "stick" 0.0625 nil)
dbCreateInst(cv pddw16sdgz_v_gMaster "D27_top3" '(11.6875 20.0) "R180")
schCreateWire(cv "route" "full" '((11.562 19.000) (11.562 18.250)) 0 0 0 nil nil)
schCreateWireLabel(cv nil '(11.562 18.750) "VIOL" "lowerRight" "R90" "stick" 0.0625 nil)
schCreateWire(cv "route" "full" '((11.438 19.000) (11.438 18.250)) 0 0 0 nil nil)
dbCreateInst(cv noConnMaster "noConn_D27_top3_C" '(11.438 18.250) "R0")
schCreateWire(cv "route" "full" '((11.812 19.000) (11.812 18.250)) 0 0 0 nil nil)
schCreateWireLabel(cv nil '(11.812 18.750) "GIOL" "lowerRight" "R90" "stick" 0.0625 nil)
schCreateWire(cv "route" "full" '((11.938 19.000) (11.938 18.250)) 0 0 0 nil nil)
schCreateWireLabel(cv nil '(11.938 18.750) "D27_CORE" "lowerRight" "R90" "stick" 0.0625 nil)
schCreatePin(cv nil "D27_CORE" "inputOutput" nil '(11.938 18.250) "R90")
schCreateWire(cv "route" "full" '((10.999 20.000) (10.999 20.750)) 0 0 0 nil nil)
schCreateWireLabel(cv nil '(10.999 20.250) "D27" "lowerLeft" "R90" "stick" 0.0625 nil)
schCreatePin(cv nil "D27" "inputOutput" nil '(10.999 20.750) "R270")
schCreateWire(cv "route" "full" '((11.312 19.000) (11.312 18.250)) 0 0 0 nil nil)
schCreateWireLabel(cv nil '(11.312 18.750) "POC" "lowerRight" "R90" "stick" 0.0625 nil)
schCreateWire(cv "route" "full" '((11.126 19.000) (11.126 18.250)) 0 0 0 nil nil)
schCreateWireLabel(cv nil '(11.126 18.750) "VIOL" "lowerRight" "R90" "stick" 0.0625 nil)
schCreateWire(cv "route" "full" '((10.938 19.000) (10.938 18.250)) 0 0 0 nil nil)
schCreateWireLabel(cv nil '(10.938 18.750) "GIOL" "lowerRight" "R90" "stick" 0.0625 nil)
schCreateWire(cv "route" "full" '((10.749 19.000) (10.749 18.250)) 0 0 0 nil nil)
schCreateWireLabel(cv nil '(10.749 18.750) "VIOH" "lowerRight" "R90" "stick" 0.0625 nil)
schCreateWire(cv "route" "full" '((10.376 19.000) (10.376 18.250)) 0 0 0 nil nil)
schCreateWireLabel(cv nil '(10.376 18.750) "GIOH" "lowerRight" "R90" "stick" 0.0625 nil)
pvdd1dgz_v_gMaster = dbOpenCellView("tphn28hpcpgv18" "PVDD1DGZ_V_G" "symbol")
dbCreateInst(cv pvdd1dgz_v_gMaster "VIOL_top4" '(10.0 20.0) "R180")
schCreateWire(cv "route" "full" '((9.625 19.000) (9.625 18.250)) 0 0 0 nil nil)
schCreateWireLabel(cv nil '(9.625 18.750) "POC" "lowerRight" "R90" "stick" 0.0625 nil)
schCreateWire(cv "route" "full" '((9.000 20.000) (9.000 20.750)) 0 0 0 nil nil)
schCreateWireLabel(cv nil '(9.000 20.250) "VIOL" "lowerLeft" "R90" "stick" 0.0625 nil)
schCreatePin(cv nil "VIOL" "inputOutput" nil '(9.000 20.750) "R270")
schCreateWire(cv "route" "full" '((9.250 19.000) (9.250 18.250)) 0 0 0 nil nil)
schCreateWireLabel(cv nil '(9.250 18.750) "GIOL" "lowerRight" "R90" "stick" 0.0625 nil)
schCreateWire(cv "route" "full" '((9.062 19.000) (9.062 18.250)) 0 0 0 nil nil)
schCreateWireLabel(cv nil '(9.062 18.750) "VIOH" "lowerRight" "R90" "stick" 0.0625 nil)
schCreateWire(cv "route" "full" '((8.688 19.000) (8.688 18.250)) 0 0 0 nil nil)
schCreateWireLabel(cv nil '(8.688 18.750) "GIOH" "lowerRight" "R90" "stick" 0.0625 nil)
pvss1dgz_v_gMaster = dbOpenCellView("tphn28hpcpgv18" "PVSS1DGZ_V_G" "symbol")
dbCreateInst(cv pvss1dgz_v_gMaster "GIOL_top5" '(8.0 20.0) "R180")
schCreateWire(cv "route" "full" '((7.625 19.000) (7.625 18.250)) 0 0 0 nil nil)
schCreateWireLabel(cv nil '(7.625 18.750) "POC" "lowerRight" "R90" "stick" 0.0625 nil)
schCreateWire(cv "route" "full" '((7.438 19.000) (7.438 18.250)) 0 0 0 nil nil)
schCreateWireLabel(cv nil '(7.438 18.750) "VIOL" "lowerRight" "R90" "stick" 0.0625 nil)
schCreateWire(cv "route" "full" '((7.000 20.000) (7.000 20.750)) 0 0 0 nil nil)
schCreateWireLabel(cv nil '(7.000 20.250) "GIOL" "lowerLeft" "R90" "stick" 0.0625 nil)
schCreatePin(cv nil "GIOL" "inputOutput" nil '(7.000 20.750) "R270")
schCreateWire(cv "route" "full" '((7.062 19.000) (7.062 18.250)) 0 0 0 nil nil)
schCreateWireLabel(cv nil '(7.062 18.750) "VIOH" "lowerRight" "R90" "stick" 0.0625 nil)
schCreateWire(cv "route" "full" '((6.688 19.000) (6.688 18.250)) 0 0 0 nil nil)
schCreateWireLabel(cv nil '(6.688 18.750) "GIOH" "lowerRight" "R90" "stick" 0.0625 nil)
pvdd2poc_v_gMaster = dbOpenCellView("tphn28hpcpgv18" "PVDD2POC_V_G" "symbol")
dbCreateInst(cv pvdd2poc_v_gMaster "VIOH_top6" '(6.0 20.0) "R180")
schCreateWire(cv "route" "full" '((5.625 19.000) (5.625 18.250)) 0 0 0 nil nil)
schCreateWireLabel(cv nil '(5.625 18.750) "POC" "lowerRight" "R90" "stick" 0.0625 nil)
schCreateWire(cv "route" "full" '((5.438 19.000) (5.438 18.250)) 0 0 0 nil nil)
schCreateWireLabel(cv nil '(5.438 18.750) "VIOL" "lowerRight" "R90" "stick" 0.0625 nil)
schCreateWire(cv "route" "full" '((5.250 19.000) (5.250 18.250)) 0 0 0 nil nil)
schCreateWireLabel(cv nil '(5.250 18.750) "GIOL" "lowerRight" "R90" "stick" 0.0625 nil)
schCreateWire(cv "route" "full" '((5.000 20.000) (5.000 20.750)) 0 0 0 nil nil)
schCreateWireLabel(cv nil '(5.000 20.250) "VIOH" "lowerLeft" "R90" "stick" 0.0625 nil)
schCreatePin(cv nil "VIOH" "inputOutput" nil '(5.000 20.750) "R270")
schCreateWire(cv "route" "full" '((4.688 19.000) (4.688 18.250)) 0 0 0 nil nil)
schCreateWireLabel(cv nil '(4.688 18.750) "GIOH" "lowerRight" "R90" "stick" 0.0625 nil)
pvss2dgz_v_gMaster = dbOpenCellView("tphn28hpcpgv18" "PVSS2DGZ_V_G" "symbol")
dbCreateInst(cv pvss2dgz_v_gMaster "GIOH_top7" '(4.0 20.0) "R180")
schCreateWire(cv "route" "full" '((3.625 19.000) (3.625 18.250)) 0 0 0 nil nil)
schCreateWireLabel(cv nil '(3.625 18.750) "POC" "lowerRight" "R90" "stick" 0.0625 nil)
schCreateWire(cv "route" "full" '((3.438 19.000) (3.438 18.250)) 0 0 0 nil nil)
schCreateWireLabel(cv nil '(3.438 18.750) "VIOL" "lowerRight" "R90" "stick" 0.0625 nil)
schCreateWire(cv "route" "full" '((3.250 19.000) (3.250 18.250)) 0 0 0 nil nil)
schCreateWireLabel(cv nil '(3.250 18.750) "GIOL" "lowerRight" "R90" "stick" 0.0625 nil)
schCreateWire(cv "route" "full" '((3.062 19.000) (3.062 18.250)) 0 0 0 nil nil)
schCreateWireLabel(cv nil '(3.062 18.750) "VIOH" "lowerRight" "R90" "stick" 0.0625 nil)
schCreateWire(cv "route" "full" '((3.000 20.000) (3.000 20.750)) 0 0 0 nil nil)
schCreateWireLabel(cv nil '(3.000 20.250) "GIOH" "lowerLeft" "R90" "stick" 0.0625 nil)
schCreatePin(cv nil "GIOH" "inputOutput" nil '(3.000 20.750) "R270")
dbCreateInst(cv pddw16sdgz_v_gMaster "D28_top23" '(13.375 16.0) "R180")
schCreateWire(cv "route" "full" '((13.250 15.000) (13.250 14.250)) 0 0 0 nil nil)
schCreateWireLabel(cv nil '(13.250 14.750) "VIOL" "lowerRight" "R90" "stick" 0.0625 nil)
schCreateWire(cv "route" "full" '((13.125 15.000) (13.125 14.250)) 0 0 0 nil nil)
dbCreateInst(cv noConnMaster "noConn_D28_top23_C" '(13.125 14.250) "R0")
schCreateWire(cv "route" "full" '((13.500 15.000) (13.500 14.250)) 0 0 0 nil nil)
schCreateWireLabel(cv nil '(13.500 14.750) "GIOL" "lowerRight" "R90" "stick" 0.0625 nil)
schCreateWire(cv "route" "full" '((13.625 15.000) (13.625 14.250)) 0 0 0 nil nil)
schCreateWireLabel(cv nil '(13.625 14.750) "D28_CORE" "lowerRight" "R90" "stick" 0.0625 nil)
schCreatePin(cv nil "D28_CORE" "inputOutput" nil '(13.625 14.250) "R90")
schCreateWire(cv "route" "full" '((12.687 16.000) (12.687 16.750)) 0 0 0 nil nil)
schCreateWireLabel(cv nil '(12.687 16.250) "D28" "lowerLeft" "R90" "stick" 0.0625 nil)
schCreatePin(cv nil "D28" "inputOutput" nil '(12.687 16.750) "R270")
schCreateWire(cv "route" "full" '((13.000 15.000) (13.000 14.250)) 0 0 0 nil nil)
schCreateWireLabel(cv nil '(13.000 14.750) "POC" "lowerRight" "R90" "stick" 0.0625 nil)
schCreateWire(cv "route" "full" '((12.813 15.000) (12.813 14.250)) 0 0 0 nil nil)
schCreateWireLabel(cv nil '(12.813 14.750) "VIOL" "lowerRight" "R90" "stick" 0.0625 nil)
schCreateWire(cv "route" "full" '((12.625 15.000) (12.625 14.250)) 0 0 0 nil nil)
schCreateWireLabel(cv nil '(12.625 14.750) "GIOL" "lowerRight" "R90" "stick" 0.0625 nil)
schCreateWire(cv "route" "full" '((12.437 15.000) (12.437 14.250)) 0 0 0 nil nil)
schCreateWireLabel(cv nil '(12.437 14.750) "VIOH" "lowerRight" "R90" "stick" 0.0625 nil)
schCreateWire(cv "route" "full" '((12.063 15.000) (12.063 14.250)) 0 0 0 nil nil)
schCreateWireLabel(cv nil '(12.063 14.750) "GIOH" "lowerRight" "R90" "stick" 0.0625 nil)
dbCreateInst(cv pddw16sdgz_v_gMaster "D29_top34" '(11.53125 16.0) "R180")
schCreateWire(cv "route" "full" '((11.406 15.000) (11.406 14.250)) 0 0 0 nil nil)
schCreateWireLabel(cv nil '(11.406 14.750) "VIOL" "lowerRight" "R90" "stick" 0.0625 nil)
schCreateWire(cv "route" "full" '((11.281 15.000) (11.281 14.250)) 0 0 0 nil nil)
dbCreateInst(cv noConnMaster "noConn_D29_top34_C" '(11.281 14.250) "R0")
schCreateWire(cv "route" "full" '((11.656 15.000) (11.656 14.250)) 0 0 0 nil nil)
schCreateWireLabel(cv nil '(11.656 14.750) "GIOL" "lowerRight" "R90" "stick" 0.0625 nil)
schCreateWire(cv "route" "full" '((11.781 15.000) (11.781 14.250)) 0 0 0 nil nil)
schCreateWireLabel(cv nil '(11.781 14.750) "D29_CORE" "lowerRight" "R90" "stick" 0.0625 nil)
schCreatePin(cv nil "D29_CORE" "inputOutput" nil '(11.781 14.250) "R90")
schCreateWire(cv "route" "full" '((10.843 16.000) (10.843 16.750)) 0 0 0 nil nil)
schCreateWireLabel(cv nil '(10.843 16.250) "D29" "lowerLeft" "R90" "stick" 0.0625 nil)
schCreatePin(cv nil "D29" "inputOutput" nil '(10.843 16.750) "R270")
schCreateWire(cv "route" "full" '((11.156 15.000) (11.156 14.250)) 0 0 0 nil nil)
schCreateWireLabel(cv nil '(11.156 14.750) "POC" "lowerRight" "R90" "stick" 0.0625 nil)
schCreateWire(cv "route" "full" '((10.969 15.000) (10.969 14.250)) 0 0 0 nil nil)
schCreateWireLabel(cv nil '(10.969 14.750) "VIOL" "lowerRight" "R90" "stick" 0.0625 nil)
schCreateWire(cv "route" "full" '((10.781 15.000) (10.781 14.250)) 0 0 0 nil nil)
schCreateWireLabel(cv nil '(10.781 14.750) "GIOL" "lowerRight" "R90" "stick" 0.0625 nil)
schCreateWire(cv "route" "full" '((10.593 15.000) (10.593 14.250)) 0 0 0 nil nil)
schCreateWireLabel(cv nil '(10.593 14.750) "VIOH" "lowerRight" "R90" "stick" 0.0625 nil)
schCreateWire(cv "route" "full" '((10.219 15.000) (10.219 14.250)) 0 0 0 nil nil)
schCreateWireLabel(cv nil '(10.219 14.750) "GIOH" "lowerRight" "R90" "stick" 0.0625 nil)
schCheck(cv)
dbSave(cv)
t
