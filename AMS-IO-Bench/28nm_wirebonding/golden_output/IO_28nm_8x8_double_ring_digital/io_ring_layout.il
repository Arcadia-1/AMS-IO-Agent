; Generated Layout Script with Dual Ring Support

; ==================== All Components (Sorted by Placement Order) ====================
dbCreateParamInstByMasterName(cv "tphn28hpcpgv18" "PDDW16SDGZ_H_G" "layout" "D7_left_7" list(0 150) "R270")
dbCreateParamInstByMasterName(cv "PAD" "PAD60GU" "layout" "pad60gu_D7_left_7" list(0 150) "R270")
dbCreateParamInstByMasterName(cv "tphn28hpcpgv18" "PDDW16SDGZ_H_G" "layout" "D6_left_6" list(0 210) "R270")
dbCreateParamInstByMasterName(cv "PAD" "PAD60GU" "layout" "pad60gu_D6_left_6" list(0 210) "R270")
dbCreateParamInstByMasterName(cv "tphn28hpcpgv18" "PDDW16SDGZ_H_G" "layout" "D5_left_5" list(0 270) "R270")
dbCreateParamInstByMasterName(cv "PAD" "PAD60GU" "layout" "pad60gu_D5_left_5" list(0 270) "R270")
dbCreateParamInstByMasterName(cv "tphn28hpcpgv18" "PDDW16SDGZ_H_G" "layout" "D4_left_4" list(0 330) "R270")
dbCreateParamInstByMasterName(cv "PAD" "PAD60GU" "layout" "pad60gu_D4_left_4" list(0 330) "R270")
dbCreateParamInstByMasterName(cv "tphn28hpcpgv18" "PDDW16SDGZ_H_G" "layout" "D3_left_3" list(0 390) "R270")
dbCreateParamInstByMasterName(cv "PAD" "PAD60GU" "layout" "pad60gu_D3_left_3" list(0 390) "R270")
dbCreateParamInstByMasterName(cv "tphn28hpcpgv18" "PDDW16SDGZ_H_G" "layout" "D2_left_2" list(0 450) "R270")
dbCreateParamInstByMasterName(cv "PAD" "PAD60GU" "layout" "pad60gu_D2_left_2" list(0 450) "R270")
dbCreateParamInstByMasterName(cv "tphn28hpcpgv18" "PDDW16SDGZ_H_G" "layout" "D1_left_1" list(0 510) "R270")
dbCreateParamInstByMasterName(cv "PAD" "PAD60GU" "layout" "pad60gu_D1_left_1" list(0 510) "R270")
dbCreateParamInstByMasterName(cv "tphn28hpcpgv18" "PDDW16SDGZ_H_G" "layout" "D0_left_0" list(0 570) "R270")
dbCreateParamInstByMasterName(cv "PAD" "PAD60GU" "layout" "pad60gu_D0_left_0" list(0 570) "R270")
dbCreateParamInstByMasterName(cv "tphn28hpcpgv18" "PCORNER_G" "layout" "CORNER_TL_top_left" list(0 700) "R270")
dbCreateParamInstByMasterName(cv "tphn28hpcpgv18" "PDDW16SDGZ_V_G" "layout" "D15_bottom_7" list(550 0) "R0")
dbCreateParamInstByMasterName(cv "PAD" "PAD60GU" "layout" "pad60gu_D15_bottom_7" list(550 0) "R0")
dbCreateParamInstByMasterName(cv "tphn28hpcpgv18" "PDDW16SDGZ_V_G" "layout" "D14_bottom_6" list(490 0) "R0")
dbCreateParamInstByMasterName(cv "PAD" "PAD60GU" "layout" "pad60gu_D14_bottom_6" list(490 0) "R0")
dbCreateParamInstByMasterName(cv "tphn28hpcpgv18" "PDDW16SDGZ_V_G" "layout" "D13_bottom_5" list(430 0) "R0")
dbCreateParamInstByMasterName(cv "PAD" "PAD60GU" "layout" "pad60gu_D13_bottom_5" list(430 0) "R0")
dbCreateParamInstByMasterName(cv "tphn28hpcpgv18" "PDDW16SDGZ_V_G" "layout" "D12_bottom_4" list(370 0) "R0")
dbCreateParamInstByMasterName(cv "PAD" "PAD60GU" "layout" "pad60gu_D12_bottom_4" list(370 0) "R0")
dbCreateParamInstByMasterName(cv "tphn28hpcpgv18" "PDDW16SDGZ_V_G" "layout" "D11_bottom_3" list(310 0) "R0")
dbCreateParamInstByMasterName(cv "PAD" "PAD60GU" "layout" "pad60gu_D11_bottom_3" list(310 0) "R0")
dbCreateParamInstByMasterName(cv "tphn28hpcpgv18" "PDDW16SDGZ_V_G" "layout" "D10_bottom_2" list(250 0) "R0")
dbCreateParamInstByMasterName(cv "PAD" "PAD60GU" "layout" "pad60gu_D10_bottom_2" list(250 0) "R0")
dbCreateParamInstByMasterName(cv "tphn28hpcpgv18" "PDDW16SDGZ_V_G" "layout" "D9_bottom_1" list(190 0) "R0")
dbCreateParamInstByMasterName(cv "PAD" "PAD60GU" "layout" "pad60gu_D9_bottom_1" list(190 0) "R0")
dbCreateParamInstByMasterName(cv "tphn28hpcpgv18" "PDDW16SDGZ_V_G" "layout" "D8_bottom_0" list(130 0) "R0")
dbCreateParamInstByMasterName(cv "PAD" "PAD60GU" "layout" "pad60gu_D8_bottom_0" list(130 0) "R0")
dbCreateParamInstByMasterName(cv "tphn28hpcpgv18" "PCORNER_G" "layout" "CORNER_BL_bottom_left" list(0 0) "R0")
dbCreateParamInstByMasterName(cv "tphn28hpcpgv18" "PDDW16SDGZ_H_G" "layout" "D23_right_7" list(700 550) "R90")
dbCreateParamInstByMasterName(cv "PAD" "PAD60GU" "layout" "pad60gu_D23_right_7" list(700 550) "R90")
dbCreateParamInstByMasterName(cv "tphn28hpcpgv18" "PDDW16SDGZ_H_G" "layout" "D22_right_6" list(700 490) "R90")
dbCreateParamInstByMasterName(cv "PAD" "PAD60GU" "layout" "pad60gu_D22_right_6" list(700 490) "R90")
dbCreateParamInstByMasterName(cv "tphn28hpcpgv18" "PDDW16SDGZ_H_G" "layout" "D21_right_5" list(700 430) "R90")
dbCreateParamInstByMasterName(cv "PAD" "PAD60GU" "layout" "pad60gu_D21_right_5" list(700 430) "R90")
dbCreateParamInstByMasterName(cv "tphn28hpcpgv18" "PDDW16SDGZ_H_G" "layout" "D20_right_4" list(700 370) "R90")
dbCreateParamInstByMasterName(cv "PAD" "PAD60GU" "layout" "pad60gu_D20_right_4" list(700 370) "R90")
dbCreateParamInstByMasterName(cv "tphn28hpcpgv18" "PDDW16SDGZ_H_G" "layout" "D19_right_3" list(700 310) "R90")
dbCreateParamInstByMasterName(cv "PAD" "PAD60GU" "layout" "pad60gu_D19_right_3" list(700 310) "R90")
dbCreateParamInstByMasterName(cv "tphn28hpcpgv18" "PDDW16SDGZ_H_G" "layout" "D18_right_2" list(700 250) "R90")
dbCreateParamInstByMasterName(cv "PAD" "PAD60GU" "layout" "pad60gu_D18_right_2" list(700 250) "R90")
dbCreateParamInstByMasterName(cv "tphn28hpcpgv18" "PDDW16SDGZ_H_G" "layout" "D17_right_1" list(700 190) "R90")
dbCreateParamInstByMasterName(cv "PAD" "PAD60GU" "layout" "pad60gu_D17_right_1" list(700 190) "R90")
dbCreateParamInstByMasterName(cv "tphn28hpcpgv18" "PDDW16SDGZ_H_G" "layout" "D16_right_0" list(700 130) "R90")
dbCreateParamInstByMasterName(cv "PAD" "PAD60GU" "layout" "pad60gu_D16_right_0" list(700 130) "R90")
dbCreateParamInstByMasterName(cv "tphn28hpcpgv18" "PCORNER_G" "layout" "CORNER_BR_bottom_right" list(700 0) "R90")
dbCreateParamInstByMasterName(cv "tphn28hpcpgv18" "PVSS2DGZ_V_G" "layout" "GIOH_top_7" list(150 700) "R180")
dbCreateParamInstByMasterName(cv "PAD" "PAD60GU" "layout" "pad60gu_GIOH_top_7" list(150 700) "R180")
dbCreateParamInstByMasterName(cv "tphn28hpcpgv18" "PVDD2POC_V_G" "layout" "VIOH_top_6" list(210 700) "R180")
dbCreateParamInstByMasterName(cv "PAD" "PAD60GU" "layout" "pad60gu_VIOH_top_6" list(210 700) "R180")
dbCreateParamInstByMasterName(cv "tphn28hpcpgv18" "PVSS1DGZ_V_G" "layout" "GIOL_top_5" list(270 700) "R180")
dbCreateParamInstByMasterName(cv "PAD" "PAD60GU" "layout" "pad60gu_GIOL_top_5" list(270 700) "R180")
dbCreateParamInstByMasterName(cv "tphn28hpcpgv18" "PVDD1DGZ_V_G" "layout" "VIOL_top_4" list(330 700) "R180")
dbCreateParamInstByMasterName(cv "PAD" "PAD60GU" "layout" "pad60gu_VIOL_top_4" list(330 700) "R180")
dbCreateParamInstByMasterName(cv "tphn28hpcpgv18" "PDDW16SDGZ_V_G" "layout" "D27_top_3" list(390 700) "R180")
dbCreateParamInstByMasterName(cv "PAD" "PAD60GU" "layout" "pad60gu_D27_top_3" list(390 700) "R180")
dbCreateParamInstByMasterName(cv "tphn28hpcpgv18" "PDDW16SDGZ_V_G" "layout" "D26_top_2" list(450 700) "R180")
dbCreateParamInstByMasterName(cv "PAD" "PAD60GU" "layout" "pad60gu_D26_top_2" list(450 700) "R180")
dbCreateParamInstByMasterName(cv "tphn28hpcpgv18" "PDDW16SDGZ_V_G" "layout" "D25_top_1" list(510 700) "R180")
dbCreateParamInstByMasterName(cv "PAD" "PAD60GU" "layout" "pad60gu_D25_top_1" list(510 700) "R180")
dbCreateParamInstByMasterName(cv "tphn28hpcpgv18" "PDDW16SDGZ_V_G" "layout" "D24_top_0" list(570 700) "R180")
dbCreateParamInstByMasterName(cv "PAD" "PAD60GU" "layout" "pad60gu_D24_top_0" list(570 700) "R180")
dbCreateParamInstByMasterName(cv "tphn28hpcpgv18" "PCORNER_G" "layout" "CORNER_TR_top_right" list(700 700) "R180")

; ==================== Inner Ring Pads ====================
dbCreateParamInstByMasterName(cv "tphn28hpcpgv18" "PDDW16SDGZ_V_G" "layout" "inner_pad_D28_top_2_3" list(420 700) "R180")
dbCreateParamInstByMasterName(cv "PAD" "PAD60NU" "layout" "inner_pad60nu_D28_top_2_3" list(420 700) "R180")
dbCreateParamInstByMasterName(cv "tphn28hpcpgv18" "PDDW16SDGZ_V_G" "layout" "inner_pad_D29_top_3_4" list(360 700) "R180")
dbCreateParamInstByMasterName(cv "PAD" "PAD60NU" "layout" "inner_pad60nu_D29_top_3_4" list(360 700) "R180")

; ==================== Filler Components ====================
dbCreateParamInstByMasterName(cv "tphn28hpcpgv18" "PFILLER20_G" "layout" "sep_bottom_right_corner" list(570 0) "R0")
dbCreateParamInstByMasterName(cv "tphn28hpcpgv18" "PFILLER20_G" "layout" "filler_bottom_left_corner" list(110 0) "R0")
dbCreateParamInstByMasterName(cv "tphn28hpcpgv18" "PFILLER20_G" "layout" "filler_R0_1_1" list(530 0) "R0")
dbCreateParamInstByMasterName(cv "tphn28hpcpgv18" "PFILLER20_G" "layout" "filler_R0_1_2" list(510 0) "R0")
dbCreateParamInstByMasterName(cv "tphn28hpcpgv18" "PFILLER20_G" "layout" "filler_R0_2_1" list(470 0) "R0")
dbCreateParamInstByMasterName(cv "tphn28hpcpgv18" "PFILLER20_G" "layout" "filler_R0_2_2" list(450 0) "R0")
dbCreateParamInstByMasterName(cv "tphn28hpcpgv18" "PFILLER20_G" "layout" "filler_R0_3_1" list(410 0) "R0")
dbCreateParamInstByMasterName(cv "tphn28hpcpgv18" "PFILLER20_G" "layout" "filler_R0_3_2" list(390 0) "R0")
dbCreateParamInstByMasterName(cv "tphn28hpcpgv18" "PFILLER20_G" "layout" "filler_R0_4_1" list(350 0) "R0")
dbCreateParamInstByMasterName(cv "tphn28hpcpgv18" "PFILLER20_G" "layout" "filler_R0_4_2" list(330 0) "R0")
dbCreateParamInstByMasterName(cv "tphn28hpcpgv18" "PFILLER20_G" "layout" "filler_R0_5_1" list(290 0) "R0")
dbCreateParamInstByMasterName(cv "tphn28hpcpgv18" "PFILLER20_G" "layout" "filler_R0_5_2" list(270 0) "R0")
dbCreateParamInstByMasterName(cv "tphn28hpcpgv18" "PFILLER20_G" "layout" "filler_R0_6_1" list(230 0) "R0")
dbCreateParamInstByMasterName(cv "tphn28hpcpgv18" "PFILLER20_G" "layout" "filler_R0_6_2" list(210 0) "R0")
dbCreateParamInstByMasterName(cv "tphn28hpcpgv18" "PFILLER20_G" "layout" "filler_R0_7_1" list(170 0) "R0")
dbCreateParamInstByMasterName(cv "tphn28hpcpgv18" "PFILLER20_G" "layout" "filler_R0_7_2" list(150 0) "R0")
dbCreateParamInstByMasterName(cv "tphn28hpcpgv18" "PFILLER20_G" "layout" "filler_right_top_corner" list(700 570) "R90")
dbCreateParamInstByMasterName(cv "tphn28hpcpgv18" "PFILLER20_G" "layout" "filler_right_bottom_corner" list(700 110) "R90")
dbCreateParamInstByMasterName(cv "tphn28hpcpgv18" "PFILLER20_G" "layout" "filler_R90_1_1" list(700 530) "R90")
dbCreateParamInstByMasterName(cv "tphn28hpcpgv18" "PFILLER20_G" "layout" "filler_R90_1_2" list(700 510) "R90")
dbCreateParamInstByMasterName(cv "tphn28hpcpgv18" "PFILLER20_G" "layout" "filler_R90_2_1" list(700 470) "R90")
dbCreateParamInstByMasterName(cv "tphn28hpcpgv18" "PFILLER20_G" "layout" "filler_R90_2_2" list(700 450) "R90")
dbCreateParamInstByMasterName(cv "tphn28hpcpgv18" "PFILLER20_G" "layout" "filler_R90_3_1" list(700 410) "R90")
dbCreateParamInstByMasterName(cv "tphn28hpcpgv18" "PFILLER20_G" "layout" "filler_R90_3_2" list(700 390) "R90")
dbCreateParamInstByMasterName(cv "tphn28hpcpgv18" "PFILLER20_G" "layout" "filler_R90_4_1" list(700 350) "R90")
dbCreateParamInstByMasterName(cv "tphn28hpcpgv18" "PFILLER20_G" "layout" "filler_R90_4_2" list(700 330) "R90")
dbCreateParamInstByMasterName(cv "tphn28hpcpgv18" "PFILLER20_G" "layout" "filler_R90_5_1" list(700 290) "R90")
dbCreateParamInstByMasterName(cv "tphn28hpcpgv18" "PFILLER20_G" "layout" "filler_R90_5_2" list(700 270) "R90")
dbCreateParamInstByMasterName(cv "tphn28hpcpgv18" "PFILLER20_G" "layout" "filler_R90_6_1" list(700 230) "R90")
dbCreateParamInstByMasterName(cv "tphn28hpcpgv18" "PFILLER20_G" "layout" "filler_R90_6_2" list(700 210) "R90")
dbCreateParamInstByMasterName(cv "tphn28hpcpgv18" "PFILLER20_G" "layout" "filler_R90_7_1" list(700 170) "R90")
dbCreateParamInstByMasterName(cv "tphn28hpcpgv18" "PFILLER20_G" "layout" "filler_R90_7_2" list(700 150) "R90")
dbCreateParamInstByMasterName(cv "tphn28hpcpgv18" "PFILLER20_G" "layout" "sep_top_left_corner" list(130 700) "R180")
dbCreateParamInstByMasterName(cv "tphn28hpcpgv18" "PFILLER20_G" "layout" "filler_top_right_corner" list(590 700) "R180")
dbCreateParamInstByMasterName(cv "tphn28hpcpgv18" "PFILLER20_G" "layout" "filler_R180_1_1" list(170 700) "R180")
dbCreateParamInstByMasterName(cv "tphn28hpcpgv18" "PFILLER20_G" "layout" "filler_R180_1_2" list(190 700) "R180")
dbCreateParamInstByMasterName(cv "tphn28hpcpgv18" "PFILLER20_G" "layout" "filler_R180_2_1" list(230 700) "R180")
dbCreateParamInstByMasterName(cv "tphn28hpcpgv18" "PFILLER20_G" "layout" "filler_R180_2_2" list(250 700) "R180")
dbCreateParamInstByMasterName(cv "tphn28hpcpgv18" "PFILLER20_G" "layout" "filler_R180_3_1" list(290 700) "R180")
dbCreateParamInstByMasterName(cv "tphn28hpcpgv18" "PFILLER20_G" "layout" "filler_R180_3_2" list(310 700) "R180")
dbCreateParamInstByMasterName(cv "tphn28hpcpgv18" "PFILLER10_G" "layout" "filler_R180_4_1" list(340 700) "R180")
dbCreateParamInstByMasterName(cv "tphn28hpcpgv18" "PFILLER10_G" "layout" "filler_R180_4_2" list(370 700) "R180")
dbCreateParamInstByMasterName(cv "tphn28hpcpgv18" "PFILLER10_G" "layout" "filler_R180_5_1" list(400 700) "R180")
dbCreateParamInstByMasterName(cv "tphn28hpcpgv18" "PFILLER10_G" "layout" "filler_R180_5_2" list(430 700) "R180")
dbCreateParamInstByMasterName(cv "tphn28hpcpgv18" "PFILLER20_G" "layout" "filler_R180_6_1" list(470 700) "R180")
dbCreateParamInstByMasterName(cv "tphn28hpcpgv18" "PFILLER20_G" "layout" "filler_R180_6_2" list(490 700) "R180")
dbCreateParamInstByMasterName(cv "tphn28hpcpgv18" "PFILLER20_G" "layout" "filler_R180_7_1" list(530 700) "R180")
dbCreateParamInstByMasterName(cv "tphn28hpcpgv18" "PFILLER20_G" "layout" "filler_R180_7_2" list(550 700) "R180")
dbCreateParamInstByMasterName(cv "tphn28hpcpgv18" "PFILLER20_G" "layout" "filler_left_bottom_corner" list(0 130) "R270")
dbCreateParamInstByMasterName(cv "tphn28hpcpgv18" "PFILLER20_G" "layout" "sep_left_top_corner" list(0 590) "R270")
dbCreateParamInstByMasterName(cv "tphn28hpcpgv18" "PFILLER20_G" "layout" "filler_R270_1_1" list(0 170) "R270")
dbCreateParamInstByMasterName(cv "tphn28hpcpgv18" "PFILLER20_G" "layout" "filler_R270_1_2" list(0 190) "R270")
dbCreateParamInstByMasterName(cv "tphn28hpcpgv18" "PFILLER20_G" "layout" "filler_R270_2_1" list(0 230) "R270")
dbCreateParamInstByMasterName(cv "tphn28hpcpgv18" "PFILLER20_G" "layout" "filler_R270_2_2" list(0 250) "R270")
dbCreateParamInstByMasterName(cv "tphn28hpcpgv18" "PFILLER20_G" "layout" "filler_R270_3_1" list(0 290) "R270")
dbCreateParamInstByMasterName(cv "tphn28hpcpgv18" "PFILLER20_G" "layout" "filler_R270_3_2" list(0 310) "R270")
dbCreateParamInstByMasterName(cv "tphn28hpcpgv18" "PFILLER20_G" "layout" "filler_R270_4_1" list(0 350) "R270")
dbCreateParamInstByMasterName(cv "tphn28hpcpgv18" "PFILLER20_G" "layout" "filler_R270_4_2" list(0 370) "R270")
dbCreateParamInstByMasterName(cv "tphn28hpcpgv18" "PFILLER20_G" "layout" "filler_R270_5_1" list(0 410) "R270")
dbCreateParamInstByMasterName(cv "tphn28hpcpgv18" "PFILLER20_G" "layout" "filler_R270_5_2" list(0 430) "R270")
dbCreateParamInstByMasterName(cv "tphn28hpcpgv18" "PFILLER20_G" "layout" "filler_R270_6_1" list(0 470) "R270")
dbCreateParamInstByMasterName(cv "tphn28hpcpgv18" "PFILLER20_G" "layout" "filler_R270_6_2" list(0 490) "R270")
dbCreateParamInstByMasterName(cv "tphn28hpcpgv18" "PFILLER20_G" "layout" "filler_R270_7_1" list(0 530) "R270")
dbCreateParamInstByMasterName(cv "tphn28hpcpgv18" "PFILLER20_G" "layout" "filler_R270_7_2" list(0 550) "R270")

; ==================== Digital IO Features (with Inner Pad Support) ====================
dbCreatePath(cv list("M3" "drawing") list(list(130 110.5) list(570 110.5)) 0.2)
dbCreatePath(cv list("M3" "drawing") list(list(130 109.24) list(570 109.24)) 0.2)
dbCreatePath(cv list("M3" "drawing") list(list(589.5 130) list(589.5 570)) 0.2)
dbCreatePath(cv list("M3" "drawing") list(list(590.76 130) list(590.76 570)) 0.2)
dbCreatePath(cv list("M3" "drawing") list(list(130 589.5) list(570 589.5)) 0.2)
dbCreatePath(cv list("M3" "drawing") list(list(130 590.76) list(570 590.76)) 0.2)
dbCreatePath(cv list("M3" "drawing") list(list(110.5 130) list(110.5 570)) 0.2)
dbCreatePath(cv list("M3" "drawing") list(list(109.24 130) list(109.24 570)) 0.2)
dbCreatePath(cv list("M3" "drawing") list(list(130 589.5) list(110.5 589.5)) 0.2 "extendExtend")
dbCreatePath(cv list("M3" "drawing") list(list(110.5 589.5) list(110.5 570)) 0.2 "extendExtend")
dbCreatePath(cv list("M3" "drawing") list(list(130 590.76) list(109.24 590.76)) 0.2 "extendExtend")
dbCreatePath(cv list("M3" "drawing") list(list(109.24 590.76) list(109.24 570)) 0.2 "extendExtend")
dbCreatePath(cv list("M3" "drawing") list(list(570 589.5) list(589.5 589.5)) 0.2 "extendExtend")
dbCreatePath(cv list("M3" "drawing") list(list(589.5 589.5) list(589.5 570)) 0.2 "extendExtend")
dbCreatePath(cv list("M3" "drawing") list(list(570 590.76) list(590.76 590.76)) 0.2 "extendExtend")
dbCreatePath(cv list("M3" "drawing") list(list(590.76 590.76) list(590.76 570)) 0.2 "extendExtend")
dbCreatePath(cv list("M3" "drawing") list(list(130 110.5) list(110.5 110.5)) 0.2 "extendExtend")
dbCreatePath(cv list("M3" "drawing") list(list(110.5 110.5) list(110.5 130)) 0.2 "extendExtend")
dbCreatePath(cv list("M3" "drawing") list(list(130 109.24) list(109.24 109.24)) 0.2 "extendExtend")
dbCreatePath(cv list("M3" "drawing") list(list(109.24 109.24) list(109.24 130)) 0.2 "extendExtend")
dbCreatePath(cv list("M3" "drawing") list(list(570 110.5) list(589.5 110.5)) 0.2 "extendExtend")
dbCreatePath(cv list("M3" "drawing") list(list(589.5 110.5) list(589.5 130)) 0.2 "extendExtend")
dbCreatePath(cv list("M3" "drawing") list(list(570 109.24) list(590.76 109.24)) 0.2 "extendExtend")
dbCreatePath(cv list("M3" "drawing") list(list(590.76 109.24) list(590.76 130)) 0.2 "extendExtend")
dbCreatePath(cv list("M3" "drawing") list(list(327.655 589.88) list(327.655 589.5)) 0.2)
tech = techGetTechFile(cv)
viaParams = list(list("cutRows" 2) list("cutColumns" 4))
viaDefId = techFindViaDefByName(tech "M3_M2")
newVia = dbCreateVia(cv viaDefId list(327.655 589.88) "R180" viaParams)
dbCreatePath(cv list("M3" "drawing") list(list(267.61 589.88) list(267.61 590.76)) 0.2)
tech = techGetTechFile(cv)
viaParams = list(list("cutRows" 2) list("cutColumns" 4))
viaDefId = techFindViaDefByName(tech "M3_M2")
newVia = dbCreateVia(cv viaDefId list(267.61 589.88) "R180" viaParams)
dbCreatePath(cv list("M3" "drawing") list(list(109.875 559.8) list(110.5 559.8)) 0.26)
dbCreatePath(cv list("M3" "drawing") list(list(109.875 564.1) list(109.24 564.1)) 0.26)
dbCreateLabel(cv list("M4" "pin") list(109.875 568.275) "D0_CORE" "centerLeft" "R0" "roman" 2)
dbCreatePath(cv list("M3" "drawing") list(list(109.875 499.8) list(110.5 499.8)) 0.26)
dbCreatePath(cv list("M3" "drawing") list(list(109.875 504.1) list(109.24 504.1)) 0.26)
dbCreateLabel(cv list("M4" "pin") list(109.875 508.275) "D1_CORE" "centerLeft" "R0" "roman" 2)
dbCreatePath(cv list("M3" "drawing") list(list(109.875 439.8) list(110.5 439.8)) 0.26)
dbCreatePath(cv list("M3" "drawing") list(list(109.875 444.1) list(109.24 444.1)) 0.26)
dbCreateLabel(cv list("M4" "pin") list(109.875 448.275) "D2_CORE" "centerLeft" "R0" "roman" 2)
dbCreatePath(cv list("M3" "drawing") list(list(109.875 379.8) list(110.5 379.8)) 0.26)
dbCreatePath(cv list("M3" "drawing") list(list(109.875 384.1) list(109.24 384.1)) 0.26)
dbCreateLabel(cv list("M4" "pin") list(109.875 388.275) "D3_CORE" "centerLeft" "R0" "roman" 2)
dbCreatePath(cv list("M3" "drawing") list(list(109.875 319.8) list(110.5 319.8)) 0.26)
dbCreatePath(cv list("M3" "drawing") list(list(109.875 324.1) list(109.24 324.1)) 0.26)
dbCreateLabel(cv list("M4" "pin") list(109.875 328.275) "D4_CORE" "centerLeft" "R0" "roman" 2)
dbCreatePath(cv list("M3" "drawing") list(list(109.875 259.8) list(110.5 259.8)) 0.26)
dbCreatePath(cv list("M3" "drawing") list(list(109.875 264.1) list(109.24 264.1)) 0.26)
dbCreateLabel(cv list("M4" "pin") list(109.875 268.275) "D5_CORE" "centerLeft" "R0" "roman" 2)
dbCreatePath(cv list("M3" "drawing") list(list(109.875 199.8) list(110.5 199.8)) 0.26)
dbCreatePath(cv list("M3" "drawing") list(list(109.875 204.1) list(109.24 204.1)) 0.26)
dbCreateLabel(cv list("M4" "pin") list(109.875 208.275) "D6_CORE" "centerLeft" "R0" "roman" 2)
dbCreatePath(cv list("M3" "drawing") list(list(109.875 139.8) list(110.5 139.8)) 0.26)
dbCreatePath(cv list("M3" "drawing") list(list(109.875 144.1) list(109.24 144.1)) 0.26)
dbCreateLabel(cv list("M4" "pin") list(109.875 148.275) "D7_CORE" "centerLeft" "R0" "roman" 2)
dbCreatePath(cv list("M3" "drawing") list(list(140.2 109.875) list(140.2 110.5)) 0.26)
dbCreatePath(cv list("M3" "drawing") list(list(135.9 109.875) list(135.9 109.24)) 0.26)
dbCreateLabel(cv list("M4" "pin") list(131.725 109.875) "D8_CORE" "centerLeft" "R90" "roman" 2)
dbCreatePath(cv list("M3" "drawing") list(list(200.2 109.875) list(200.2 110.5)) 0.26)
dbCreatePath(cv list("M3" "drawing") list(list(195.9 109.875) list(195.9 109.24)) 0.26)
dbCreateLabel(cv list("M4" "pin") list(191.725 109.875) "D9_CORE" "centerLeft" "R90" "roman" 2)
dbCreatePath(cv list("M3" "drawing") list(list(260.2 109.875) list(260.2 110.5)) 0.26)
dbCreatePath(cv list("M3" "drawing") list(list(255.9 109.875) list(255.9 109.24)) 0.26)
dbCreateLabel(cv list("M4" "pin") list(251.725 109.875) "D10_CORE" "centerLeft" "R90" "roman" 2)
dbCreatePath(cv list("M3" "drawing") list(list(320.2 109.875) list(320.2 110.5)) 0.26)
dbCreatePath(cv list("M3" "drawing") list(list(315.9 109.875) list(315.9 109.24)) 0.26)
dbCreateLabel(cv list("M4" "pin") list(311.725 109.875) "D11_CORE" "centerLeft" "R90" "roman" 2)
dbCreatePath(cv list("M3" "drawing") list(list(380.2 109.875) list(380.2 110.5)) 0.26)
dbCreatePath(cv list("M3" "drawing") list(list(375.9 109.875) list(375.9 109.24)) 0.26)
dbCreateLabel(cv list("M4" "pin") list(371.725 109.875) "D12_CORE" "centerLeft" "R90" "roman" 2)
dbCreatePath(cv list("M3" "drawing") list(list(440.2 109.875) list(440.2 110.5)) 0.26)
dbCreatePath(cv list("M3" "drawing") list(list(435.9 109.875) list(435.9 109.24)) 0.26)
dbCreateLabel(cv list("M4" "pin") list(431.725 109.875) "D13_CORE" "centerLeft" "R90" "roman" 2)
dbCreatePath(cv list("M3" "drawing") list(list(500.2 109.875) list(500.2 110.5)) 0.26)
dbCreatePath(cv list("M3" "drawing") list(list(495.9 109.875) list(495.9 109.24)) 0.26)
dbCreateLabel(cv list("M4" "pin") list(491.725 109.875) "D14_CORE" "centerLeft" "R90" "roman" 2)
dbCreatePath(cv list("M3" "drawing") list(list(560.2 109.875) list(560.2 110.5)) 0.26)
dbCreatePath(cv list("M3" "drawing") list(list(555.9 109.875) list(555.9 109.24)) 0.26)
dbCreateLabel(cv list("M4" "pin") list(551.725 109.875) "D15_CORE" "centerLeft" "R90" "roman" 2)
dbCreatePath(cv list("M3" "drawing") list(list(589.5 140.2) list(590.125 140.2)) 0.26)
dbCreatePath(cv list("M3" "drawing") list(list(590.76 135.9) list(590.125 135.9)) 0.26)
dbCreateLabel(cv list("M4" "pin") list(590.125 131.725) "D16_CORE" "centerRight" "R0" "roman" 2)
dbCreatePath(cv list("M3" "drawing") list(list(589.5 200.2) list(590.125 200.2)) 0.26)
dbCreatePath(cv list("M3" "drawing") list(list(590.76 195.9) list(590.125 195.9)) 0.26)
dbCreateLabel(cv list("M4" "pin") list(590.125 191.725) "D17_CORE" "centerRight" "R0" "roman" 2)
dbCreatePath(cv list("M3" "drawing") list(list(589.5 260.2) list(590.125 260.2)) 0.26)
dbCreatePath(cv list("M3" "drawing") list(list(590.76 255.9) list(590.125 255.9)) 0.26)
dbCreateLabel(cv list("M4" "pin") list(590.125 251.725) "D18_CORE" "centerRight" "R0" "roman" 2)
dbCreatePath(cv list("M3" "drawing") list(list(589.5 320.2) list(590.125 320.2)) 0.26)
dbCreatePath(cv list("M3" "drawing") list(list(590.76 315.9) list(590.125 315.9)) 0.26)
dbCreateLabel(cv list("M4" "pin") list(590.125 311.725) "D19_CORE" "centerRight" "R0" "roman" 2)
dbCreatePath(cv list("M3" "drawing") list(list(589.5 380.2) list(590.125 380.2)) 0.26)
dbCreatePath(cv list("M3" "drawing") list(list(590.76 375.9) list(590.125 375.9)) 0.26)
dbCreateLabel(cv list("M4" "pin") list(590.125 371.725) "D20_CORE" "centerRight" "R0" "roman" 2)
dbCreatePath(cv list("M3" "drawing") list(list(589.5 440.2) list(590.125 440.2)) 0.26)
dbCreatePath(cv list("M3" "drawing") list(list(590.76 435.9) list(590.125 435.9)) 0.26)
dbCreateLabel(cv list("M4" "pin") list(590.125 431.725) "D21_CORE" "centerRight" "R0" "roman" 2)
dbCreatePath(cv list("M3" "drawing") list(list(589.5 500.2) list(590.125 500.2)) 0.26)
dbCreatePath(cv list("M3" "drawing") list(list(590.76 495.9) list(590.125 495.9)) 0.26)
dbCreateLabel(cv list("M4" "pin") list(590.125 491.725) "D22_CORE" "centerRight" "R0" "roman" 2)
dbCreatePath(cv list("M3" "drawing") list(list(589.5 560.2) list(590.125 560.2)) 0.26)
dbCreatePath(cv list("M3" "drawing") list(list(590.76 555.9) list(590.125 555.9)) 0.26)
dbCreateLabel(cv list("M4" "pin") list(590.125 551.725) "D23_CORE" "centerRight" "R0" "roman" 2)
dbCreatePath(cv list("M3" "drawing") list(list(559.8 590.125) list(559.8 589.5)) 0.26)
dbCreatePath(cv list("M3" "drawing") list(list(564.1 590.125) list(564.1 590.76)) 0.26)
dbCreateLabel(cv list("M4" "pin") list(568.275 590.125) "D24_CORE" "centerRight" "R90" "roman" 2)
dbCreatePath(cv list("M3" "drawing") list(list(499.8 590.125) list(499.8 589.5)) 0.26)
dbCreatePath(cv list("M3" "drawing") list(list(504.1 590.125) list(504.1 590.76)) 0.26)
dbCreateLabel(cv list("M4" "pin") list(508.275 590.125) "D25_CORE" "centerRight" "R90" "roman" 2)
dbCreatePath(cv list("M3" "drawing") list(list(439.8 590.125) list(439.8 589.5)) 0.26)
dbCreatePath(cv list("M3" "drawing") list(list(444.1 590.125) list(444.1 590.76)) 0.26)
dbCreateLabel(cv list("M4" "pin") list(448.275 590.125) "D26_CORE" "centerRight" "R90" "roman" 2)
dbCreatePath(cv list("M3" "drawing") list(list(379.8 590.125) list(379.8 589.5)) 0.26)
dbCreatePath(cv list("M3" "drawing") list(list(384.1 590.125) list(384.1 590.76)) 0.26)
dbCreateLabel(cv list("M4" "pin") list(388.275 590.125) "D27_CORE" "centerRight" "R90" "roman" 2)
dbCreatePath(cv list("M3" "drawing") list(list(409.8 590.125) list(409.8 589.5)) 0.26)
dbCreatePath(cv list("M3" "drawing") list(list(414.1 590.125) list(414.1 590.76)) 0.26)
dbCreateLabel(cv list("M4" "pin") list(418.275 590.125) "D28_CORE" "centerRight" "R90" "roman" 2)
dbCreatePath(cv list("M3" "drawing") list(list(349.8 590.125) list(349.8 589.5)) 0.26)
dbCreatePath(cv list("M3" "drawing") list(list(354.1 590.125) list(354.1 590.76)) 0.26)
dbCreateLabel(cv list("M4" "pin") list(358.275 590.125) "D29_CORE" "centerRight" "R90" "roman" 2)

; ==================== Pin Labels (with Inner Pad Support) ====================
dbCreateLabel(cv list("AP" "pin") list(-11 560) "D0" "centerRight" "R0" "roman" 10)
dbCreateLabel(cv list("AP" "pin") list(-11 500) "D1" "centerRight" "R0" "roman" 10)
dbCreateLabel(cv list("AP" "pin") list(-11 440) "D2" "centerRight" "R0" "roman" 10)
dbCreateLabel(cv list("AP" "pin") list(-11 380) "D3" "centerRight" "R0" "roman" 10)
dbCreateLabel(cv list("AP" "pin") list(-11 320) "D4" "centerRight" "R0" "roman" 10)
dbCreateLabel(cv list("AP" "pin") list(-11 260) "D5" "centerRight" "R0" "roman" 10)
dbCreateLabel(cv list("AP" "pin") list(-11 200) "D6" "centerRight" "R0" "roman" 10)
dbCreateLabel(cv list("AP" "pin") list(-11 140) "D7" "centerRight" "R0" "roman" 10)
dbCreateLabel(cv list("AP" "pin") list(140 -11) "D8" "centerRight" "R90" "roman" 10)
dbCreateLabel(cv list("AP" "pin") list(200 -11) "D9" "centerRight" "R90" "roman" 10)
dbCreateLabel(cv list("AP" "pin") list(260 -11) "D10" "centerRight" "R90" "roman" 10)
dbCreateLabel(cv list("AP" "pin") list(320 -11) "D11" "centerRight" "R90" "roman" 10)
dbCreateLabel(cv list("AP" "pin") list(380 -11) "D12" "centerRight" "R90" "roman" 10)
dbCreateLabel(cv list("AP" "pin") list(440 -11) "D13" "centerRight" "R90" "roman" 10)
dbCreateLabel(cv list("AP" "pin") list(500 -11) "D14" "centerRight" "R90" "roman" 10)
dbCreateLabel(cv list("AP" "pin") list(560 -11) "D15" "centerRight" "R90" "roman" 10)
dbCreateLabel(cv list("AP" "pin") list(711 140) "D16" "centerLeft" "R0" "roman" 10)
dbCreateLabel(cv list("AP" "pin") list(711 200) "D17" "centerLeft" "R0" "roman" 10)
dbCreateLabel(cv list("AP" "pin") list(711 260) "D18" "centerLeft" "R0" "roman" 10)
dbCreateLabel(cv list("AP" "pin") list(711 320) "D19" "centerLeft" "R0" "roman" 10)
dbCreateLabel(cv list("AP" "pin") list(711 380) "D20" "centerLeft" "R0" "roman" 10)
dbCreateLabel(cv list("AP" "pin") list(711 440) "D21" "centerLeft" "R0" "roman" 10)
dbCreateLabel(cv list("AP" "pin") list(711 500) "D22" "centerLeft" "R0" "roman" 10)
dbCreateLabel(cv list("AP" "pin") list(711 560) "D23" "centerLeft" "R0" "roman" 10)
dbCreateLabel(cv list("AP" "pin") list(560 711) "D24" "centerLeft" "R90" "roman" 10)
dbCreateLabel(cv list("AP" "pin") list(500 711) "D25" "centerLeft" "R90" "roman" 10)
dbCreateLabel(cv list("AP" "pin") list(440 711) "D26" "centerLeft" "R90" "roman" 10)
dbCreateLabel(cv list("AP" "pin") list(380 711) "D27" "centerLeft" "R90" "roman" 10)
dbCreateLabel(cv list("AP" "pin") list(320 711) "VIOL" "centerLeft" "R90" "roman" 10)
dbCreateLabel(cv list("AP" "pin") list(260 711) "GIOL" "centerLeft" "R90" "roman" 10)
dbCreateLabel(cv list("AP" "pin") list(200 711) "VIOH" "centerLeft" "R90" "roman" 10)
dbCreateLabel(cv list("AP" "pin") list(140 711) "GIOH" "centerLeft" "R90" "roman" 10)
dbCreateLabel(cv list("AP" "pin") list(410 548) "D28" "centerRight" "R90" "roman" 10)
dbCreateLabel(cv list("AP" "pin") list(350 548) "D29" "centerRight" "R90" "roman" 10)

dbSave(cv)
t
