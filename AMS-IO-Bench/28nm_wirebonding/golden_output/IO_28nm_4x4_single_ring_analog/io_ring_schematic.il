pdb3ac_h_gMaster = dbOpenCellView("tphn28hpcpgv18" "PDB3AC_H_G" "symbol")
dbCreateInst(cv pdb3ac_h_gMaster "VINP_left0" '(0 8.8125) "R270")
schCreateWire(cv "route" "full" '((0.000 9.001) (-0.750 9.001)) 0 0 0 nil nil)
schCreateWireLabel(cv nil '(-0.250 9.001) "VINP" "lowerRight" "R0" "stick" 0.0625 nil)
schCreatePin(cv nil "VINP" "inputOutput" nil '(-0.750 9.001) "R0")
schCreateWire(cv "route" "full" '((0.875 9.062) (1.625 9.062)) 0 0 0 nil nil)
schCreateWireLabel(cv nil '(1.125 9.062) "AVSS" "lowerLeft" "R0" "stick" 0.0625 nil)
schCreateWire(cv "route" "full" '((0.875 8.688) (1.625 8.688)) 0 0 0 nil nil)
schCreateWireLabel(cv nil '(1.125 8.688) "GIOL" "lowerLeft" "R0" "stick" 0.0625 nil)
schCreateWire(cv "route" "full" '((0.875 9.438) (1.625 9.438)) 0 0 0 nil nil)
schCreateWireLabel(cv nil '(1.125 9.438) "AVDD" "lowerLeft" "R0" "stick" 0.0625 nil)
dbCreateInst(cv pdb3ac_h_gMaster "VINN_left1" '(0 6.8125) "R270")
schCreateWire(cv "route" "full" '((0.000 7.000) (-0.750 7.000)) 0 0 0 nil nil)
schCreateWireLabel(cv nil '(-0.250 7.000) "VINN" "lowerRight" "R0" "stick" 0.0625 nil)
schCreatePin(cv nil "VINN" "inputOutput" nil '(-0.750 7.000) "R0")
schCreateWire(cv "route" "full" '((0.875 7.062) (1.625 7.062)) 0 0 0 nil nil)
schCreateWireLabel(cv nil '(1.125 7.062) "AVSS" "lowerLeft" "R0" "stick" 0.0625 nil)
schCreateWire(cv "route" "full" '((0.875 6.688) (1.625 6.688)) 0 0 0 nil nil)
schCreateWireLabel(cv nil '(1.125 6.688) "GIOL" "lowerLeft" "R0" "stick" 0.0625 nil)
schCreateWire(cv "route" "full" '((0.875 7.438) (1.625 7.438)) 0 0 0 nil nil)
schCreateWireLabel(cv nil '(1.125 7.438) "AVDD" "lowerLeft" "R0" "stick" 0.0625 nil)
dbCreateInst(cv pdb3ac_h_gMaster "VIP_left2" '(0 4.8125) "R270")
schCreateWire(cv "route" "full" '((0.000 5.000) (-0.750 5.000)) 0 0 0 nil nil)
schCreateWireLabel(cv nil '(-0.250 5.000) "VIP" "lowerRight" "R0" "stick" 0.0625 nil)
schCreatePin(cv nil "VIP" "inputOutput" nil '(-0.750 5.000) "R0")
schCreateWire(cv "route" "full" '((0.875 5.062) (1.625 5.062)) 0 0 0 nil nil)
schCreateWireLabel(cv nil '(1.125 5.062) "AVSS" "lowerLeft" "R0" "stick" 0.0625 nil)
schCreateWire(cv "route" "full" '((0.875 4.688) (1.625 4.688)) 0 0 0 nil nil)
schCreateWireLabel(cv nil '(1.125 4.688) "GIOL" "lowerLeft" "R0" "stick" 0.0625 nil)
schCreateWire(cv "route" "full" '((0.875 5.438) (1.625 5.438)) 0 0 0 nil nil)
schCreateWireLabel(cv nil '(1.125 5.438) "AVDD" "lowerLeft" "R0" "stick" 0.0625 nil)
dbCreateInst(cv pdb3ac_h_gMaster "VIM_left3" '(0 2.8125) "R270")
schCreateWire(cv "route" "full" '((0.000 3.001) (-0.750 3.001)) 0 0 0 nil nil)
schCreateWireLabel(cv nil '(-0.250 3.001) "VIM" "lowerRight" "R0" "stick" 0.0625 nil)
schCreatePin(cv nil "VIM" "inputOutput" nil '(-0.750 3.001) "R0")
schCreateWire(cv "route" "full" '((0.875 3.062) (1.625 3.062)) 0 0 0 nil nil)
schCreateWireLabel(cv nil '(1.125 3.062) "AVSS" "lowerLeft" "R0" "stick" 0.0625 nil)
schCreateWire(cv "route" "full" '((0.875 2.688) (1.625 2.688)) 0 0 0 nil nil)
schCreateWireLabel(cv nil '(1.125 2.688) "GIOL" "lowerLeft" "R0" "stick" 0.0625 nil)
schCreateWire(cv "route" "full" '((0.875 3.438) (1.625 3.438)) 0 0 0 nil nil)
schCreateWireLabel(cv nil '(1.125 3.438) "AVDD" "lowerLeft" "R0" "stick" 0.0625 nil)
pdb3ac_v_gMaster = dbOpenCellView("tphn28hpcpgv18" "PDB3AC_V_G" "symbol")
dbCreateInst(cv pdb3ac_v_gMaster "VCM_bottom0" '(3.1875 0) "R0")
schCreateWire(cv "route" "full" '((2.999 0.000) (2.999 -0.750)) 0 0 0 nil nil)
schCreateWireLabel(cv nil '(2.999 -0.250) "VCM" "lowerRight" "R90" "stick" 0.0625 nil)
schCreatePin(cv nil "VCM" "inputOutput" nil '(2.999 -0.750) "R90")
schCreateWire(cv "route" "full" '((2.938 0.875) (2.938 1.625)) 0 0 0 nil nil)
schCreateWireLabel(cv nil '(2.938 1.125) "AVSS" "lowerLeft" "R90" "stick" 0.0625 nil)
schCreateWire(cv "route" "full" '((3.312 0.875) (3.312 1.625)) 0 0 0 nil nil)
schCreateWireLabel(cv nil '(3.312 1.125) "GIOL" "lowerLeft" "R90" "stick" 0.0625 nil)
schCreateWire(cv "route" "full" '((2.562 0.875) (2.562 1.625)) 0 0 0 nil nil)
schCreateWireLabel(cv nil '(2.562 1.125) "AVDD" "lowerLeft" "R90" "stick" 0.0625 nil)
dbCreateInst(cv pdb3ac_v_gMaster "VREF_bottom1" '(5.1875 0) "R0")
schCreateWire(cv "route" "full" '((5.000 0.000) (5.000 -0.750)) 0 0 0 nil nil)
schCreateWireLabel(cv nil '(5.000 -0.250) "VREF" "lowerRight" "R90" "stick" 0.0625 nil)
schCreatePin(cv nil "VREF" "inputOutput" nil '(5.000 -0.750) "R90")
schCreateWire(cv "route" "full" '((4.938 0.875) (4.938 1.625)) 0 0 0 nil nil)
schCreateWireLabel(cv nil '(4.938 1.125) "AVSS" "lowerLeft" "R90" "stick" 0.0625 nil)
schCreateWire(cv "route" "full" '((5.312 0.875) (5.312 1.625)) 0 0 0 nil nil)
schCreateWireLabel(cv nil '(5.312 1.125) "GIOL" "lowerLeft" "R90" "stick" 0.0625 nil)
schCreateWire(cv "route" "full" '((4.562 0.875) (4.562 1.625)) 0 0 0 nil nil)
schCreateWireLabel(cv nil '(4.562 1.125) "AVDD" "lowerLeft" "R90" "stick" 0.0625 nil)
pvdd3ac_v_gMaster = dbOpenCellView("tphn28hpcpgv18" "PVDD3AC_V_G" "symbol")
dbCreateInst(cv pvdd3ac_v_gMaster "AVDD_bottom2" '(7.1875 0) "R0")
schCreateWire(cv "route" "full" '((6.562 0.875) (6.562 1.625)) 0 0 0 nil nil)
schCreateWireLabel(cv nil '(6.562 1.125) "AVDD_CORE" "lowerLeft" "R90" "stick" 0.0625 nil)
schCreatePin(cv nil "AVDD_CORE" "inputOutput" nil '(6.562 1.625) "R270")
schCreateWire(cv "route" "full" '((6.938 0.875) (6.938 1.625)) 0 0 0 nil nil)
schCreateWireLabel(cv nil '(6.938 1.125) "AVSS" "lowerLeft" "R90" "stick" 0.0625 nil)
schCreateWire(cv "route" "full" '((7.312 0.875) (7.312 1.625)) 0 0 0 nil nil)
schCreateWireLabel(cv nil '(7.312 1.125) "GIOL" "lowerLeft" "R90" "stick" 0.0625 nil)
schCreateWire(cv "route" "full" '((7.000 0.000) (7.000 -0.750)) 0 0 0 nil nil)
schCreateWireLabel(cv nil '(7.000 -0.250) "AVDD" "lowerRight" "R90" "stick" 0.0625 nil)
schCreatePin(cv nil "AVDD" "inputOutput" nil '(7.000 -0.750) "R90")
pvss3ac_v_gMaster = dbOpenCellView("tphn28hpcpgv18" "PVSS3AC_V_G" "symbol")
dbCreateInst(cv pvss3ac_v_gMaster "AVSS_bottom3" '(9.1875 0) "R0")
schCreateWire(cv "route" "full" '((8.999 0.000) (8.999 -0.750)) 0 0 0 nil nil)
schCreateWireLabel(cv nil '(8.999 -0.250) "AVSS" "lowerRight" "R90" "stick" 0.0625 nil)
schCreatePin(cv nil "AVSS" "inputOutput" nil '(8.999 -0.750) "R90")
schCreateWire(cv "route" "full" '((9.312 0.875) (9.312 1.625)) 0 0 0 nil nil)
schCreateWireLabel(cv nil '(9.312 1.125) "GIOL" "lowerLeft" "R90" "stick" 0.0625 nil)
schCreateWire(cv "route" "full" '((8.562 0.875) (8.562 1.625)) 0 0 0 nil nil)
schCreateWireLabel(cv nil '(8.562 1.125) "AVSS_CORE" "lowerLeft" "R90" "stick" 0.0625 nil)
schCreatePin(cv nil "AVSS_CORE" "inputOutput" nil '(8.562 1.625) "R270")
schCreateWire(cv "route" "full" '((8.938 0.875) (8.938 1.625)) 0 0 0 nil nil)
schCreateWireLabel(cv nil '(8.938 1.125) "AVDD" "lowerLeft" "R90" "stick" 0.0625 nil)
dbCreateInst(cv pdb3ac_h_gMaster "IB0_right0" '(12.0 3.1875) "R90")
schCreateWire(cv "route" "full" '((12.000 2.999) (12.750 2.999)) 0 0 0 nil nil)
schCreateWireLabel(cv nil '(12.250 2.999) "IB0" "lowerLeft" "R0" "stick" 0.0625 nil)
schCreatePin(cv nil "IB0" "inputOutput" nil '(12.750 2.999) "R180")
schCreateWire(cv "route" "full" '((11.125 2.938) (10.375 2.938)) 0 0 0 nil nil)
schCreateWireLabel(cv nil '(10.875 2.938) "AVSS" "lowerRight" "R0" "stick" 0.0625 nil)
schCreateWire(cv "route" "full" '((11.125 3.312) (10.375 3.312)) 0 0 0 nil nil)
schCreateWireLabel(cv nil '(10.875 3.312) "GIOL" "lowerRight" "R0" "stick" 0.0625 nil)
schCreateWire(cv "route" "full" '((11.125 2.562) (10.375 2.562)) 0 0 0 nil nil)
schCreateWireLabel(cv nil '(10.875 2.562) "AVDD" "lowerRight" "R0" "stick" 0.0625 nil)
dbCreateInst(cv pdb3ac_h_gMaster "IB1_right1" '(12.0 5.1875) "R90")
schCreateWire(cv "route" "full" '((12.000 5.000) (12.750 5.000)) 0 0 0 nil nil)
schCreateWireLabel(cv nil '(12.250 5.000) "IB1" "lowerLeft" "R0" "stick" 0.0625 nil)
schCreatePin(cv nil "IB1" "inputOutput" nil '(12.750 5.000) "R180")
schCreateWire(cv "route" "full" '((11.125 4.938) (10.375 4.938)) 0 0 0 nil nil)
schCreateWireLabel(cv nil '(10.875 4.938) "AVSS" "lowerRight" "R0" "stick" 0.0625 nil)
schCreateWire(cv "route" "full" '((11.125 5.312) (10.375 5.312)) 0 0 0 nil nil)
schCreateWireLabel(cv nil '(10.875 5.312) "GIOL" "lowerRight" "R0" "stick" 0.0625 nil)
schCreateWire(cv "route" "full" '((11.125 4.562) (10.375 4.562)) 0 0 0 nil nil)
schCreateWireLabel(cv nil '(10.875 4.562) "AVDD" "lowerRight" "R0" "stick" 0.0625 nil)
dbCreateInst(cv pdb3ac_h_gMaster "IB2_right2" '(12.0 7.1875) "R90")
schCreateWire(cv "route" "full" '((12.000 7.000) (12.750 7.000)) 0 0 0 nil nil)
schCreateWireLabel(cv nil '(12.250 7.000) "IB2" "lowerLeft" "R0" "stick" 0.0625 nil)
schCreatePin(cv nil "IB2" "inputOutput" nil '(12.750 7.000) "R180")
schCreateWire(cv "route" "full" '((11.125 6.938) (10.375 6.938)) 0 0 0 nil nil)
schCreateWireLabel(cv nil '(10.875 6.938) "AVSS" "lowerRight" "R0" "stick" 0.0625 nil)
schCreateWire(cv "route" "full" '((11.125 7.312) (10.375 7.312)) 0 0 0 nil nil)
schCreateWireLabel(cv nil '(10.875 7.312) "GIOL" "lowerRight" "R0" "stick" 0.0625 nil)
schCreateWire(cv "route" "full" '((11.125 6.562) (10.375 6.562)) 0 0 0 nil nil)
schCreateWireLabel(cv nil '(10.875 6.562) "AVDD" "lowerRight" "R0" "stick" 0.0625 nil)
dbCreateInst(cv pdb3ac_h_gMaster "IB3_right3" '(12.0 9.1875) "R90")
schCreateWire(cv "route" "full" '((12.000 8.999) (12.750 8.999)) 0 0 0 nil nil)
schCreateWireLabel(cv nil '(12.250 8.999) "IB3" "lowerLeft" "R0" "stick" 0.0625 nil)
schCreatePin(cv nil "IB3" "inputOutput" nil '(12.750 8.999) "R180")
schCreateWire(cv "route" "full" '((11.125 8.938) (10.375 8.938)) 0 0 0 nil nil)
schCreateWireLabel(cv nil '(10.875 8.938) "AVSS" "lowerRight" "R0" "stick" 0.0625 nil)
schCreateWire(cv "route" "full" '((11.125 9.312) (10.375 9.312)) 0 0 0 nil nil)
schCreateWireLabel(cv nil '(10.875 9.312) "GIOL" "lowerRight" "R0" "stick" 0.0625 nil)
schCreateWire(cv "route" "full" '((11.125 8.562) (10.375 8.562)) 0 0 0 nil nil)
schCreateWireLabel(cv nil '(10.875 8.562) "AVDD" "lowerRight" "R0" "stick" 0.0625 nil)
dbCreateInst(cv pdb3ac_v_gMaster "IBIAS_top0" '(8.8125 12.0) "R180")
schCreateWire(cv "route" "full" '((9.001 12.000) (9.001 12.750)) 0 0 0 nil nil)
schCreateWireLabel(cv nil '(9.001 12.250) "IBIAS" "lowerLeft" "R90" "stick" 0.0625 nil)
schCreatePin(cv nil "IBIAS" "inputOutput" nil '(9.001 12.750) "R270")
schCreateWire(cv "route" "full" '((9.062 11.125) (9.062 10.375)) 0 0 0 nil nil)
schCreateWireLabel(cv nil '(9.062 10.875) "AVSS" "lowerRight" "R90" "stick" 0.0625 nil)
schCreateWire(cv "route" "full" '((8.688 11.125) (8.688 10.375)) 0 0 0 nil nil)
schCreateWireLabel(cv nil '(8.688 10.875) "GIOL" "lowerRight" "R90" "stick" 0.0625 nil)
schCreateWire(cv "route" "full" '((9.438 11.125) (9.438 10.375)) 0 0 0 nil nil)
schCreateWireLabel(cv nil '(9.438 10.875) "AVDD" "lowerRight" "R90" "stick" 0.0625 nil)
dbCreateInst(cv pdb3ac_v_gMaster "IBIAS2_top1" '(6.8125 12.0) "R180")
schCreateWire(cv "route" "full" '((7.000 12.000) (7.000 12.750)) 0 0 0 nil nil)
schCreateWireLabel(cv nil '(7.000 12.250) "IBIAS2" "lowerLeft" "R90" "stick" 0.0625 nil)
schCreatePin(cv nil "IBIAS2" "inputOutput" nil '(7.000 12.750) "R270")
schCreateWire(cv "route" "full" '((7.062 11.125) (7.062 10.375)) 0 0 0 nil nil)
schCreateWireLabel(cv nil '(7.062 10.875) "AVSS" "lowerRight" "R90" "stick" 0.0625 nil)
schCreateWire(cv "route" "full" '((6.688 11.125) (6.688 10.375)) 0 0 0 nil nil)
schCreateWireLabel(cv nil '(6.688 10.875) "GIOL" "lowerRight" "R90" "stick" 0.0625 nil)
schCreateWire(cv "route" "full" '((7.438 11.125) (7.438 10.375)) 0 0 0 nil nil)
schCreateWireLabel(cv nil '(7.438 10.875) "AVDD" "lowerRight" "R90" "stick" 0.0625 nil)
dbCreateInst(cv pdb3ac_v_gMaster "VAMP_top2" '(4.8125 12.0) "R180")
schCreateWire(cv "route" "full" '((5.000 12.000) (5.000 12.750)) 0 0 0 nil nil)
schCreateWireLabel(cv nil '(5.000 12.250) "VAMP" "lowerLeft" "R90" "stick" 0.0625 nil)
schCreatePin(cv nil "VAMP" "inputOutput" nil '(5.000 12.750) "R270")
schCreateWire(cv "route" "full" '((5.062 11.125) (5.062 10.375)) 0 0 0 nil nil)
schCreateWireLabel(cv nil '(5.062 10.875) "AVSS" "lowerRight" "R90" "stick" 0.0625 nil)
schCreateWire(cv "route" "full" '((4.688 11.125) (4.688 10.375)) 0 0 0 nil nil)
schCreateWireLabel(cv nil '(4.688 10.875) "GIOL" "lowerRight" "R90" "stick" 0.0625 nil)
schCreateWire(cv "route" "full" '((5.438 11.125) (5.438 10.375)) 0 0 0 nil nil)
schCreateWireLabel(cv nil '(5.438 10.875) "AVDD" "lowerRight" "R90" "stick" 0.0625 nil)
dbCreateInst(cv pdb3ac_v_gMaster "VAMP2_top3" '(2.8125 12.0) "R180")
schCreateWire(cv "route" "full" '((3.001 12.000) (3.001 12.750)) 0 0 0 nil nil)
schCreateWireLabel(cv nil '(3.001 12.250) "VAMP2" "lowerLeft" "R90" "stick" 0.0625 nil)
schCreatePin(cv nil "VAMP2" "inputOutput" nil '(3.001 12.750) "R270")
schCreateWire(cv "route" "full" '((3.062 11.125) (3.062 10.375)) 0 0 0 nil nil)
schCreateWireLabel(cv nil '(3.062 10.875) "AVSS" "lowerRight" "R90" "stick" 0.0625 nil)
schCreateWire(cv "route" "full" '((2.688 11.125) (2.688 10.375)) 0 0 0 nil nil)
schCreateWireLabel(cv nil '(2.688 10.875) "GIOL" "lowerRight" "R90" "stick" 0.0625 nil)
schCreateWire(cv "route" "full" '((3.438 11.125) (3.438 10.375)) 0 0 0 nil nil)
schCreateWireLabel(cv nil '(3.438 10.875) "AVDD" "lowerRight" "R90" "stick" 0.0625 nil)
schCheck(cv)
dbSave(cv)
t
