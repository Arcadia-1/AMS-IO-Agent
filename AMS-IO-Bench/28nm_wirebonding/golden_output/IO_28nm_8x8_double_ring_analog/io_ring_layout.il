; Generated Layout Script with Dual Ring Support

; ==================== All Components (Sorted by Placement Order) ====================
dbCreateParamInstByMasterName(cv "tphn28hpcpgv18" "PVSS3AC_H_G" "layout" "AVSS_left_7" list(0 150) "R270")
dbCreateParamInstByMasterName(cv "PAD" "PAD60GU" "layout" "pad60gu_AVSS_left_7" list(0 150) "R270")
dbCreateParamInstByMasterName(cv "tphn28hpcpgv18" "PVDD3AC_H_G" "layout" "AVDD_left_6" list(0 210) "R270")
dbCreateParamInstByMasterName(cv "PAD" "PAD60GU" "layout" "pad60gu_AVDD_left_6" list(0 210) "R270")
dbCreateParamInstByMasterName(cv "tphn28hpcpgv18" "PDB3AC_H_G" "layout" "VREF_left_5" list(0 270) "R270")
dbCreateParamInstByMasterName(cv "PAD" "PAD60GU" "layout" "pad60gu_VREF_left_5" list(0 270) "R270")
dbCreateParamInstByMasterName(cv "tphn28hpcpgv18" "PDB3AC_H_G" "layout" "VCM_left_4" list(0 330) "R270")
dbCreateParamInstByMasterName(cv "PAD" "PAD60GU" "layout" "pad60gu_VCM_left_4" list(0 330) "R270")
dbCreateParamInstByMasterName(cv "tphn28hpcpgv18" "PDB3AC_H_G" "layout" "VIM_left_3" list(0 390) "R270")
dbCreateParamInstByMasterName(cv "PAD" "PAD60GU" "layout" "pad60gu_VIM_left_3" list(0 390) "R270")
dbCreateParamInstByMasterName(cv "tphn28hpcpgv18" "PDB3AC_H_G" "layout" "VIP_left_2" list(0 450) "R270")
dbCreateParamInstByMasterName(cv "PAD" "PAD60GU" "layout" "pad60gu_VIP_left_2" list(0 450) "R270")
dbCreateParamInstByMasterName(cv "tphn28hpcpgv18" "PDB3AC_H_G" "layout" "VINN_left_1" list(0 510) "R270")
dbCreateParamInstByMasterName(cv "PAD" "PAD60GU" "layout" "pad60gu_VINN_left_1" list(0 510) "R270")
dbCreateParamInstByMasterName(cv "tphn28hpcpgv18" "PDB3AC_H_G" "layout" "VINP_left_0" list(0 570) "R270")
dbCreateParamInstByMasterName(cv "PAD" "PAD60GU" "layout" "pad60gu_VINP_left_0" list(0 570) "R270")
dbCreateParamInstByMasterName(cv "tphn28hpcpgv18" "PCORNERA_G" "layout" "CORNER_TL_top_left" list(0 700) "R270")
dbCreateParamInstByMasterName(cv "tphn28hpcpgv18" "PDB3AC_V_G" "layout" "VAMP2_bottom_7" list(550 0) "R0")
dbCreateParamInstByMasterName(cv "PAD" "PAD60GU" "layout" "pad60gu_VAMP2_bottom_7" list(550 0) "R0")
dbCreateParamInstByMasterName(cv "tphn28hpcpgv18" "PDB3AC_V_G" "layout" "VAMP_bottom_6" list(490 0) "R0")
dbCreateParamInstByMasterName(cv "PAD" "PAD60GU" "layout" "pad60gu_VAMP_bottom_6" list(490 0) "R0")
dbCreateParamInstByMasterName(cv "tphn28hpcpgv18" "PDB3AC_V_G" "layout" "IBIAS2_bottom_5" list(430 0) "R0")
dbCreateParamInstByMasterName(cv "PAD" "PAD60GU" "layout" "pad60gu_IBIAS2_bottom_5" list(430 0) "R0")
dbCreateParamInstByMasterName(cv "tphn28hpcpgv18" "PDB3AC_V_G" "layout" "IBIAS_bottom_4" list(370 0) "R0")
dbCreateParamInstByMasterName(cv "PAD" "PAD60GU" "layout" "pad60gu_IBIAS_bottom_4" list(370 0) "R0")
dbCreateParamInstByMasterName(cv "tphn28hpcpgv18" "PDB3AC_V_G" "layout" "VREF4_bottom_3" list(310 0) "R0")
dbCreateParamInstByMasterName(cv "PAD" "PAD60GU" "layout" "pad60gu_VREF4_bottom_3" list(310 0) "R0")
dbCreateParamInstByMasterName(cv "tphn28hpcpgv18" "PDB3AC_V_G" "layout" "VREF3_bottom_2" list(250 0) "R0")
dbCreateParamInstByMasterName(cv "PAD" "PAD60GU" "layout" "pad60gu_VREF3_bottom_2" list(250 0) "R0")
dbCreateParamInstByMasterName(cv "tphn28hpcpgv18" "PDB3AC_V_G" "layout" "VREF2_bottom_1" list(190 0) "R0")
dbCreateParamInstByMasterName(cv "PAD" "PAD60GU" "layout" "pad60gu_VREF2_bottom_1" list(190 0) "R0")
dbCreateParamInstByMasterName(cv "tphn28hpcpgv18" "PDB3AC_V_G" "layout" "VREF1_bottom_0" list(130 0) "R0")
dbCreateParamInstByMasterName(cv "PAD" "PAD60GU" "layout" "pad60gu_VREF1_bottom_0" list(130 0) "R0")
dbCreateParamInstByMasterName(cv "tphn28hpcpgv18" "PCORNERA_G" "layout" "CORNER_BL_bottom_left" list(0 0) "R0")
dbCreateParamInstByMasterName(cv "tphn28hpcpgv18" "PDB3AC_H_G" "layout" "VAMP10_right_7" list(700 550) "R90")
dbCreateParamInstByMasterName(cv "PAD" "PAD60GU" "layout" "pad60gu_VAMP10_right_7" list(700 550) "R90")
dbCreateParamInstByMasterName(cv "tphn28hpcpgv18" "PDB3AC_H_G" "layout" "VAMP9_right_6" list(700 490) "R90")
dbCreateParamInstByMasterName(cv "PAD" "PAD60GU" "layout" "pad60gu_VAMP9_right_6" list(700 490) "R90")
dbCreateParamInstByMasterName(cv "tphn28hpcpgv18" "PDB3AC_H_G" "layout" "VAMP8_right_5" list(700 430) "R90")
dbCreateParamInstByMasterName(cv "PAD" "PAD60GU" "layout" "pad60gu_VAMP8_right_5" list(700 430) "R90")
dbCreateParamInstByMasterName(cv "tphn28hpcpgv18" "PDB3AC_H_G" "layout" "VAMP7_right_4" list(700 370) "R90")
dbCreateParamInstByMasterName(cv "PAD" "PAD60GU" "layout" "pad60gu_VAMP7_right_4" list(700 370) "R90")
dbCreateParamInstByMasterName(cv "tphn28hpcpgv18" "PDB3AC_H_G" "layout" "VAMP6_right_3" list(700 310) "R90")
dbCreateParamInstByMasterName(cv "PAD" "PAD60GU" "layout" "pad60gu_VAMP6_right_3" list(700 310) "R90")
dbCreateParamInstByMasterName(cv "tphn28hpcpgv18" "PDB3AC_H_G" "layout" "VAMP5_right_2" list(700 250) "R90")
dbCreateParamInstByMasterName(cv "PAD" "PAD60GU" "layout" "pad60gu_VAMP5_right_2" list(700 250) "R90")
dbCreateParamInstByMasterName(cv "tphn28hpcpgv18" "PDB3AC_H_G" "layout" "VAMP4_right_1" list(700 190) "R90")
dbCreateParamInstByMasterName(cv "PAD" "PAD60GU" "layout" "pad60gu_VAMP4_right_1" list(700 190) "R90")
dbCreateParamInstByMasterName(cv "tphn28hpcpgv18" "PDB3AC_H_G" "layout" "VAMP3_right_0" list(700 130) "R90")
dbCreateParamInstByMasterName(cv "PAD" "PAD60GU" "layout" "pad60gu_VAMP3_right_0" list(700 130) "R90")
dbCreateParamInstByMasterName(cv "tphn28hpcpgv18" "PCORNERA_G" "layout" "CORNER_BR_bottom_right" list(700 0) "R90")
dbCreateParamInstByMasterName(cv "tphn28hpcpgv18" "PDB3AC_V_G" "layout" "VAMP18_top_7" list(150 700) "R180")
dbCreateParamInstByMasterName(cv "PAD" "PAD60GU" "layout" "pad60gu_VAMP18_top_7" list(150 700) "R180")
dbCreateParamInstByMasterName(cv "tphn28hpcpgv18" "PDB3AC_V_G" "layout" "VAMP17_top_6" list(210 700) "R180")
dbCreateParamInstByMasterName(cv "PAD" "PAD60GU" "layout" "pad60gu_VAMP17_top_6" list(210 700) "R180")
dbCreateParamInstByMasterName(cv "tphn28hpcpgv18" "PDB3AC_V_G" "layout" "VAMP16_top_5" list(270 700) "R180")
dbCreateParamInstByMasterName(cv "PAD" "PAD60GU" "layout" "pad60gu_VAMP16_top_5" list(270 700) "R180")
dbCreateParamInstByMasterName(cv "tphn28hpcpgv18" "PDB3AC_V_G" "layout" "VAMP15_top_4" list(330 700) "R180")
dbCreateParamInstByMasterName(cv "PAD" "PAD60GU" "layout" "pad60gu_VAMP15_top_4" list(330 700) "R180")
dbCreateParamInstByMasterName(cv "tphn28hpcpgv18" "PDB3AC_V_G" "layout" "VAMP14_top_3" list(390 700) "R180")
dbCreateParamInstByMasterName(cv "PAD" "PAD60GU" "layout" "pad60gu_VAMP14_top_3" list(390 700) "R180")
dbCreateParamInstByMasterName(cv "tphn28hpcpgv18" "PDB3AC_V_G" "layout" "VAMP13_top_2" list(450 700) "R180")
dbCreateParamInstByMasterName(cv "PAD" "PAD60GU" "layout" "pad60gu_VAMP13_top_2" list(450 700) "R180")
dbCreateParamInstByMasterName(cv "tphn28hpcpgv18" "PDB3AC_V_G" "layout" "VAMP12_top_1" list(510 700) "R180")
dbCreateParamInstByMasterName(cv "PAD" "PAD60GU" "layout" "pad60gu_VAMP12_top_1" list(510 700) "R180")
dbCreateParamInstByMasterName(cv "tphn28hpcpgv18" "PDB3AC_V_G" "layout" "VAMP11_top_0" list(570 700) "R180")
dbCreateParamInstByMasterName(cv "PAD" "PAD60GU" "layout" "pad60gu_VAMP11_top_0" list(570 700) "R180")
dbCreateParamInstByMasterName(cv "tphn28hpcpgv18" "PCORNERA_G" "layout" "CORNER_TR_top_right" list(700 700) "R180")

; ==================== Inner Ring Pads ====================
dbCreateParamInstByMasterName(cv "tphn28hpcpgv18" "PDB3AC_H_G" "layout" "inner_pad_VCM_CORE_left_3_4" list(0 360) "R270")
dbCreateParamInstByMasterName(cv "PAD" "PAD60NU" "layout" "inner_pad60nu_VCM_CORE_left_3_4" list(0 360) "R270")
dbCreateParamInstByMasterName(cv "tphn28hpcpgv18" "PDB3AC_V_G" "layout" "inner_pad_IBIAS_CORE_bottom_4_5" list(400 0) "R0")
dbCreateParamInstByMasterName(cv "PAD" "PAD60NU" "layout" "inner_pad60nu_IBIAS_CORE_bottom_4_5" list(400 0) "R0")
dbCreateParamInstByMasterName(cv "tphn28hpcpgv18" "PDB3AC_V_G" "layout" "inner_pad_VAMP_CORE_bottom_6_7" list(520 0) "R0")
dbCreateParamInstByMasterName(cv "PAD" "PAD60NU" "layout" "inner_pad60nu_VAMP_CORE_bottom_6_7" list(520 0) "R0")
dbCreateParamInstByMasterName(cv "tphn28hpcpgv18" "PDB3AC_H_G" "layout" "inner_pad_VREF_CORE_left_5_6" list(0 240) "R270")
dbCreateParamInstByMasterName(cv "PAD" "PAD60NU" "layout" "inner_pad60nu_VREF_CORE_left_5_6" list(0 240) "R270")

; ==================== Filler Components ====================
dbCreateParamInstByMasterName(cv "tphn28hpcpgv18" "PFILLER20A_G" "layout" "sep_bottom_right_corner" list(570 0) "R0")
dbCreateParamInstByMasterName(cv "tphn28hpcpgv18" "PFILLER20A_G" "layout" "filler_bottom_left_corner" list(110 0) "R0")
dbCreateParamInstByMasterName(cv "tphn28hpcpgv18" "PFILLER10A_G" "layout" "filler_R0_1_1" list(540 0) "R0")
dbCreateParamInstByMasterName(cv "tphn28hpcpgv18" "PFILLER10A_G" "layout" "filler_R0_1_2" list(510 0) "R0")
dbCreateParamInstByMasterName(cv "tphn28hpcpgv18" "PFILLER20A_G" "layout" "filler_R0_2_1" list(470 0) "R0")
dbCreateParamInstByMasterName(cv "tphn28hpcpgv18" "PFILLER20A_G" "layout" "filler_R0_2_2" list(450 0) "R0")
dbCreateParamInstByMasterName(cv "tphn28hpcpgv18" "PFILLER10A_G" "layout" "filler_R0_3_1" list(420 0) "R0")
dbCreateParamInstByMasterName(cv "tphn28hpcpgv18" "PFILLER10A_G" "layout" "filler_R0_3_2" list(390 0) "R0")
dbCreateParamInstByMasterName(cv "tphn28hpcpgv18" "PFILLER20A_G" "layout" "filler_R0_4_1" list(350 0) "R0")
dbCreateParamInstByMasterName(cv "tphn28hpcpgv18" "PFILLER20A_G" "layout" "filler_R0_4_2" list(330 0) "R0")
dbCreateParamInstByMasterName(cv "tphn28hpcpgv18" "PFILLER20A_G" "layout" "filler_R0_5_1" list(290 0) "R0")
dbCreateParamInstByMasterName(cv "tphn28hpcpgv18" "PFILLER20A_G" "layout" "filler_R0_5_2" list(270 0) "R0")
dbCreateParamInstByMasterName(cv "tphn28hpcpgv18" "PFILLER20A_G" "layout" "filler_R0_6_1" list(230 0) "R0")
dbCreateParamInstByMasterName(cv "tphn28hpcpgv18" "PFILLER20A_G" "layout" "filler_R0_6_2" list(210 0) "R0")
dbCreateParamInstByMasterName(cv "tphn28hpcpgv18" "PFILLER20A_G" "layout" "filler_R0_7_1" list(170 0) "R0")
dbCreateParamInstByMasterName(cv "tphn28hpcpgv18" "PFILLER20A_G" "layout" "filler_R0_7_2" list(150 0) "R0")
dbCreateParamInstByMasterName(cv "tphn28hpcpgv18" "PFILLER20A_G" "layout" "filler_right_top_corner" list(700 570) "R90")
dbCreateParamInstByMasterName(cv "tphn28hpcpgv18" "PFILLER20A_G" "layout" "filler_right_bottom_corner" list(700 110) "R90")
dbCreateParamInstByMasterName(cv "tphn28hpcpgv18" "PFILLER20A_G" "layout" "filler_R90_1_1" list(700 530) "R90")
dbCreateParamInstByMasterName(cv "tphn28hpcpgv18" "PFILLER20A_G" "layout" "filler_R90_1_2" list(700 510) "R90")
dbCreateParamInstByMasterName(cv "tphn28hpcpgv18" "PFILLER20A_G" "layout" "filler_R90_2_1" list(700 470) "R90")
dbCreateParamInstByMasterName(cv "tphn28hpcpgv18" "PFILLER20A_G" "layout" "filler_R90_2_2" list(700 450) "R90")
dbCreateParamInstByMasterName(cv "tphn28hpcpgv18" "PFILLER20A_G" "layout" "filler_R90_3_1" list(700 410) "R90")
dbCreateParamInstByMasterName(cv "tphn28hpcpgv18" "PFILLER20A_G" "layout" "filler_R90_3_2" list(700 390) "R90")
dbCreateParamInstByMasterName(cv "tphn28hpcpgv18" "PFILLER20A_G" "layout" "filler_R90_4_1" list(700 350) "R90")
dbCreateParamInstByMasterName(cv "tphn28hpcpgv18" "PFILLER20A_G" "layout" "filler_R90_4_2" list(700 330) "R90")
dbCreateParamInstByMasterName(cv "tphn28hpcpgv18" "PFILLER20A_G" "layout" "filler_R90_5_1" list(700 290) "R90")
dbCreateParamInstByMasterName(cv "tphn28hpcpgv18" "PFILLER20A_G" "layout" "filler_R90_5_2" list(700 270) "R90")
dbCreateParamInstByMasterName(cv "tphn28hpcpgv18" "PFILLER20A_G" "layout" "filler_R90_6_1" list(700 230) "R90")
dbCreateParamInstByMasterName(cv "tphn28hpcpgv18" "PFILLER20A_G" "layout" "filler_R90_6_2" list(700 210) "R90")
dbCreateParamInstByMasterName(cv "tphn28hpcpgv18" "PFILLER20A_G" "layout" "filler_R90_7_1" list(700 170) "R90")
dbCreateParamInstByMasterName(cv "tphn28hpcpgv18" "PFILLER20A_G" "layout" "filler_R90_7_2" list(700 150) "R90")
dbCreateParamInstByMasterName(cv "tphn28hpcpgv18" "PFILLER20A_G" "layout" "sep_top_left_corner" list(130 700) "R180")
dbCreateParamInstByMasterName(cv "tphn28hpcpgv18" "PFILLER20A_G" "layout" "filler_top_right_corner" list(590 700) "R180")
dbCreateParamInstByMasterName(cv "tphn28hpcpgv18" "PFILLER20A_G" "layout" "filler_R180_1_1" list(170 700) "R180")
dbCreateParamInstByMasterName(cv "tphn28hpcpgv18" "PFILLER20A_G" "layout" "filler_R180_1_2" list(190 700) "R180")
dbCreateParamInstByMasterName(cv "tphn28hpcpgv18" "PFILLER20A_G" "layout" "filler_R180_2_1" list(230 700) "R180")
dbCreateParamInstByMasterName(cv "tphn28hpcpgv18" "PFILLER20A_G" "layout" "filler_R180_2_2" list(250 700) "R180")
dbCreateParamInstByMasterName(cv "tphn28hpcpgv18" "PFILLER20A_G" "layout" "filler_R180_3_1" list(290 700) "R180")
dbCreateParamInstByMasterName(cv "tphn28hpcpgv18" "PFILLER20A_G" "layout" "filler_R180_3_2" list(310 700) "R180")
dbCreateParamInstByMasterName(cv "tphn28hpcpgv18" "PFILLER20A_G" "layout" "filler_R180_4_1" list(350 700) "R180")
dbCreateParamInstByMasterName(cv "tphn28hpcpgv18" "PFILLER20A_G" "layout" "filler_R180_4_2" list(370 700) "R180")
dbCreateParamInstByMasterName(cv "tphn28hpcpgv18" "PFILLER20A_G" "layout" "filler_R180_5_1" list(410 700) "R180")
dbCreateParamInstByMasterName(cv "tphn28hpcpgv18" "PFILLER20A_G" "layout" "filler_R180_5_2" list(430 700) "R180")
dbCreateParamInstByMasterName(cv "tphn28hpcpgv18" "PFILLER20A_G" "layout" "filler_R180_6_1" list(470 700) "R180")
dbCreateParamInstByMasterName(cv "tphn28hpcpgv18" "PFILLER20A_G" "layout" "filler_R180_6_2" list(490 700) "R180")
dbCreateParamInstByMasterName(cv "tphn28hpcpgv18" "PFILLER20A_G" "layout" "filler_R180_7_1" list(530 700) "R180")
dbCreateParamInstByMasterName(cv "tphn28hpcpgv18" "PFILLER20A_G" "layout" "filler_R180_7_2" list(550 700) "R180")
dbCreateParamInstByMasterName(cv "tphn28hpcpgv18" "PFILLER20A_G" "layout" "filler_left_bottom_corner" list(0 130) "R270")
dbCreateParamInstByMasterName(cv "tphn28hpcpgv18" "PFILLER20A_G" "layout" "sep_left_top_corner" list(0 590) "R270")
dbCreateParamInstByMasterName(cv "tphn28hpcpgv18" "PFILLER20A_G" "layout" "filler_R270_1_1" list(0 170) "R270")
dbCreateParamInstByMasterName(cv "tphn28hpcpgv18" "PFILLER20A_G" "layout" "filler_R270_1_2" list(0 190) "R270")
dbCreateParamInstByMasterName(cv "tphn28hpcpgv18" "PFILLER10A_G" "layout" "filler_R270_2_1" list(0 220) "R270")
dbCreateParamInstByMasterName(cv "tphn28hpcpgv18" "PFILLER10A_G" "layout" "filler_R270_2_2" list(0 250) "R270")
dbCreateParamInstByMasterName(cv "tphn28hpcpgv18" "PFILLER20A_G" "layout" "filler_R270_3_1" list(0 290) "R270")
dbCreateParamInstByMasterName(cv "tphn28hpcpgv18" "PFILLER20A_G" "layout" "filler_R270_3_2" list(0 310) "R270")
dbCreateParamInstByMasterName(cv "tphn28hpcpgv18" "PFILLER10A_G" "layout" "filler_R270_4_1" list(0 340) "R270")
dbCreateParamInstByMasterName(cv "tphn28hpcpgv18" "PFILLER10A_G" "layout" "filler_R270_4_2" list(0 370) "R270")
dbCreateParamInstByMasterName(cv "tphn28hpcpgv18" "PFILLER20A_G" "layout" "filler_R270_5_1" list(0 410) "R270")
dbCreateParamInstByMasterName(cv "tphn28hpcpgv18" "PFILLER20A_G" "layout" "filler_R270_5_2" list(0 430) "R270")
dbCreateParamInstByMasterName(cv "tphn28hpcpgv18" "PFILLER20A_G" "layout" "filler_R270_6_1" list(0 470) "R270")
dbCreateParamInstByMasterName(cv "tphn28hpcpgv18" "PFILLER20A_G" "layout" "filler_R270_6_2" list(0 490) "R270")
dbCreateParamInstByMasterName(cv "tphn28hpcpgv18" "PFILLER20A_G" "layout" "filler_R270_7_1" list(0 530) "R270")
dbCreateParamInstByMasterName(cv "tphn28hpcpgv18" "PFILLER20A_G" "layout" "filler_R270_7_2" list(0 550) "R270")

; ==================== Digital IO Features (with Inner Pad Support) ====================

; ==================== Pin Labels (with Inner Pad Support) ====================
dbCreateLabel(cv list("AP" "pin") list(-11 560) "VINP" "centerRight" "R0" "roman" 10)
dbCreateLabel(cv list("AP" "pin") list(-11 500) "VINN" "centerRight" "R0" "roman" 10)
dbCreateLabel(cv list("AP" "pin") list(-11 440) "VIP" "centerRight" "R0" "roman" 10)
dbCreateLabel(cv list("AP" "pin") list(-11 380) "VIM" "centerRight" "R0" "roman" 10)
dbCreateLabel(cv list("AP" "pin") list(-11 320) "VCM" "centerRight" "R0" "roman" 10)
dbCreateLabel(cv list("AP" "pin") list(-11 260) "VREF" "centerRight" "R0" "roman" 10)
dbCreateLabel(cv list("AP" "pin") list(-11 200) "AVDD" "centerRight" "R0" "roman" 10)
dbCreateLabel(cv list("M2" "pin") list(109.9 200) "AVDD_CORE" "centerLeft" "R0" "roman" 2)
dbCreateLabel(cv list("AP" "pin") list(-11 140) "AVSS" "centerRight" "R0" "roman" 10)
dbCreateLabel(cv list("M2" "pin") list(109.9 140) "AVSS_CORE" "centerLeft" "R0" "roman" 2)
dbCreateLabel(cv list("AP" "pin") list(140 -11) "VREF1" "centerRight" "R90" "roman" 10)
dbCreateLabel(cv list("AP" "pin") list(200 -11) "VREF2" "centerRight" "R90" "roman" 10)
dbCreateLabel(cv list("AP" "pin") list(260 -11) "VREF3" "centerRight" "R90" "roman" 10)
dbCreateLabel(cv list("AP" "pin") list(320 -11) "VREF4" "centerRight" "R90" "roman" 10)
dbCreateLabel(cv list("AP" "pin") list(380 -11) "IBIAS" "centerRight" "R90" "roman" 10)
dbCreateLabel(cv list("AP" "pin") list(440 -11) "IBIAS2" "centerRight" "R90" "roman" 10)
dbCreateLabel(cv list("AP" "pin") list(500 -11) "VAMP" "centerRight" "R90" "roman" 10)
dbCreateLabel(cv list("AP" "pin") list(560 -11) "VAMP2" "centerRight" "R90" "roman" 10)
dbCreateLabel(cv list("AP" "pin") list(711 140) "VAMP3" "centerLeft" "R0" "roman" 10)
dbCreateLabel(cv list("AP" "pin") list(711 200) "VAMP4" "centerLeft" "R0" "roman" 10)
dbCreateLabel(cv list("AP" "pin") list(711 260) "VAMP5" "centerLeft" "R0" "roman" 10)
dbCreateLabel(cv list("AP" "pin") list(711 320) "VAMP6" "centerLeft" "R0" "roman" 10)
dbCreateLabel(cv list("AP" "pin") list(711 380) "VAMP7" "centerLeft" "R0" "roman" 10)
dbCreateLabel(cv list("AP" "pin") list(711 440) "VAMP8" "centerLeft" "R0" "roman" 10)
dbCreateLabel(cv list("AP" "pin") list(711 500) "VAMP9" "centerLeft" "R0" "roman" 10)
dbCreateLabel(cv list("AP" "pin") list(711 560) "VAMP10" "centerLeft" "R0" "roman" 10)
dbCreateLabel(cv list("AP" "pin") list(560 711) "VAMP11" "centerLeft" "R90" "roman" 10)
dbCreateLabel(cv list("AP" "pin") list(500 711) "VAMP12" "centerLeft" "R90" "roman" 10)
dbCreateLabel(cv list("AP" "pin") list(440 711) "VAMP13" "centerLeft" "R90" "roman" 10)
dbCreateLabel(cv list("AP" "pin") list(380 711) "VAMP14" "centerLeft" "R90" "roman" 10)
dbCreateLabel(cv list("AP" "pin") list(320 711) "VAMP15" "centerLeft" "R90" "roman" 10)
dbCreateLabel(cv list("AP" "pin") list(260 711) "VAMP16" "centerLeft" "R90" "roman" 10)
dbCreateLabel(cv list("AP" "pin") list(200 711) "VAMP17" "centerLeft" "R90" "roman" 10)
dbCreateLabel(cv list("AP" "pin") list(140 711) "VAMP18" "centerLeft" "R90" "roman" 10)
dbCreateLabel(cv list("AP" "pin") list(152 350) "VCM_CORE" "centerLeft" "R0" "roman" 10)
dbCreateLabel(cv list("AP" "pin") list(410 152) "IBIAS_CORE" "centerLeft" "R90" "roman" 10)
dbCreateLabel(cv list("AP" "pin") list(530 152) "VAMP_CORE" "centerLeft" "R90" "roman" 10)
dbCreateLabel(cv list("AP" "pin") list(152 230) "VREF_CORE" "centerLeft" "R0" "roman" 10)

dbSave(cv)
t
