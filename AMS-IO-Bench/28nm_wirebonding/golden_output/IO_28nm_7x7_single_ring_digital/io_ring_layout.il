; Generated Layout Script with Dual Ring Support

; ==================== All Components (Sorted by Placement Order) ====================
dbCreateParamInstByMasterName(cv "tphn28hpcpgv18" "PDDW16SDGZ_H_G" "layout" "D6_left_6" list(0 150) "R270")
dbCreateParamInstByMasterName(cv "PAD" "PAD60GU" "layout" "pad60gu_D6_left_6" list(0 150) "R270")
dbCreateParamInstByMasterName(cv "tphn28hpcpgv18" "PDDW16SDGZ_H_G" "layout" "D5_left_5" list(0 210) "R270")
dbCreateParamInstByMasterName(cv "PAD" "PAD60GU" "layout" "pad60gu_D5_left_5" list(0 210) "R270")
dbCreateParamInstByMasterName(cv "tphn28hpcpgv18" "PDDW16SDGZ_H_G" "layout" "D4_left_4" list(0 270) "R270")
dbCreateParamInstByMasterName(cv "PAD" "PAD60GU" "layout" "pad60gu_D4_left_4" list(0 270) "R270")
dbCreateParamInstByMasterName(cv "tphn28hpcpgv18" "PDDW16SDGZ_H_G" "layout" "D3_left_3" list(0 330) "R270")
dbCreateParamInstByMasterName(cv "PAD" "PAD60GU" "layout" "pad60gu_D3_left_3" list(0 330) "R270")
dbCreateParamInstByMasterName(cv "tphn28hpcpgv18" "PDDW16SDGZ_H_G" "layout" "D2_left_2" list(0 390) "R270")
dbCreateParamInstByMasterName(cv "PAD" "PAD60GU" "layout" "pad60gu_D2_left_2" list(0 390) "R270")
dbCreateParamInstByMasterName(cv "tphn28hpcpgv18" "PDDW16SDGZ_H_G" "layout" "D1_left_1" list(0 450) "R270")
dbCreateParamInstByMasterName(cv "PAD" "PAD60GU" "layout" "pad60gu_D1_left_1" list(0 450) "R270")
dbCreateParamInstByMasterName(cv "tphn28hpcpgv18" "PDDW16SDGZ_H_G" "layout" "D0_left_0" list(0 510) "R270")
dbCreateParamInstByMasterName(cv "PAD" "PAD60GU" "layout" "pad60gu_D0_left_0" list(0 510) "R270")
dbCreateParamInstByMasterName(cv "tphn28hpcpgv18" "PCORNER_G" "layout" "CORNER_TL_top_left" list(0 640) "R270")
dbCreateParamInstByMasterName(cv "tphn28hpcpgv18" "PDDW16SDGZ_V_G" "layout" "D13_bottom_6" list(490 0) "R0")
dbCreateParamInstByMasterName(cv "PAD" "PAD60GU" "layout" "pad60gu_D13_bottom_6" list(490 0) "R0")
dbCreateParamInstByMasterName(cv "tphn28hpcpgv18" "PDDW16SDGZ_V_G" "layout" "D12_bottom_5" list(430 0) "R0")
dbCreateParamInstByMasterName(cv "PAD" "PAD60GU" "layout" "pad60gu_D12_bottom_5" list(430 0) "R0")
dbCreateParamInstByMasterName(cv "tphn28hpcpgv18" "PDDW16SDGZ_V_G" "layout" "D11_bottom_4" list(370 0) "R0")
dbCreateParamInstByMasterName(cv "PAD" "PAD60GU" "layout" "pad60gu_D11_bottom_4" list(370 0) "R0")
dbCreateParamInstByMasterName(cv "tphn28hpcpgv18" "PDDW16SDGZ_V_G" "layout" "D10_bottom_3" list(310 0) "R0")
dbCreateParamInstByMasterName(cv "PAD" "PAD60GU" "layout" "pad60gu_D10_bottom_3" list(310 0) "R0")
dbCreateParamInstByMasterName(cv "tphn28hpcpgv18" "PDDW16SDGZ_V_G" "layout" "D9_bottom_2" list(250 0) "R0")
dbCreateParamInstByMasterName(cv "PAD" "PAD60GU" "layout" "pad60gu_D9_bottom_2" list(250 0) "R0")
dbCreateParamInstByMasterName(cv "tphn28hpcpgv18" "PDDW16SDGZ_V_G" "layout" "D8_bottom_1" list(190 0) "R0")
dbCreateParamInstByMasterName(cv "PAD" "PAD60GU" "layout" "pad60gu_D8_bottom_1" list(190 0) "R0")
dbCreateParamInstByMasterName(cv "tphn28hpcpgv18" "PDDW16SDGZ_V_G" "layout" "D7_bottom_0" list(130 0) "R0")
dbCreateParamInstByMasterName(cv "PAD" "PAD60GU" "layout" "pad60gu_D7_bottom_0" list(130 0) "R0")
dbCreateParamInstByMasterName(cv "tphn28hpcpgv18" "PCORNER_G" "layout" "CORNER_BL_bottom_left" list(0 0) "R0")
dbCreateParamInstByMasterName(cv "tphn28hpcpgv18" "PDDW16SDGZ_H_G" "layout" "D20_right_6" list(640 490) "R90")
dbCreateParamInstByMasterName(cv "PAD" "PAD60GU" "layout" "pad60gu_D20_right_6" list(640 490) "R90")
dbCreateParamInstByMasterName(cv "tphn28hpcpgv18" "PDDW16SDGZ_H_G" "layout" "D19_right_5" list(640 430) "R90")
dbCreateParamInstByMasterName(cv "PAD" "PAD60GU" "layout" "pad60gu_D19_right_5" list(640 430) "R90")
dbCreateParamInstByMasterName(cv "tphn28hpcpgv18" "PDDW16SDGZ_H_G" "layout" "D18_right_4" list(640 370) "R90")
dbCreateParamInstByMasterName(cv "PAD" "PAD60GU" "layout" "pad60gu_D18_right_4" list(640 370) "R90")
dbCreateParamInstByMasterName(cv "tphn28hpcpgv18" "PDDW16SDGZ_H_G" "layout" "D17_right_3" list(640 310) "R90")
dbCreateParamInstByMasterName(cv "PAD" "PAD60GU" "layout" "pad60gu_D17_right_3" list(640 310) "R90")
dbCreateParamInstByMasterName(cv "tphn28hpcpgv18" "PDDW16SDGZ_H_G" "layout" "D16_right_2" list(640 250) "R90")
dbCreateParamInstByMasterName(cv "PAD" "PAD60GU" "layout" "pad60gu_D16_right_2" list(640 250) "R90")
dbCreateParamInstByMasterName(cv "tphn28hpcpgv18" "PDDW16SDGZ_H_G" "layout" "D15_right_1" list(640 190) "R90")
dbCreateParamInstByMasterName(cv "PAD" "PAD60GU" "layout" "pad60gu_D15_right_1" list(640 190) "R90")
dbCreateParamInstByMasterName(cv "tphn28hpcpgv18" "PDDW16SDGZ_H_G" "layout" "D14_right_0" list(640 130) "R90")
dbCreateParamInstByMasterName(cv "PAD" "PAD60GU" "layout" "pad60gu_D14_right_0" list(640 130) "R90")
dbCreateParamInstByMasterName(cv "tphn28hpcpgv18" "PCORNER_G" "layout" "CORNER_BR_bottom_right" list(640 0) "R90")
dbCreateParamInstByMasterName(cv "tphn28hpcpgv18" "PVSS2DGZ_V_G" "layout" "GIOH_top_6" list(150 640) "R180")
dbCreateParamInstByMasterName(cv "PAD" "PAD60GU" "layout" "pad60gu_GIOH_top_6" list(150 640) "R180")
dbCreateParamInstByMasterName(cv "tphn28hpcpgv18" "PVDD2POC_V_G" "layout" "VIOH_top_5" list(210 640) "R180")
dbCreateParamInstByMasterName(cv "PAD" "PAD60GU" "layout" "pad60gu_VIOH_top_5" list(210 640) "R180")
dbCreateParamInstByMasterName(cv "tphn28hpcpgv18" "PVSS1DGZ_V_G" "layout" "GIOL_top_4" list(270 640) "R180")
dbCreateParamInstByMasterName(cv "PAD" "PAD60GU" "layout" "pad60gu_GIOL_top_4" list(270 640) "R180")
dbCreateParamInstByMasterName(cv "tphn28hpcpgv18" "PVDD1DGZ_V_G" "layout" "VIOL_top_3" list(330 640) "R180")
dbCreateParamInstByMasterName(cv "PAD" "PAD60GU" "layout" "pad60gu_VIOL_top_3" list(330 640) "R180")
dbCreateParamInstByMasterName(cv "tphn28hpcpgv18" "PDDW16SDGZ_V_G" "layout" "D23_top_2" list(390 640) "R180")
dbCreateParamInstByMasterName(cv "PAD" "PAD60GU" "layout" "pad60gu_D23_top_2" list(390 640) "R180")
dbCreateParamInstByMasterName(cv "tphn28hpcpgv18" "PDDW16SDGZ_V_G" "layout" "D22_top_1" list(450 640) "R180")
dbCreateParamInstByMasterName(cv "PAD" "PAD60GU" "layout" "pad60gu_D22_top_1" list(450 640) "R180")
dbCreateParamInstByMasterName(cv "tphn28hpcpgv18" "PDDW16SDGZ_V_G" "layout" "D21_top_0" list(510 640) "R180")
dbCreateParamInstByMasterName(cv "PAD" "PAD60GU" "layout" "pad60gu_D21_top_0" list(510 640) "R180")
dbCreateParamInstByMasterName(cv "tphn28hpcpgv18" "PCORNER_G" "layout" "CORNER_TR_top_right" list(640 640) "R180")

; ==================== Filler Components ====================
dbCreateParamInstByMasterName(cv "tphn28hpcpgv18" "PFILLER20_G" "layout" "sep_bottom_right_corner" list(510 0) "R0")
dbCreateParamInstByMasterName(cv "tphn28hpcpgv18" "PFILLER20_G" "layout" "filler_bottom_left_corner" list(110 0) "R0")
dbCreateParamInstByMasterName(cv "tphn28hpcpgv18" "PFILLER20_G" "layout" "filler_R0_1_1" list(470 0) "R0")
dbCreateParamInstByMasterName(cv "tphn28hpcpgv18" "PFILLER20_G" "layout" "filler_R0_1_2" list(450 0) "R0")
dbCreateParamInstByMasterName(cv "tphn28hpcpgv18" "PFILLER20_G" "layout" "filler_R0_2_1" list(410 0) "R0")
dbCreateParamInstByMasterName(cv "tphn28hpcpgv18" "PFILLER20_G" "layout" "filler_R0_2_2" list(390 0) "R0")
dbCreateParamInstByMasterName(cv "tphn28hpcpgv18" "PFILLER20_G" "layout" "filler_R0_3_1" list(350 0) "R0")
dbCreateParamInstByMasterName(cv "tphn28hpcpgv18" "PFILLER20_G" "layout" "filler_R0_3_2" list(330 0) "R0")
dbCreateParamInstByMasterName(cv "tphn28hpcpgv18" "PFILLER20_G" "layout" "filler_R0_4_1" list(290 0) "R0")
dbCreateParamInstByMasterName(cv "tphn28hpcpgv18" "PFILLER20_G" "layout" "filler_R0_4_2" list(270 0) "R0")
dbCreateParamInstByMasterName(cv "tphn28hpcpgv18" "PFILLER20_G" "layout" "filler_R0_5_1" list(230 0) "R0")
dbCreateParamInstByMasterName(cv "tphn28hpcpgv18" "PFILLER20_G" "layout" "filler_R0_5_2" list(210 0) "R0")
dbCreateParamInstByMasterName(cv "tphn28hpcpgv18" "PFILLER20_G" "layout" "filler_R0_6_1" list(170 0) "R0")
dbCreateParamInstByMasterName(cv "tphn28hpcpgv18" "PFILLER20_G" "layout" "filler_R0_6_2" list(150 0) "R0")
dbCreateParamInstByMasterName(cv "tphn28hpcpgv18" "PFILLER20_G" "layout" "filler_right_top_corner" list(640 510) "R90")
dbCreateParamInstByMasterName(cv "tphn28hpcpgv18" "PFILLER20_G" "layout" "filler_right_bottom_corner" list(640 110) "R90")
dbCreateParamInstByMasterName(cv "tphn28hpcpgv18" "PFILLER20_G" "layout" "filler_R90_1_1" list(640 470) "R90")
dbCreateParamInstByMasterName(cv "tphn28hpcpgv18" "PFILLER20_G" "layout" "filler_R90_1_2" list(640 450) "R90")
dbCreateParamInstByMasterName(cv "tphn28hpcpgv18" "PFILLER20_G" "layout" "filler_R90_2_1" list(640 410) "R90")
dbCreateParamInstByMasterName(cv "tphn28hpcpgv18" "PFILLER20_G" "layout" "filler_R90_2_2" list(640 390) "R90")
dbCreateParamInstByMasterName(cv "tphn28hpcpgv18" "PFILLER20_G" "layout" "filler_R90_3_1" list(640 350) "R90")
dbCreateParamInstByMasterName(cv "tphn28hpcpgv18" "PFILLER20_G" "layout" "filler_R90_3_2" list(640 330) "R90")
dbCreateParamInstByMasterName(cv "tphn28hpcpgv18" "PFILLER20_G" "layout" "filler_R90_4_1" list(640 290) "R90")
dbCreateParamInstByMasterName(cv "tphn28hpcpgv18" "PFILLER20_G" "layout" "filler_R90_4_2" list(640 270) "R90")
dbCreateParamInstByMasterName(cv "tphn28hpcpgv18" "PFILLER20_G" "layout" "filler_R90_5_1" list(640 230) "R90")
dbCreateParamInstByMasterName(cv "tphn28hpcpgv18" "PFILLER20_G" "layout" "filler_R90_5_2" list(640 210) "R90")
dbCreateParamInstByMasterName(cv "tphn28hpcpgv18" "PFILLER20_G" "layout" "filler_R90_6_1" list(640 170) "R90")
dbCreateParamInstByMasterName(cv "tphn28hpcpgv18" "PFILLER20_G" "layout" "filler_R90_6_2" list(640 150) "R90")
dbCreateParamInstByMasterName(cv "tphn28hpcpgv18" "PFILLER20_G" "layout" "sep_top_left_corner" list(130 640) "R180")
dbCreateParamInstByMasterName(cv "tphn28hpcpgv18" "PFILLER20_G" "layout" "filler_top_right_corner" list(530 640) "R180")
dbCreateParamInstByMasterName(cv "tphn28hpcpgv18" "PFILLER20_G" "layout" "filler_R180_1_1" list(170 640) "R180")
dbCreateParamInstByMasterName(cv "tphn28hpcpgv18" "PFILLER20_G" "layout" "filler_R180_1_2" list(190 640) "R180")
dbCreateParamInstByMasterName(cv "tphn28hpcpgv18" "PFILLER20_G" "layout" "filler_R180_2_1" list(230 640) "R180")
dbCreateParamInstByMasterName(cv "tphn28hpcpgv18" "PFILLER20_G" "layout" "filler_R180_2_2" list(250 640) "R180")
dbCreateParamInstByMasterName(cv "tphn28hpcpgv18" "PFILLER20_G" "layout" "filler_R180_3_1" list(290 640) "R180")
dbCreateParamInstByMasterName(cv "tphn28hpcpgv18" "PFILLER20_G" "layout" "filler_R180_3_2" list(310 640) "R180")
dbCreateParamInstByMasterName(cv "tphn28hpcpgv18" "PFILLER20_G" "layout" "filler_R180_4_1" list(350 640) "R180")
dbCreateParamInstByMasterName(cv "tphn28hpcpgv18" "PFILLER20_G" "layout" "filler_R180_4_2" list(370 640) "R180")
dbCreateParamInstByMasterName(cv "tphn28hpcpgv18" "PFILLER20_G" "layout" "filler_R180_5_1" list(410 640) "R180")
dbCreateParamInstByMasterName(cv "tphn28hpcpgv18" "PFILLER20_G" "layout" "filler_R180_5_2" list(430 640) "R180")
dbCreateParamInstByMasterName(cv "tphn28hpcpgv18" "PFILLER20_G" "layout" "filler_R180_6_1" list(470 640) "R180")
dbCreateParamInstByMasterName(cv "tphn28hpcpgv18" "PFILLER20_G" "layout" "filler_R180_6_2" list(490 640) "R180")
dbCreateParamInstByMasterName(cv "tphn28hpcpgv18" "PFILLER20_G" "layout" "filler_left_bottom_corner" list(0 130) "R270")
dbCreateParamInstByMasterName(cv "tphn28hpcpgv18" "PFILLER20_G" "layout" "sep_left_top_corner" list(0 530) "R270")
dbCreateParamInstByMasterName(cv "tphn28hpcpgv18" "PFILLER20_G" "layout" "filler_R270_1_1" list(0 170) "R270")
dbCreateParamInstByMasterName(cv "tphn28hpcpgv18" "PFILLER20_G" "layout" "filler_R270_1_2" list(0 190) "R270")
dbCreateParamInstByMasterName(cv "tphn28hpcpgv18" "PFILLER20_G" "layout" "filler_R270_2_1" list(0 230) "R270")
dbCreateParamInstByMasterName(cv "tphn28hpcpgv18" "PFILLER20_G" "layout" "filler_R270_2_2" list(0 250) "R270")
dbCreateParamInstByMasterName(cv "tphn28hpcpgv18" "PFILLER20_G" "layout" "filler_R270_3_1" list(0 290) "R270")
dbCreateParamInstByMasterName(cv "tphn28hpcpgv18" "PFILLER20_G" "layout" "filler_R270_3_2" list(0 310) "R270")
dbCreateParamInstByMasterName(cv "tphn28hpcpgv18" "PFILLER20_G" "layout" "filler_R270_4_1" list(0 350) "R270")
dbCreateParamInstByMasterName(cv "tphn28hpcpgv18" "PFILLER20_G" "layout" "filler_R270_4_2" list(0 370) "R270")
dbCreateParamInstByMasterName(cv "tphn28hpcpgv18" "PFILLER20_G" "layout" "filler_R270_5_1" list(0 410) "R270")
dbCreateParamInstByMasterName(cv "tphn28hpcpgv18" "PFILLER20_G" "layout" "filler_R270_5_2" list(0 430) "R270")
dbCreateParamInstByMasterName(cv "tphn28hpcpgv18" "PFILLER20_G" "layout" "filler_R270_6_1" list(0 470) "R270")
dbCreateParamInstByMasterName(cv "tphn28hpcpgv18" "PFILLER20_G" "layout" "filler_R270_6_2" list(0 490) "R270")

; ==================== Digital IO Features (with Inner Pad Support) ====================
dbCreatePath(cv list("M3" "drawing") list(list(130 110.5) list(510 110.5)) 0.2)
dbCreatePath(cv list("M3" "drawing") list(list(130 109.24) list(510 109.24)) 0.2)
dbCreatePath(cv list("M3" "drawing") list(list(529.5 130) list(529.5 510)) 0.2)
dbCreatePath(cv list("M3" "drawing") list(list(530.76 130) list(530.76 510)) 0.2)
dbCreatePath(cv list("M3" "drawing") list(list(130 529.5) list(510 529.5)) 0.2)
dbCreatePath(cv list("M3" "drawing") list(list(130 530.76) list(510 530.76)) 0.2)
dbCreatePath(cv list("M3" "drawing") list(list(110.5 130) list(110.5 510)) 0.2)
dbCreatePath(cv list("M3" "drawing") list(list(109.24 130) list(109.24 510)) 0.2)
dbCreatePath(cv list("M3" "drawing") list(list(130 529.5) list(110.5 529.5)) 0.2 "extendExtend")
dbCreatePath(cv list("M3" "drawing") list(list(110.5 529.5) list(110.5 510)) 0.2 "extendExtend")
dbCreatePath(cv list("M3" "drawing") list(list(130 530.76) list(109.24 530.76)) 0.2 "extendExtend")
dbCreatePath(cv list("M3" "drawing") list(list(109.24 530.76) list(109.24 510)) 0.2 "extendExtend")
dbCreatePath(cv list("M3" "drawing") list(list(510 529.5) list(529.5 529.5)) 0.2 "extendExtend")
dbCreatePath(cv list("M3" "drawing") list(list(529.5 529.5) list(529.5 510)) 0.2 "extendExtend")
dbCreatePath(cv list("M3" "drawing") list(list(510 530.76) list(530.76 530.76)) 0.2 "extendExtend")
dbCreatePath(cv list("M3" "drawing") list(list(530.76 530.76) list(530.76 510)) 0.2 "extendExtend")
dbCreatePath(cv list("M3" "drawing") list(list(130 110.5) list(110.5 110.5)) 0.2 "extendExtend")
dbCreatePath(cv list("M3" "drawing") list(list(110.5 110.5) list(110.5 130)) 0.2 "extendExtend")
dbCreatePath(cv list("M3" "drawing") list(list(130 109.24) list(109.24 109.24)) 0.2 "extendExtend")
dbCreatePath(cv list("M3" "drawing") list(list(109.24 109.24) list(109.24 130)) 0.2 "extendExtend")
dbCreatePath(cv list("M3" "drawing") list(list(510 110.5) list(529.5 110.5)) 0.2 "extendExtend")
dbCreatePath(cv list("M3" "drawing") list(list(529.5 110.5) list(529.5 130)) 0.2 "extendExtend")
dbCreatePath(cv list("M3" "drawing") list(list(510 109.24) list(530.76 109.24)) 0.2 "extendExtend")
dbCreatePath(cv list("M3" "drawing") list(list(530.76 109.24) list(530.76 130)) 0.2 "extendExtend")
dbCreatePath(cv list("M3" "drawing") list(list(327.655 529.88) list(327.655 529.5)) 0.2)
tech = techGetTechFile(cv)
viaParams = list(list("cutRows" 2) list("cutColumns" 4))
viaDefId = techFindViaDefByName(tech "M3_M2")
newVia = dbCreateVia(cv viaDefId list(327.655 529.88) "R180" viaParams)
dbCreatePath(cv list("M3" "drawing") list(list(267.61 529.88) list(267.61 530.76)) 0.2)
tech = techGetTechFile(cv)
viaParams = list(list("cutRows" 2) list("cutColumns" 4))
viaDefId = techFindViaDefByName(tech "M3_M2")
newVia = dbCreateVia(cv viaDefId list(267.61 529.88) "R180" viaParams)
dbCreatePath(cv list("M3" "drawing") list(list(109.875 499.8) list(109.24 499.8)) 0.26)
dbCreatePath(cv list("M3" "drawing") list(list(109.875 508.275) list(109.24 508.275)) 0.26)
dbCreatePath(cv list("M3" "drawing") list(list(109.875 504.1) list(110.5 504.1)) 0.26)
dbCreateLabel(cv list("M4" "pin") list(109.875 495.67) "D0_CORE" "centerLeft" "R0" "roman" 2)
dbCreatePath(cv list("M3" "drawing") list(list(109.875 439.8) list(109.24 439.8)) 0.26)
dbCreatePath(cv list("M3" "drawing") list(list(109.875 448.275) list(109.24 448.275)) 0.26)
dbCreatePath(cv list("M3" "drawing") list(list(109.875 444.1) list(110.5 444.1)) 0.26)
dbCreateLabel(cv list("M4" "pin") list(109.875 435.67) "D1_CORE" "centerLeft" "R0" "roman" 2)
dbCreatePath(cv list("M3" "drawing") list(list(109.875 379.8) list(109.24 379.8)) 0.26)
dbCreatePath(cv list("M3" "drawing") list(list(109.875 388.275) list(109.24 388.275)) 0.26)
dbCreatePath(cv list("M3" "drawing") list(list(109.875 384.1) list(110.5 384.1)) 0.26)
dbCreateLabel(cv list("M4" "pin") list(109.875 375.67) "D2_CORE" "centerLeft" "R0" "roman" 2)
dbCreatePath(cv list("M3" "drawing") list(list(109.875 319.8) list(109.24 319.8)) 0.26)
dbCreatePath(cv list("M3" "drawing") list(list(109.875 328.275) list(109.24 328.275)) 0.26)
dbCreatePath(cv list("M3" "drawing") list(list(109.875 324.1) list(110.5 324.1)) 0.26)
dbCreateLabel(cv list("M4" "pin") list(109.875 315.67) "D3_CORE" "centerLeft" "R0" "roman" 2)
dbCreatePath(cv list("M3" "drawing") list(list(109.875 259.8) list(109.24 259.8)) 0.26)
dbCreatePath(cv list("M3" "drawing") list(list(109.875 268.275) list(109.24 268.275)) 0.26)
dbCreatePath(cv list("M3" "drawing") list(list(109.875 264.1) list(110.5 264.1)) 0.26)
dbCreateLabel(cv list("M4" "pin") list(109.875 255.67) "D4_CORE" "centerLeft" "R0" "roman" 2)
dbCreatePath(cv list("M3" "drawing") list(list(109.875 199.8) list(109.24 199.8)) 0.26)
dbCreatePath(cv list("M3" "drawing") list(list(109.875 208.275) list(109.24 208.275)) 0.26)
dbCreatePath(cv list("M3" "drawing") list(list(109.875 204.1) list(110.5 204.1)) 0.26)
dbCreateLabel(cv list("M4" "pin") list(109.875 195.67) "D5_CORE" "centerLeft" "R0" "roman" 2)
dbCreatePath(cv list("M3" "drawing") list(list(109.875 139.8) list(109.24 139.8)) 0.26)
dbCreatePath(cv list("M3" "drawing") list(list(109.875 148.275) list(109.24 148.275)) 0.26)
dbCreatePath(cv list("M3" "drawing") list(list(109.875 144.1) list(110.5 144.1)) 0.26)
dbCreateLabel(cv list("M4" "pin") list(109.875 135.67) "D6_CORE" "centerLeft" "R0" "roman" 2)
dbCreatePath(cv list("M3" "drawing") list(list(140.2 109.875) list(140.2 109.24)) 0.26)
dbCreatePath(cv list("M3" "drawing") list(list(131.725 109.875) list(131.725 109.24)) 0.26)
dbCreatePath(cv list("M3" "drawing") list(list(135.9 109.875) list(135.9 110.5)) 0.26)
dbCreateLabel(cv list("M4" "pin") list(144.33 109.875) "D7_CORE" "centerLeft" "R90" "roman" 2)
dbCreatePath(cv list("M3" "drawing") list(list(200.2 109.875) list(200.2 109.24)) 0.26)
dbCreatePath(cv list("M3" "drawing") list(list(191.725 109.875) list(191.725 109.24)) 0.26)
dbCreatePath(cv list("M3" "drawing") list(list(195.9 109.875) list(195.9 110.5)) 0.26)
dbCreateLabel(cv list("M4" "pin") list(204.33 109.875) "D8_CORE" "centerLeft" "R90" "roman" 2)
dbCreatePath(cv list("M3" "drawing") list(list(260.2 109.875) list(260.2 109.24)) 0.26)
dbCreatePath(cv list("M3" "drawing") list(list(251.725 109.875) list(251.725 109.24)) 0.26)
dbCreatePath(cv list("M3" "drawing") list(list(255.9 109.875) list(255.9 110.5)) 0.26)
dbCreateLabel(cv list("M4" "pin") list(264.33 109.875) "D9_CORE" "centerLeft" "R90" "roman" 2)
dbCreatePath(cv list("M3" "drawing") list(list(320.2 109.875) list(320.2 109.24)) 0.26)
dbCreatePath(cv list("M3" "drawing") list(list(311.725 109.875) list(311.725 109.24)) 0.26)
dbCreatePath(cv list("M3" "drawing") list(list(315.9 109.875) list(315.9 110.5)) 0.26)
dbCreateLabel(cv list("M4" "pin") list(324.33 109.875) "D10_CORE" "centerLeft" "R90" "roman" 2)
dbCreatePath(cv list("M3" "drawing") list(list(380.2 109.875) list(380.2 109.24)) 0.26)
dbCreatePath(cv list("M3" "drawing") list(list(371.725 109.875) list(371.725 109.24)) 0.26)
dbCreatePath(cv list("M3" "drawing") list(list(375.9 109.875) list(375.9 110.5)) 0.26)
dbCreateLabel(cv list("M4" "pin") list(384.33 109.875) "D11_CORE" "centerLeft" "R90" "roman" 2)
dbCreatePath(cv list("M3" "drawing") list(list(440.2 109.875) list(440.2 109.24)) 0.26)
dbCreatePath(cv list("M3" "drawing") list(list(431.725 109.875) list(431.725 109.24)) 0.26)
dbCreatePath(cv list("M3" "drawing") list(list(435.9 109.875) list(435.9 110.5)) 0.26)
dbCreateLabel(cv list("M4" "pin") list(444.33 109.875) "D12_CORE" "centerLeft" "R90" "roman" 2)
dbCreatePath(cv list("M3" "drawing") list(list(500.2 109.875) list(500.2 109.24)) 0.26)
dbCreatePath(cv list("M3" "drawing") list(list(491.725 109.875) list(491.725 109.24)) 0.26)
dbCreatePath(cv list("M3" "drawing") list(list(495.9 109.875) list(495.9 110.5)) 0.26)
dbCreateLabel(cv list("M4" "pin") list(504.33 109.875) "D13_CORE" "centerLeft" "R90" "roman" 2)
dbCreatePath(cv list("M3" "drawing") list(list(530.76 140.2) list(530.125 140.2)) 0.26)
dbCreatePath(cv list("M3" "drawing") list(list(530.76 131.725) list(530.125 131.725)) 0.26)
dbCreatePath(cv list("M3" "drawing") list(list(529.5 135.9) list(530.125 135.9)) 0.26)
dbCreateLabel(cv list("M4" "pin") list(530.125 144.33) "D14_CORE" "centerRight" "R0" "roman" 2)
dbCreatePath(cv list("M3" "drawing") list(list(530.76 200.2) list(530.125 200.2)) 0.26)
dbCreatePath(cv list("M3" "drawing") list(list(530.76 191.725) list(530.125 191.725)) 0.26)
dbCreatePath(cv list("M3" "drawing") list(list(529.5 195.9) list(530.125 195.9)) 0.26)
dbCreateLabel(cv list("M4" "pin") list(530.125 204.33) "D15_CORE" "centerRight" "R0" "roman" 2)
dbCreatePath(cv list("M3" "drawing") list(list(530.76 260.2) list(530.125 260.2)) 0.26)
dbCreatePath(cv list("M3" "drawing") list(list(530.76 251.725) list(530.125 251.725)) 0.26)
dbCreatePath(cv list("M3" "drawing") list(list(529.5 255.9) list(530.125 255.9)) 0.26)
dbCreateLabel(cv list("M4" "pin") list(530.125 264.33) "D16_CORE" "centerRight" "R0" "roman" 2)
dbCreatePath(cv list("M3" "drawing") list(list(530.76 320.2) list(530.125 320.2)) 0.26)
dbCreatePath(cv list("M3" "drawing") list(list(530.76 311.725) list(530.125 311.725)) 0.26)
dbCreatePath(cv list("M3" "drawing") list(list(529.5 315.9) list(530.125 315.9)) 0.26)
dbCreateLabel(cv list("M4" "pin") list(530.125 324.33) "D17_CORE" "centerRight" "R0" "roman" 2)
dbCreatePath(cv list("M3" "drawing") list(list(530.76 380.2) list(530.125 380.2)) 0.26)
dbCreatePath(cv list("M3" "drawing") list(list(530.76 371.725) list(530.125 371.725)) 0.26)
dbCreatePath(cv list("M3" "drawing") list(list(529.5 375.9) list(530.125 375.9)) 0.26)
dbCreateLabel(cv list("M4" "pin") list(530.125 384.33) "D18_CORE" "centerRight" "R0" "roman" 2)
dbCreatePath(cv list("M3" "drawing") list(list(530.76 440.2) list(530.125 440.2)) 0.26)
dbCreatePath(cv list("M3" "drawing") list(list(530.76 431.725) list(530.125 431.725)) 0.26)
dbCreatePath(cv list("M3" "drawing") list(list(529.5 435.9) list(530.125 435.9)) 0.26)
dbCreateLabel(cv list("M4" "pin") list(530.125 444.33) "D19_CORE" "centerRight" "R0" "roman" 2)
dbCreatePath(cv list("M3" "drawing") list(list(530.76 500.2) list(530.125 500.2)) 0.26)
dbCreatePath(cv list("M3" "drawing") list(list(530.76 491.725) list(530.125 491.725)) 0.26)
dbCreatePath(cv list("M3" "drawing") list(list(529.5 495.9) list(530.125 495.9)) 0.26)
dbCreateLabel(cv list("M4" "pin") list(530.125 504.33) "D20_CORE" "centerRight" "R0" "roman" 2)
dbCreatePath(cv list("M3" "drawing") list(list(499.8 530.125) list(499.8 530.76)) 0.26)
dbCreatePath(cv list("M3" "drawing") list(list(508.275 530.125) list(508.275 530.76)) 0.26)
dbCreatePath(cv list("M3" "drawing") list(list(504.1 530.125) list(504.1 529.5)) 0.26)
dbCreateLabel(cv list("M4" "pin") list(495.67 530.125) "D21_CORE" "centerRight" "R90" "roman" 2)
dbCreatePath(cv list("M3" "drawing") list(list(439.8 530.125) list(439.8 530.76)) 0.26)
dbCreatePath(cv list("M3" "drawing") list(list(448.275 530.125) list(448.275 530.76)) 0.26)
dbCreatePath(cv list("M3" "drawing") list(list(444.1 530.125) list(444.1 529.5)) 0.26)
dbCreateLabel(cv list("M4" "pin") list(435.67 530.125) "D22_CORE" "centerRight" "R90" "roman" 2)
dbCreatePath(cv list("M3" "drawing") list(list(379.8 530.125) list(379.8 530.76)) 0.26)
dbCreatePath(cv list("M3" "drawing") list(list(388.275 530.125) list(388.275 530.76)) 0.26)
dbCreatePath(cv list("M3" "drawing") list(list(384.1 530.125) list(384.1 529.5)) 0.26)
dbCreateLabel(cv list("M4" "pin") list(375.67 530.125) "D23_CORE" "centerRight" "R90" "roman" 2)

; ==================== Pin Labels (with Inner Pad Support) ====================
dbCreateLabel(cv list("AP" "pin") list(-11 500) "D0" "centerRight" "R0" "roman" 10)
dbCreateLabel(cv list("AP" "pin") list(-11 440) "D1" "centerRight" "R0" "roman" 10)
dbCreateLabel(cv list("AP" "pin") list(-11 380) "D2" "centerRight" "R0" "roman" 10)
dbCreateLabel(cv list("AP" "pin") list(-11 320) "D3" "centerRight" "R0" "roman" 10)
dbCreateLabel(cv list("AP" "pin") list(-11 260) "D4" "centerRight" "R0" "roman" 10)
dbCreateLabel(cv list("AP" "pin") list(-11 200) "D5" "centerRight" "R0" "roman" 10)
dbCreateLabel(cv list("AP" "pin") list(-11 140) "D6" "centerRight" "R0" "roman" 10)
dbCreateLabel(cv list("AP" "pin") list(140 -11) "D7" "centerRight" "R90" "roman" 10)
dbCreateLabel(cv list("AP" "pin") list(200 -11) "D8" "centerRight" "R90" "roman" 10)
dbCreateLabel(cv list("AP" "pin") list(260 -11) "D9" "centerRight" "R90" "roman" 10)
dbCreateLabel(cv list("AP" "pin") list(320 -11) "D10" "centerRight" "R90" "roman" 10)
dbCreateLabel(cv list("AP" "pin") list(380 -11) "D11" "centerRight" "R90" "roman" 10)
dbCreateLabel(cv list("AP" "pin") list(440 -11) "D12" "centerRight" "R90" "roman" 10)
dbCreateLabel(cv list("AP" "pin") list(500 -11) "D13" "centerRight" "R90" "roman" 10)
dbCreateLabel(cv list("AP" "pin") list(651 140) "D14" "centerLeft" "R0" "roman" 10)
dbCreateLabel(cv list("AP" "pin") list(651 200) "D15" "centerLeft" "R0" "roman" 10)
dbCreateLabel(cv list("AP" "pin") list(651 260) "D16" "centerLeft" "R0" "roman" 10)
dbCreateLabel(cv list("AP" "pin") list(651 320) "D17" "centerLeft" "R0" "roman" 10)
dbCreateLabel(cv list("AP" "pin") list(651 380) "D18" "centerLeft" "R0" "roman" 10)
dbCreateLabel(cv list("AP" "pin") list(651 440) "D19" "centerLeft" "R0" "roman" 10)
dbCreateLabel(cv list("AP" "pin") list(651 500) "D20" "centerLeft" "R0" "roman" 10)
dbCreateLabel(cv list("AP" "pin") list(500 651) "D21" "centerLeft" "R90" "roman" 10)
dbCreateLabel(cv list("AP" "pin") list(440 651) "D22" "centerLeft" "R90" "roman" 10)
dbCreateLabel(cv list("AP" "pin") list(380 651) "D23" "centerLeft" "R90" "roman" 10)
dbCreateLabel(cv list("AP" "pin") list(320 651) "VIOL" "centerLeft" "R90" "roman" 10)
dbCreateLabel(cv list("AP" "pin") list(260 651) "GIOL" "centerLeft" "R90" "roman" 10)
dbCreateLabel(cv list("AP" "pin") list(200 651) "VIOH" "centerLeft" "R90" "roman" 10)
dbCreateLabel(cv list("AP" "pin") list(140 651) "GIOH" "centerLeft" "R90" "roman" 10)

dbSave(cv)
t
