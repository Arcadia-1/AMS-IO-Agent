pdb3ac_h_gMaster = dbOpenCellView("tphn28hpcpgv18" "PDB3AC_H_G" "symbol")
dbCreateInst(cv pdb3ac_h_gMaster "VINP_left0" '(0 14.8125) "R270")
schCreateWire(cv "route" "full" '((0.000 15.001) (-0.750 15.001)) 0 0 0 nil nil)
schCreateWireLabel(cv nil '(-0.250 15.001) "VINP" "lowerRight" "R0" "stick" 0.0625 nil)
schCreatePin(cv nil "VINP" "inputOutput" nil '(-0.750 15.001) "R0")
schCreateWire(cv "route" "full" '((0.875 15.062) (1.625 15.062)) 0 0 0 nil nil)
schCreateWireLabel(cv nil '(1.125 15.062) "AVSS" "lowerLeft" "R0" "stick" 0.0625 nil)
schCreateWire(cv "route" "full" '((0.875 14.688) (1.625 14.688)) 0 0 0 nil nil)
schCreateWireLabel(cv nil '(1.125 14.688) "GIOL" "lowerLeft" "R0" "stick" 0.0625 nil)
schCreateWire(cv "route" "full" '((0.875 15.438) (1.625 15.438)) 0 0 0 nil nil)
schCreateWireLabel(cv nil '(1.125 15.438) "AVDD" "lowerLeft" "R0" "stick" 0.0625 nil)
dbCreateInst(cv pdb3ac_h_gMaster "VINN_left1" '(0 12.8125) "R270")
schCreateWire(cv "route" "full" '((0.000 13.001) (-0.750 13.001)) 0 0 0 nil nil)
schCreateWireLabel(cv nil '(-0.250 13.001) "VINN" "lowerRight" "R0" "stick" 0.0625 nil)
schCreatePin(cv nil "VINN" "inputOutput" nil '(-0.750 13.001) "R0")
schCreateWire(cv "route" "full" '((0.875 13.062) (1.625 13.062)) 0 0 0 nil nil)
schCreateWireLabel(cv nil '(1.125 13.062) "AVSS" "lowerLeft" "R0" "stick" 0.0625 nil)
schCreateWire(cv "route" "full" '((0.875 12.688) (1.625 12.688)) 0 0 0 nil nil)
schCreateWireLabel(cv nil '(1.125 12.688) "GIOL" "lowerLeft" "R0" "stick" 0.0625 nil)
schCreateWire(cv "route" "full" '((0.875 13.438) (1.625 13.438)) 0 0 0 nil nil)
schCreateWireLabel(cv nil '(1.125 13.438) "AVDD" "lowerLeft" "R0" "stick" 0.0625 nil)
dbCreateInst(cv pdb3ac_h_gMaster "VIP_left2" '(0 10.8125) "R270")
schCreateWire(cv "route" "full" '((0.000 11.001) (-0.750 11.001)) 0 0 0 nil nil)
schCreateWireLabel(cv nil '(-0.250 11.001) "VIP" "lowerRight" "R0" "stick" 0.0625 nil)
schCreatePin(cv nil "VIP" "inputOutput" nil '(-0.750 11.001) "R0")
schCreateWire(cv "route" "full" '((0.875 11.062) (1.625 11.062)) 0 0 0 nil nil)
schCreateWireLabel(cv nil '(1.125 11.062) "AVSS" "lowerLeft" "R0" "stick" 0.0625 nil)
schCreateWire(cv "route" "full" '((0.875 10.688) (1.625 10.688)) 0 0 0 nil nil)
schCreateWireLabel(cv nil '(1.125 10.688) "GIOL" "lowerLeft" "R0" "stick" 0.0625 nil)
schCreateWire(cv "route" "full" '((0.875 11.438) (1.625 11.438)) 0 0 0 nil nil)
schCreateWireLabel(cv nil '(1.125 11.438) "AVDD" "lowerLeft" "R0" "stick" 0.0625 nil)
dbCreateInst(cv pdb3ac_h_gMaster "VIM_left3" '(0 8.8125) "R270")
schCreateWire(cv "route" "full" '((0.000 9.001) (-0.750 9.001)) 0 0 0 nil nil)
schCreateWireLabel(cv nil '(-0.250 9.001) "VIM" "lowerRight" "R0" "stick" 0.0625 nil)
schCreatePin(cv nil "VIM" "inputOutput" nil '(-0.750 9.001) "R0")
schCreateWire(cv "route" "full" '((0.875 9.062) (1.625 9.062)) 0 0 0 nil nil)
schCreateWireLabel(cv nil '(1.125 9.062) "AVSS" "lowerLeft" "R0" "stick" 0.0625 nil)
schCreateWire(cv "route" "full" '((0.875 8.688) (1.625 8.688)) 0 0 0 nil nil)
schCreateWireLabel(cv nil '(1.125 8.688) "GIOL" "lowerLeft" "R0" "stick" 0.0625 nil)
schCreateWire(cv "route" "full" '((0.875 9.438) (1.625 9.438)) 0 0 0 nil nil)
schCreateWireLabel(cv nil '(1.125 9.438) "AVDD" "lowerLeft" "R0" "stick" 0.0625 nil)
dbCreateInst(cv pdb3ac_h_gMaster "VCM_left4" '(0 6.8125) "R270")
schCreateWire(cv "route" "full" '((0.000 7.000) (-0.750 7.000)) 0 0 0 nil nil)
schCreateWireLabel(cv nil '(-0.250 7.000) "VCM" "lowerRight" "R0" "stick" 0.0625 nil)
schCreatePin(cv nil "VCM" "inputOutput" nil '(-0.750 7.000) "R0")
schCreateWire(cv "route" "full" '((0.875 7.062) (1.625 7.062)) 0 0 0 nil nil)
schCreateWireLabel(cv nil '(1.125 7.062) "AVSS" "lowerLeft" "R0" "stick" 0.0625 nil)
schCreateWire(cv "route" "full" '((0.875 6.688) (1.625 6.688)) 0 0 0 nil nil)
schCreateWireLabel(cv nil '(1.125 6.688) "GIOL" "lowerLeft" "R0" "stick" 0.0625 nil)
schCreateWire(cv "route" "full" '((0.875 7.438) (1.625 7.438)) 0 0 0 nil nil)
schCreateWireLabel(cv nil '(1.125 7.438) "AVDD" "lowerLeft" "R0" "stick" 0.0625 nil)
dbCreateInst(cv pdb3ac_h_gMaster "VREF_left5" '(0 4.8125) "R270")
schCreateWire(cv "route" "full" '((0.000 5.000) (-0.750 5.000)) 0 0 0 nil nil)
schCreateWireLabel(cv nil '(-0.250 5.000) "VREF" "lowerRight" "R0" "stick" 0.0625 nil)
schCreatePin(cv nil "VREF" "inputOutput" nil '(-0.750 5.000) "R0")
schCreateWire(cv "route" "full" '((0.875 5.062) (1.625 5.062)) 0 0 0 nil nil)
schCreateWireLabel(cv nil '(1.125 5.062) "AVSS" "lowerLeft" "R0" "stick" 0.0625 nil)
schCreateWire(cv "route" "full" '((0.875 4.688) (1.625 4.688)) 0 0 0 nil nil)
schCreateWireLabel(cv nil '(1.125 4.688) "GIOL" "lowerLeft" "R0" "stick" 0.0625 nil)
schCreateWire(cv "route" "full" '((0.875 5.438) (1.625 5.438)) 0 0 0 nil nil)
schCreateWireLabel(cv nil '(1.125 5.438) "AVDD" "lowerLeft" "R0" "stick" 0.0625 nil)
pvdd3ac_h_gMaster = dbOpenCellView("tphn28hpcpgv18" "PVDD3AC_H_G" "symbol")
dbCreateInst(cv pvdd3ac_h_gMaster "AVDD_left6" '(0 2.8125) "R270")
schCreateWire(cv "route" "full" '((0.875 3.438) (1.625 3.438)) 0 0 0 nil nil)
schCreateWireLabel(cv nil '(1.125 3.438) "AVDD_CORE" "lowerLeft" "R0" "stick" 0.0625 nil)
schCreatePin(cv nil "AVDD_CORE" "inputOutput" nil '(1.625 3.438) "R180")
schCreateWire(cv "route" "full" '((0.875 3.062) (1.625 3.062)) 0 0 0 nil nil)
schCreateWireLabel(cv nil '(1.125 3.062) "AVSS" "lowerLeft" "R0" "stick" 0.0625 nil)
schCreateWire(cv "route" "full" '((0.875 2.688) (1.625 2.688)) 0 0 0 nil nil)
schCreateWireLabel(cv nil '(1.125 2.688) "GIOL" "lowerLeft" "R0" "stick" 0.0625 nil)
schCreateWire(cv "route" "full" '((0.000 3.001) (-0.750 3.001)) 0 0 0 nil nil)
schCreateWireLabel(cv nil '(-0.250 3.001) "AVDD" "lowerRight" "R0" "stick" 0.0625 nil)
schCreatePin(cv nil "AVDD" "inputOutput" nil '(-0.750 3.001) "R0")
pvss3ac_v_gMaster = dbOpenCellView("tphn28hpcpgv18" "PVSS3AC_V_G" "symbol")
dbCreateInst(cv pvss3ac_v_gMaster "AVSS_bottom0" '(3.1875 0) "R0")
schCreateWire(cv "route" "full" '((2.999 0.000) (2.999 -0.750)) 0 0 0 nil nil)
schCreateWireLabel(cv nil '(2.999 -0.250) "AVSS" "lowerRight" "R90" "stick" 0.0625 nil)
schCreatePin(cv nil "AVSS" "inputOutput" nil '(2.999 -0.750) "R90")
schCreateWire(cv "route" "full" '((3.312 0.875) (3.312 1.625)) 0 0 0 nil nil)
schCreateWireLabel(cv nil '(3.312 1.125) "GIOL" "lowerLeft" "R90" "stick" 0.0625 nil)
schCreateWire(cv "route" "full" '((2.562 0.875) (2.562 1.625)) 0 0 0 nil nil)
schCreateWireLabel(cv nil '(2.562 1.125) "AVSS_CORE" "lowerLeft" "R90" "stick" 0.0625 nil)
schCreatePin(cv nil "AVSS_CORE" "inputOutput" nil '(2.562 1.625) "R270")
schCreateWire(cv "route" "full" '((2.938 0.875) (2.938 1.625)) 0 0 0 nil nil)
schCreateWireLabel(cv nil '(2.938 1.125) "AVDD" "lowerLeft" "R90" "stick" 0.0625 nil)
pdb3ac_v_gMaster = dbOpenCellView("tphn28hpcpgv18" "PDB3AC_V_G" "symbol")
dbCreateInst(cv pdb3ac_v_gMaster "VREF1_bottom1" '(5.1875 0) "R0")
schCreateWire(cv "route" "full" '((5.000 0.000) (5.000 -0.750)) 0 0 0 nil nil)
schCreateWireLabel(cv nil '(5.000 -0.250) "VREF1" "lowerRight" "R90" "stick" 0.0625 nil)
schCreatePin(cv nil "VREF1" "inputOutput" nil '(5.000 -0.750) "R90")
schCreateWire(cv "route" "full" '((4.938 0.875) (4.938 1.625)) 0 0 0 nil nil)
schCreateWireLabel(cv nil '(4.938 1.125) "AVSS" "lowerLeft" "R90" "stick" 0.0625 nil)
schCreateWire(cv "route" "full" '((5.312 0.875) (5.312 1.625)) 0 0 0 nil nil)
schCreateWireLabel(cv nil '(5.312 1.125) "GIOL" "lowerLeft" "R90" "stick" 0.0625 nil)
schCreateWire(cv "route" "full" '((4.562 0.875) (4.562 1.625)) 0 0 0 nil nil)
schCreateWireLabel(cv nil '(4.562 1.125) "AVDD" "lowerLeft" "R90" "stick" 0.0625 nil)
dbCreateInst(cv pdb3ac_v_gMaster "VREF2_bottom2" '(7.1875 0) "R0")
schCreateWire(cv "route" "full" '((7.000 0.000) (7.000 -0.750)) 0 0 0 nil nil)
schCreateWireLabel(cv nil '(7.000 -0.250) "VREF2" "lowerRight" "R90" "stick" 0.0625 nil)
schCreatePin(cv nil "VREF2" "inputOutput" nil '(7.000 -0.750) "R90")
schCreateWire(cv "route" "full" '((6.938 0.875) (6.938 1.625)) 0 0 0 nil nil)
schCreateWireLabel(cv nil '(6.938 1.125) "AVSS" "lowerLeft" "R90" "stick" 0.0625 nil)
schCreateWire(cv "route" "full" '((7.312 0.875) (7.312 1.625)) 0 0 0 nil nil)
schCreateWireLabel(cv nil '(7.312 1.125) "GIOL" "lowerLeft" "R90" "stick" 0.0625 nil)
schCreateWire(cv "route" "full" '((6.562 0.875) (6.562 1.625)) 0 0 0 nil nil)
schCreateWireLabel(cv nil '(6.562 1.125) "AVDD" "lowerLeft" "R90" "stick" 0.0625 nil)
dbCreateInst(cv pdb3ac_v_gMaster "VREF3_bottom3" '(9.1875 0) "R0")
schCreateWire(cv "route" "full" '((8.999 0.000) (8.999 -0.750)) 0 0 0 nil nil)
schCreateWireLabel(cv nil '(8.999 -0.250) "VREF3" "lowerRight" "R90" "stick" 0.0625 nil)
schCreatePin(cv nil "VREF3" "inputOutput" nil '(8.999 -0.750) "R90")
schCreateWire(cv "route" "full" '((8.938 0.875) (8.938 1.625)) 0 0 0 nil nil)
schCreateWireLabel(cv nil '(8.938 1.125) "AVSS" "lowerLeft" "R90" "stick" 0.0625 nil)
schCreateWire(cv "route" "full" '((9.312 0.875) (9.312 1.625)) 0 0 0 nil nil)
schCreateWireLabel(cv nil '(9.312 1.125) "GIOL" "lowerLeft" "R90" "stick" 0.0625 nil)
schCreateWire(cv "route" "full" '((8.562 0.875) (8.562 1.625)) 0 0 0 nil nil)
schCreateWireLabel(cv nil '(8.562 1.125) "AVDD" "lowerLeft" "R90" "stick" 0.0625 nil)
dbCreateInst(cv pdb3ac_v_gMaster "VREF4_bottom4" '(11.1875 0) "R0")
schCreateWire(cv "route" "full" '((10.999 0.000) (10.999 -0.750)) 0 0 0 nil nil)
schCreateWireLabel(cv nil '(10.999 -0.250) "VREF4" "lowerRight" "R90" "stick" 0.0625 nil)
schCreatePin(cv nil "VREF4" "inputOutput" nil '(10.999 -0.750) "R90")
schCreateWire(cv "route" "full" '((10.938 0.875) (10.938 1.625)) 0 0 0 nil nil)
schCreateWireLabel(cv nil '(10.938 1.125) "AVSS" "lowerLeft" "R90" "stick" 0.0625 nil)
schCreateWire(cv "route" "full" '((11.312 0.875) (11.312 1.625)) 0 0 0 nil nil)
schCreateWireLabel(cv nil '(11.312 1.125) "GIOL" "lowerLeft" "R90" "stick" 0.0625 nil)
schCreateWire(cv "route" "full" '((10.562 0.875) (10.562 1.625)) 0 0 0 nil nil)
schCreateWireLabel(cv nil '(10.562 1.125) "AVDD" "lowerLeft" "R90" "stick" 0.0625 nil)
dbCreateInst(cv pdb3ac_v_gMaster "IBIAS_bottom5" '(13.1875 0) "R0")
schCreateWire(cv "route" "full" '((12.999 0.000) (12.999 -0.750)) 0 0 0 nil nil)
schCreateWireLabel(cv nil '(12.999 -0.250) "IBIAS" "lowerRight" "R90" "stick" 0.0625 nil)
schCreatePin(cv nil "IBIAS" "inputOutput" nil '(12.999 -0.750) "R90")
schCreateWire(cv "route" "full" '((12.938 0.875) (12.938 1.625)) 0 0 0 nil nil)
schCreateWireLabel(cv nil '(12.938 1.125) "AVSS" "lowerLeft" "R90" "stick" 0.0625 nil)
schCreateWire(cv "route" "full" '((13.312 0.875) (13.312 1.625)) 0 0 0 nil nil)
schCreateWireLabel(cv nil '(13.312 1.125) "GIOL" "lowerLeft" "R90" "stick" 0.0625 nil)
schCreateWire(cv "route" "full" '((12.562 0.875) (12.562 1.625)) 0 0 0 nil nil)
schCreateWireLabel(cv nil '(12.562 1.125) "AVDD" "lowerLeft" "R90" "stick" 0.0625 nil)
dbCreateInst(cv pdb3ac_v_gMaster "IBIAS2_bottom6" '(15.1875 0) "R0")
schCreateWire(cv "route" "full" '((14.999 0.000) (14.999 -0.750)) 0 0 0 nil nil)
schCreateWireLabel(cv nil '(14.999 -0.250) "IBIAS2" "lowerRight" "R90" "stick" 0.0625 nil)
schCreatePin(cv nil "IBIAS2" "inputOutput" nil '(14.999 -0.750) "R90")
schCreateWire(cv "route" "full" '((14.938 0.875) (14.938 1.625)) 0 0 0 nil nil)
schCreateWireLabel(cv nil '(14.938 1.125) "AVSS" "lowerLeft" "R90" "stick" 0.0625 nil)
schCreateWire(cv "route" "full" '((15.312 0.875) (15.312 1.625)) 0 0 0 nil nil)
schCreateWireLabel(cv nil '(15.312 1.125) "GIOL" "lowerLeft" "R90" "stick" 0.0625 nil)
schCreateWire(cv "route" "full" '((14.562 0.875) (14.562 1.625)) 0 0 0 nil nil)
schCreateWireLabel(cv nil '(14.562 1.125) "AVDD" "lowerLeft" "R90" "stick" 0.0625 nil)
dbCreateInst(cv pdb3ac_h_gMaster "VAMP_right0" '(18.0 3.1875) "R90")
schCreateWire(cv "route" "full" '((18.000 2.999) (18.750 2.999)) 0 0 0 nil nil)
schCreateWireLabel(cv nil '(18.250 2.999) "VAMP" "lowerLeft" "R0" "stick" 0.0625 nil)
schCreatePin(cv nil "VAMP" "inputOutput" nil '(18.750 2.999) "R180")
schCreateWire(cv "route" "full" '((17.125 2.938) (16.375 2.938)) 0 0 0 nil nil)
schCreateWireLabel(cv nil '(16.875 2.938) "AVSS" "lowerRight" "R0" "stick" 0.0625 nil)
schCreateWire(cv "route" "full" '((17.125 3.312) (16.375 3.312)) 0 0 0 nil nil)
schCreateWireLabel(cv nil '(16.875 3.312) "GIOL" "lowerRight" "R0" "stick" 0.0625 nil)
schCreateWire(cv "route" "full" '((17.125 2.562) (16.375 2.562)) 0 0 0 nil nil)
schCreateWireLabel(cv nil '(16.875 2.562) "AVDD" "lowerRight" "R0" "stick" 0.0625 nil)
dbCreateInst(cv pdb3ac_h_gMaster "VAMP2_right1" '(18.0 5.1875) "R90")
schCreateWire(cv "route" "full" '((18.000 5.000) (18.750 5.000)) 0 0 0 nil nil)
schCreateWireLabel(cv nil '(18.250 5.000) "VAMP2" "lowerLeft" "R0" "stick" 0.0625 nil)
schCreatePin(cv nil "VAMP2" "inputOutput" nil '(18.750 5.000) "R180")
schCreateWire(cv "route" "full" '((17.125 4.938) (16.375 4.938)) 0 0 0 nil nil)
schCreateWireLabel(cv nil '(16.875 4.938) "AVSS" "lowerRight" "R0" "stick" 0.0625 nil)
schCreateWire(cv "route" "full" '((17.125 5.312) (16.375 5.312)) 0 0 0 nil nil)
schCreateWireLabel(cv nil '(16.875 5.312) "GIOL" "lowerRight" "R0" "stick" 0.0625 nil)
schCreateWire(cv "route" "full" '((17.125 4.562) (16.375 4.562)) 0 0 0 nil nil)
schCreateWireLabel(cv nil '(16.875 4.562) "AVDD" "lowerRight" "R0" "stick" 0.0625 nil)
dbCreateInst(cv pdb3ac_h_gMaster "VAMP3_right2" '(18.0 7.1875) "R90")
schCreateWire(cv "route" "full" '((18.000 7.000) (18.750 7.000)) 0 0 0 nil nil)
schCreateWireLabel(cv nil '(18.250 7.000) "VAMP3" "lowerLeft" "R0" "stick" 0.0625 nil)
schCreatePin(cv nil "VAMP3" "inputOutput" nil '(18.750 7.000) "R180")
schCreateWire(cv "route" "full" '((17.125 6.938) (16.375 6.938)) 0 0 0 nil nil)
schCreateWireLabel(cv nil '(16.875 6.938) "AVSS" "lowerRight" "R0" "stick" 0.0625 nil)
schCreateWire(cv "route" "full" '((17.125 7.312) (16.375 7.312)) 0 0 0 nil nil)
schCreateWireLabel(cv nil '(16.875 7.312) "GIOL" "lowerRight" "R0" "stick" 0.0625 nil)
schCreateWire(cv "route" "full" '((17.125 6.562) (16.375 6.562)) 0 0 0 nil nil)
schCreateWireLabel(cv nil '(16.875 6.562) "AVDD" "lowerRight" "R0" "stick" 0.0625 nil)
dbCreateInst(cv pdb3ac_h_gMaster "VAMP4_right3" '(18.0 9.1875) "R90")
schCreateWire(cv "route" "full" '((18.000 8.999) (18.750 8.999)) 0 0 0 nil nil)
schCreateWireLabel(cv nil '(18.250 8.999) "VAMP4" "lowerLeft" "R0" "stick" 0.0625 nil)
schCreatePin(cv nil "VAMP4" "inputOutput" nil '(18.750 8.999) "R180")
schCreateWire(cv "route" "full" '((17.125 8.938) (16.375 8.938)) 0 0 0 nil nil)
schCreateWireLabel(cv nil '(16.875 8.938) "AVSS" "lowerRight" "R0" "stick" 0.0625 nil)
schCreateWire(cv "route" "full" '((17.125 9.312) (16.375 9.312)) 0 0 0 nil nil)
schCreateWireLabel(cv nil '(16.875 9.312) "GIOL" "lowerRight" "R0" "stick" 0.0625 nil)
schCreateWire(cv "route" "full" '((17.125 8.562) (16.375 8.562)) 0 0 0 nil nil)
schCreateWireLabel(cv nil '(16.875 8.562) "AVDD" "lowerRight" "R0" "stick" 0.0625 nil)
dbCreateInst(cv pdb3ac_h_gMaster "VAMP5_right4" '(18.0 11.1875) "R90")
schCreateWire(cv "route" "full" '((18.000 10.999) (18.750 10.999)) 0 0 0 nil nil)
schCreateWireLabel(cv nil '(18.250 10.999) "VAMP5" "lowerLeft" "R0" "stick" 0.0625 nil)
schCreatePin(cv nil "VAMP5" "inputOutput" nil '(18.750 10.999) "R180")
schCreateWire(cv "route" "full" '((17.125 10.938) (16.375 10.938)) 0 0 0 nil nil)
schCreateWireLabel(cv nil '(16.875 10.938) "AVSS" "lowerRight" "R0" "stick" 0.0625 nil)
schCreateWire(cv "route" "full" '((17.125 11.312) (16.375 11.312)) 0 0 0 nil nil)
schCreateWireLabel(cv nil '(16.875 11.312) "GIOL" "lowerRight" "R0" "stick" 0.0625 nil)
schCreateWire(cv "route" "full" '((17.125 10.562) (16.375 10.562)) 0 0 0 nil nil)
schCreateWireLabel(cv nil '(16.875 10.562) "AVDD" "lowerRight" "R0" "stick" 0.0625 nil)
dbCreateInst(cv pdb3ac_h_gMaster "VAMP6_right5" '(18.0 13.1875) "R90")
schCreateWire(cv "route" "full" '((18.000 12.999) (18.750 12.999)) 0 0 0 nil nil)
schCreateWireLabel(cv nil '(18.250 12.999) "VAMP6" "lowerLeft" "R0" "stick" 0.0625 nil)
schCreatePin(cv nil "VAMP6" "inputOutput" nil '(18.750 12.999) "R180")
schCreateWire(cv "route" "full" '((17.125 12.938) (16.375 12.938)) 0 0 0 nil nil)
schCreateWireLabel(cv nil '(16.875 12.938) "AVSS" "lowerRight" "R0" "stick" 0.0625 nil)
schCreateWire(cv "route" "full" '((17.125 13.312) (16.375 13.312)) 0 0 0 nil nil)
schCreateWireLabel(cv nil '(16.875 13.312) "GIOL" "lowerRight" "R0" "stick" 0.0625 nil)
schCreateWire(cv "route" "full" '((17.125 12.562) (16.375 12.562)) 0 0 0 nil nil)
schCreateWireLabel(cv nil '(16.875 12.562) "AVDD" "lowerRight" "R0" "stick" 0.0625 nil)
dbCreateInst(cv pdb3ac_h_gMaster "VAMP7_right6" '(18.0 15.1875) "R90")
schCreateWire(cv "route" "full" '((18.000 14.999) (18.750 14.999)) 0 0 0 nil nil)
schCreateWireLabel(cv nil '(18.250 14.999) "VAMP7" "lowerLeft" "R0" "stick" 0.0625 nil)
schCreatePin(cv nil "VAMP7" "inputOutput" nil '(18.750 14.999) "R180")
schCreateWire(cv "route" "full" '((17.125 14.938) (16.375 14.938)) 0 0 0 nil nil)
schCreateWireLabel(cv nil '(16.875 14.938) "AVSS" "lowerRight" "R0" "stick" 0.0625 nil)
schCreateWire(cv "route" "full" '((17.125 15.312) (16.375 15.312)) 0 0 0 nil nil)
schCreateWireLabel(cv nil '(16.875 15.312) "GIOL" "lowerRight" "R0" "stick" 0.0625 nil)
schCreateWire(cv "route" "full" '((17.125 14.562) (16.375 14.562)) 0 0 0 nil nil)
schCreateWireLabel(cv nil '(16.875 14.562) "AVDD" "lowerRight" "R0" "stick" 0.0625 nil)
dbCreateInst(cv pdb3ac_v_gMaster "VAMP8_top0" '(14.8125 18.0) "R180")
schCreateWire(cv "route" "full" '((15.001 18.000) (15.001 18.750)) 0 0 0 nil nil)
schCreateWireLabel(cv nil '(15.001 18.250) "VAMP8" "lowerLeft" "R90" "stick" 0.0625 nil)
schCreatePin(cv nil "VAMP8" "inputOutput" nil '(15.001 18.750) "R270")
schCreateWire(cv "route" "full" '((15.062 17.125) (15.062 16.375)) 0 0 0 nil nil)
schCreateWireLabel(cv nil '(15.062 16.875) "AVSS" "lowerRight" "R90" "stick" 0.0625 nil)
schCreateWire(cv "route" "full" '((14.688 17.125) (14.688 16.375)) 0 0 0 nil nil)
schCreateWireLabel(cv nil '(14.688 16.875) "GIOL" "lowerRight" "R90" "stick" 0.0625 nil)
schCreateWire(cv "route" "full" '((15.438 17.125) (15.438 16.375)) 0 0 0 nil nil)
schCreateWireLabel(cv nil '(15.438 16.875) "AVDD" "lowerRight" "R90" "stick" 0.0625 nil)
dbCreateInst(cv pdb3ac_v_gMaster "VAMP9_top1" '(12.8125 18.0) "R180")
schCreateWire(cv "route" "full" '((13.001 18.000) (13.001 18.750)) 0 0 0 nil nil)
schCreateWireLabel(cv nil '(13.001 18.250) "VAMP9" "lowerLeft" "R90" "stick" 0.0625 nil)
schCreatePin(cv nil "VAMP9" "inputOutput" nil '(13.001 18.750) "R270")
schCreateWire(cv "route" "full" '((13.062 17.125) (13.062 16.375)) 0 0 0 nil nil)
schCreateWireLabel(cv nil '(13.062 16.875) "AVSS" "lowerRight" "R90" "stick" 0.0625 nil)
schCreateWire(cv "route" "full" '((12.688 17.125) (12.688 16.375)) 0 0 0 nil nil)
schCreateWireLabel(cv nil '(12.688 16.875) "GIOL" "lowerRight" "R90" "stick" 0.0625 nil)
schCreateWire(cv "route" "full" '((13.438 17.125) (13.438 16.375)) 0 0 0 nil nil)
schCreateWireLabel(cv nil '(13.438 16.875) "AVDD" "lowerRight" "R90" "stick" 0.0625 nil)
dbCreateInst(cv pdb3ac_v_gMaster "VAMP10_top2" '(10.8125 18.0) "R180")
schCreateWire(cv "route" "full" '((11.001 18.000) (11.001 18.750)) 0 0 0 nil nil)
schCreateWireLabel(cv nil '(11.001 18.250) "VAMP10" "lowerLeft" "R90" "stick" 0.0625 nil)
schCreatePin(cv nil "VAMP10" "inputOutput" nil '(11.001 18.750) "R270")
schCreateWire(cv "route" "full" '((11.062 17.125) (11.062 16.375)) 0 0 0 nil nil)
schCreateWireLabel(cv nil '(11.062 16.875) "AVSS" "lowerRight" "R90" "stick" 0.0625 nil)
schCreateWire(cv "route" "full" '((10.688 17.125) (10.688 16.375)) 0 0 0 nil nil)
schCreateWireLabel(cv nil '(10.688 16.875) "GIOL" "lowerRight" "R90" "stick" 0.0625 nil)
schCreateWire(cv "route" "full" '((11.438 17.125) (11.438 16.375)) 0 0 0 nil nil)
schCreateWireLabel(cv nil '(11.438 16.875) "AVDD" "lowerRight" "R90" "stick" 0.0625 nil)
dbCreateInst(cv pdb3ac_v_gMaster "VAMP11_top3" '(8.8125 18.0) "R180")
schCreateWire(cv "route" "full" '((9.001 18.000) (9.001 18.750)) 0 0 0 nil nil)
schCreateWireLabel(cv nil '(9.001 18.250) "VAMP11" "lowerLeft" "R90" "stick" 0.0625 nil)
schCreatePin(cv nil "VAMP11" "inputOutput" nil '(9.001 18.750) "R270")
schCreateWire(cv "route" "full" '((9.062 17.125) (9.062 16.375)) 0 0 0 nil nil)
schCreateWireLabel(cv nil '(9.062 16.875) "AVSS" "lowerRight" "R90" "stick" 0.0625 nil)
schCreateWire(cv "route" "full" '((8.688 17.125) (8.688 16.375)) 0 0 0 nil nil)
schCreateWireLabel(cv nil '(8.688 16.875) "GIOL" "lowerRight" "R90" "stick" 0.0625 nil)
schCreateWire(cv "route" "full" '((9.438 17.125) (9.438 16.375)) 0 0 0 nil nil)
schCreateWireLabel(cv nil '(9.438 16.875) "AVDD" "lowerRight" "R90" "stick" 0.0625 nil)
dbCreateInst(cv pdb3ac_v_gMaster "VAMP12_top4" '(6.8125 18.0) "R180")
schCreateWire(cv "route" "full" '((7.000 18.000) (7.000 18.750)) 0 0 0 nil nil)
schCreateWireLabel(cv nil '(7.000 18.250) "VAMP12" "lowerLeft" "R90" "stick" 0.0625 nil)
schCreatePin(cv nil "VAMP12" "inputOutput" nil '(7.000 18.750) "R270")
schCreateWire(cv "route" "full" '((7.062 17.125) (7.062 16.375)) 0 0 0 nil nil)
schCreateWireLabel(cv nil '(7.062 16.875) "AVSS" "lowerRight" "R90" "stick" 0.0625 nil)
schCreateWire(cv "route" "full" '((6.688 17.125) (6.688 16.375)) 0 0 0 nil nil)
schCreateWireLabel(cv nil '(6.688 16.875) "GIOL" "lowerRight" "R90" "stick" 0.0625 nil)
schCreateWire(cv "route" "full" '((7.438 17.125) (7.438 16.375)) 0 0 0 nil nil)
schCreateWireLabel(cv nil '(7.438 16.875) "AVDD" "lowerRight" "R90" "stick" 0.0625 nil)
dbCreateInst(cv pdb3ac_v_gMaster "VAMP13_top5" '(4.8125 18.0) "R180")
schCreateWire(cv "route" "full" '((5.000 18.000) (5.000 18.750)) 0 0 0 nil nil)
schCreateWireLabel(cv nil '(5.000 18.250) "VAMP13" "lowerLeft" "R90" "stick" 0.0625 nil)
schCreatePin(cv nil "VAMP13" "inputOutput" nil '(5.000 18.750) "R270")
schCreateWire(cv "route" "full" '((5.062 17.125) (5.062 16.375)) 0 0 0 nil nil)
schCreateWireLabel(cv nil '(5.062 16.875) "AVSS" "lowerRight" "R90" "stick" 0.0625 nil)
schCreateWire(cv "route" "full" '((4.688 17.125) (4.688 16.375)) 0 0 0 nil nil)
schCreateWireLabel(cv nil '(4.688 16.875) "GIOL" "lowerRight" "R90" "stick" 0.0625 nil)
schCreateWire(cv "route" "full" '((5.438 17.125) (5.438 16.375)) 0 0 0 nil nil)
schCreateWireLabel(cv nil '(5.438 16.875) "AVDD" "lowerRight" "R90" "stick" 0.0625 nil)
dbCreateInst(cv pdb3ac_v_gMaster "VAMP14_top6" '(2.8125 18.0) "R180")
schCreateWire(cv "route" "full" '((3.001 18.000) (3.001 18.750)) 0 0 0 nil nil)
schCreateWireLabel(cv nil '(3.001 18.250) "VAMP14" "lowerLeft" "R90" "stick" 0.0625 nil)
schCreatePin(cv nil "VAMP14" "inputOutput" nil '(3.001 18.750) "R270")
schCreateWire(cv "route" "full" '((3.062 17.125) (3.062 16.375)) 0 0 0 nil nil)
schCreateWireLabel(cv nil '(3.062 16.875) "AVSS" "lowerRight" "R90" "stick" 0.0625 nil)
schCreateWire(cv "route" "full" '((2.688 17.125) (2.688 16.375)) 0 0 0 nil nil)
schCreateWireLabel(cv nil '(2.688 16.875) "GIOL" "lowerRight" "R90" "stick" 0.0625 nil)
schCreateWire(cv "route" "full" '((3.438 17.125) (3.438 16.375)) 0 0 0 nil nil)
schCreateWireLabel(cv nil '(3.438 16.875) "AVDD" "lowerRight" "R90" "stick" 0.0625 nil)
schCheck(cv)
dbSave(cv)
t
