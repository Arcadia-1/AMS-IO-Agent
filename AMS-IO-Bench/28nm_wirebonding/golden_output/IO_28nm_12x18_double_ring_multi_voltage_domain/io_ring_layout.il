; Generated Layout Script with Dual Ring Support

; ==================== All Components (Sorted by Placement Order) ====================
dbCreateParamInstByMasterName(cv "tphn28hpcpgv18" "PDB3AC_H_G" "layout" "VSS_CDAC_left_11" list(0 150) "R270")
dbCreateParamInstByMasterName(cv "PAD" "PAD60GU" "layout" "pad60gu_VSS_CDAC_left_11" list(0 150) "R270")
dbCreateParamInstByMasterName(cv "tphn28hpcpgv18" "PDB3AC_H_G" "layout" "VDD_CDAC_left_10" list(0 210) "R270")
dbCreateParamInstByMasterName(cv "PAD" "PAD60GU" "layout" "pad60gu_VDD_CDAC_left_10" list(0 210) "R270")
dbCreateParamInstByMasterName(cv "tphn28hpcpgv18" "PDB3AC_H_G" "layout" "IB12_left_9" list(0 270) "R270")
dbCreateParamInstByMasterName(cv "PAD" "PAD60GU" "layout" "pad60gu_IB12_left_9" list(0 270) "R270")
dbCreateParamInstByMasterName(cv "tphn28hpcpgv18" "PVDD1AC_H_G" "layout" "VDD12_left_8" list(0 330) "R270")
dbCreateParamInstByMasterName(cv "PAD" "PAD60GU" "layout" "pad60gu_VDD12_left_8" list(0 330) "R270")
dbCreateParamInstByMasterName(cv "tphn28hpcpgv18" "PDB3AC_H_G" "layout" "IB3_left_7" list(0 390) "R270")
dbCreateParamInstByMasterName(cv "PAD" "PAD60GU" "layout" "pad60gu_IB3_left_7" list(0 390) "R270")
dbCreateParamInstByMasterName(cv "tphn28hpcpgv18" "PVDD1AC_H_G" "layout" "VDD3_left_6" list(0 450) "R270")
dbCreateParamInstByMasterName(cv "PAD" "PAD60GU" "layout" "pad60gu_VDD3_left_6" list(0 450) "R270")
dbCreateParamInstByMasterName(cv "tphn28hpcpgv18" "PVSS2DGZ_H_G" "layout" "GIOH_left_5" list(0 510) "R270")
dbCreateParamInstByMasterName(cv "PAD" "PAD60GU" "layout" "pad60gu_GIOH_left_5" list(0 510) "R270")
dbCreateParamInstByMasterName(cv "tphn28hpcpgv18" "PVDD2POC_H_G" "layout" "VIOH_left_4" list(0 570) "R270")
dbCreateParamInstByMasterName(cv "PAD" "PAD60GU" "layout" "pad60gu_VIOH_left_4" list(0 570) "R270")
dbCreateParamInstByMasterName(cv "tphn28hpcpgv18" "PVSS1DGZ_H_G" "layout" "GIOL_left_3" list(0 630) "R270")
dbCreateParamInstByMasterName(cv "PAD" "PAD60GU" "layout" "pad60gu_GIOL_left_3" list(0 630) "R270")
dbCreateParamInstByMasterName(cv "tphn28hpcpgv18" "PVDD1DGZ_H_G" "layout" "VIOL_left_2" list(0 690) "R270")
dbCreateParamInstByMasterName(cv "PAD" "PAD60GU" "layout" "pad60gu_VIOL_left_2" list(0 690) "R270")
dbCreateParamInstByMasterName(cv "tphn28hpcpgv18" "PDDW16SDGZ_H_G" "layout" "SYNC_left_1" list(0 750) "R270")
dbCreateParamInstByMasterName(cv "PAD" "PAD60GU" "layout" "pad60gu_SYNC_left_1" list(0 750) "R270")
dbCreateParamInstByMasterName(cv "tphn28hpcpgv18" "PDDW16SDGZ_H_G" "layout" "DCLK_left_0" list(0 810) "R270")
dbCreateParamInstByMasterName(cv "PAD" "PAD60GU" "layout" "pad60gu_DCLK_left_0" list(0 810) "R270")
dbCreateParamInstByMasterName(cv "tphn28hpcpgv18" "PCORNER_G" "layout" "CORNER_TOPLEFT_top_left" list(0 940) "R270")
dbCreateParamInstByMasterName(cv "tphn28hpcpgv18" "PDB3AC_V_G" "layout" "VSSCLK_bottom_17" list(1150 0) "R0")
dbCreateParamInstByMasterName(cv "PAD" "PAD60GU" "layout" "pad60gu_VSSCLK_bottom_17" list(1150 0) "R0")
dbCreateParamInstByMasterName(cv "tphn28hpcpgv18" "PDB3AC_V_G" "layout" "VCM_bottom_16" list(1090 0) "R0")
dbCreateParamInstByMasterName(cv "PAD" "PAD60GU" "layout" "pad60gu_VCM_bottom_16" list(1090 0) "R0")
dbCreateParamInstByMasterName(cv "tphn28hpcpgv18" "PVSS3AC_V_G" "layout" "GND_DAT_bottom_15" list(1030 0) "R0")
dbCreateParamInstByMasterName(cv "PAD" "PAD60GU" "layout" "pad60gu_GND_DAT_bottom_15" list(1030 0) "R0")
dbCreateParamInstByMasterName(cv "tphn28hpcpgv18" "PVDD3AC_V_G" "layout" "VDD_DAT_bottom_14" list(970 0) "R0")
dbCreateParamInstByMasterName(cv "PAD" "PAD60GU" "layout" "pad60gu_VDD_DAT_bottom_14" list(970 0) "R0")
dbCreateParamInstByMasterName(cv "tphn28hpcpgv18" "PDB3AC_V_G" "layout" "CLKN_bottom_13" list(910 0) "R0")
dbCreateParamInstByMasterName(cv "PAD" "PAD60GU" "layout" "pad60gu_CLKN_bottom_13" list(910 0) "R0")
dbCreateParamInstByMasterName(cv "tphn28hpcpgv18" "PDB3AC_V_G" "layout" "CLKP_bottom_12" list(850 0) "R0")
dbCreateParamInstByMasterName(cv "PAD" "PAD60GU" "layout" "pad60gu_CLKP_bottom_12" list(850 0) "R0")
dbCreateParamInstByMasterName(cv "tphn28hpcpgv18" "PVDD3AC_V_G" "layout" "VDD_CKB_bottom_11" list(790 0) "R0")
dbCreateParamInstByMasterName(cv "PAD" "PAD60GU" "layout" "pad60gu_VDD_CKB_bottom_11" list(790 0) "R0")
dbCreateParamInstByMasterName(cv "tphn28hpcpgv18" "PVSS3AC_V_G" "layout" "GND_CKB_bottom_10" list(730 0) "R0")
dbCreateParamInstByMasterName(cv "PAD" "PAD60GU" "layout" "pad60gu_GND_CKB_bottom_10" list(730 0) "R0")
dbCreateParamInstByMasterName(cv "tphn28hpcpgv18" "PDB3AC_V_G" "layout" "VINCM_bottom_9" list(670 0) "R0")
dbCreateParamInstByMasterName(cv "PAD" "PAD60GU" "layout" "pad60gu_VINCM_bottom_9" list(670 0) "R0")
dbCreateParamInstByMasterName(cv "tphn28hpcpgv18" "PDB3AC_V_G" "layout" "VINN_bottom_8" list(610 0) "R0")
dbCreateParamInstByMasterName(cv "PAD" "PAD60GU" "layout" "pad60gu_VINN_bottom_8" list(610 0) "R0")
dbCreateParamInstByMasterName(cv "tphn28hpcpgv18" "PDB3AC_V_G" "layout" "VINP_bottom_7" list(550 0) "R0")
dbCreateParamInstByMasterName(cv "PAD" "PAD60GU" "layout" "pad60gu_VINP_bottom_7" list(550 0) "R0")
dbCreateParamInstByMasterName(cv "tphn28hpcpgv18" "PVSS3AC_V_G" "layout" "VSSIB_bottom_6" list(490 0) "R0")
dbCreateParamInstByMasterName(cv "PAD" "PAD60GU" "layout" "pad60gu_VSSIB_bottom_6" list(490 0) "R0")
dbCreateParamInstByMasterName(cv "tphn28hpcpgv18" "PVDD3AC_V_G" "layout" "VDDIB_bottom_5" list(430 0) "R0")
dbCreateParamInstByMasterName(cv "PAD" "PAD60GU" "layout" "pad60gu_VDDIB_bottom_5" list(430 0) "R0")
dbCreateParamInstByMasterName(cv "tphn28hpcpgv18" "PDB3AC_V_G" "layout" "BIAS2_bottom_4" list(370 0) "R0")
dbCreateParamInstByMasterName(cv "PAD" "PAD60GU" "layout" "pad60gu_BIAS2_bottom_4" list(370 0) "R0")
dbCreateParamInstByMasterName(cv "tphn28hpcpgv18" "PDB3AC_V_G" "layout" "IBUF_IBIAS_bottom_3" list(310 0) "R0")
dbCreateParamInstByMasterName(cv "PAD" "PAD60GU" "layout" "pad60gu_IBUF_IBIAS_bottom_3" list(310 0) "R0")
dbCreateParamInstByMasterName(cv "tphn28hpcpgv18" "PVSS1AC_V_G" "layout" "VSS_bottom_2" list(250 0) "R0")
dbCreateParamInstByMasterName(cv "PAD" "PAD60GU" "layout" "pad60gu_VSS_bottom_2" list(250 0) "R0")
dbCreateParamInstByMasterName(cv "tphn28hpcpgv18" "PDB3AC_V_G" "layout" "IBREF_bottom_1" list(190 0) "R0")
dbCreateParamInstByMasterName(cv "PAD" "PAD60GU" "layout" "pad60gu_IBREF_bottom_1" list(190 0) "R0")
dbCreateParamInstByMasterName(cv "tphn28hpcpgv18" "PDB3AC_V_G" "layout" "VREFDES_bottom_0" list(130 0) "R0")
dbCreateParamInstByMasterName(cv "PAD" "PAD60GU" "layout" "pad60gu_VREFDES_bottom_0" list(130 0) "R0")
dbCreateParamInstByMasterName(cv "tphn28hpcpgv18" "PCORNERA_G" "layout" "CORNER_BOTTOMLEFT_bottom_left" list(0 0) "R0")
dbCreateParamInstByMasterName(cv "tphn28hpcpgv18" "PDDW16SDGZ_H_G" "layout" "SCK_right_11" list(1300 790) "R90")
dbCreateParamInstByMasterName(cv "PAD" "PAD60GU" "layout" "pad60gu_SCK_right_11" list(1300 790) "R90")
dbCreateParamInstByMasterName(cv "tphn28hpcpgv18" "PDDW16SDGZ_H_G" "layout" "SDI_right_10" list(1300 730) "R90")
dbCreateParamInstByMasterName(cv "PAD" "PAD60GU" "layout" "pad60gu_SDI_right_10" list(1300 730) "R90")
dbCreateParamInstByMasterName(cv "tphn28hpcpgv18" "PDDW16SDGZ_H_G" "layout" "SLP_right_9" list(1300 670) "R90")
dbCreateParamInstByMasterName(cv "PAD" "PAD60GU" "layout" "pad60gu_SLP_right_9" list(1300 670) "R90")
dbCreateParamInstByMasterName(cv "tphn28hpcpgv18" "PDB3AC_H_G" "layout" "IBREF3_right_8" list(1300 610) "R90")
dbCreateParamInstByMasterName(cv "PAD" "PAD60GU" "layout" "pad60gu_IBREF3_right_8" list(1300 610) "R90")
dbCreateParamInstByMasterName(cv "tphn28hpcpgv18" "PDB3AC_H_G" "layout" "VREFDES3_right_7" list(1300 550) "R90")
dbCreateParamInstByMasterName(cv "PAD" "PAD60GU" "layout" "pad60gu_VREFDES3_right_7" list(1300 550) "R90")
dbCreateParamInstByMasterName(cv "tphn28hpcpgv18" "PDB3AC_H_G" "layout" "IBREF2_right_6" list(1300 490) "R90")
dbCreateParamInstByMasterName(cv "PAD" "PAD60GU" "layout" "pad60gu_IBREF2_right_6" list(1300 490) "R90")
dbCreateParamInstByMasterName(cv "tphn28hpcpgv18" "PDB3AC_H_G" "layout" "VREFDES2_right_5" list(1300 430) "R90")
dbCreateParamInstByMasterName(cv "PAD" "PAD60GU" "layout" "pad60gu_VREFDES2_right_5" list(1300 430) "R90")
dbCreateParamInstByMasterName(cv "tphn28hpcpgv18" "PVSS1AC_H_G" "layout" "VSSSAR_right_4" list(1300 370) "R90")
dbCreateParamInstByMasterName(cv "PAD" "PAD60GU" "layout" "pad60gu_VSSSAR_right_4" list(1300 370) "R90")
dbCreateParamInstByMasterName(cv "tphn28hpcpgv18" "PVDD1AC_H_G" "layout" "VDDSAR_right_3" list(1300 310) "R90")
dbCreateParamInstByMasterName(cv "PAD" "PAD60GU" "layout" "pad60gu_VDDSAR_right_3" list(1300 310) "R90")
dbCreateParamInstByMasterName(cv "tphn28hpcpgv18" "PDB3AC_H_G" "layout" "AVSS_right_2" list(1300 250) "R90")
dbCreateParamInstByMasterName(cv "PAD" "PAD60GU" "layout" "pad60gu_AVSS_right_2" list(1300 250) "R90")
dbCreateParamInstByMasterName(cv "tphn28hpcpgv18" "PDB3AC_H_G" "layout" "AVDD_right_1" list(1300 190) "R90")
dbCreateParamInstByMasterName(cv "PAD" "PAD60GU" "layout" "pad60gu_AVDD_right_1" list(1300 190) "R90")
dbCreateParamInstByMasterName(cv "tphn28hpcpgv18" "PDB3AC_H_G" "layout" "VDDCLK_right_0" list(1300 130) "R90")
dbCreateParamInstByMasterName(cv "PAD" "PAD60GU" "layout" "pad60gu_VDDCLK_right_0" list(1300 130) "R90")
dbCreateParamInstByMasterName(cv "tphn28hpcpgv18" "PCORNERA_G" "layout" "CORNER_BOTTOMRIGHT_bottom_right" list(1300 0) "R90")
dbCreateParamInstByMasterName(cv "tphn28hpcpgv18" "PDDW16SDGZ_V_G" "layout" "RSTN_top_17" list(150 940) "R180")
dbCreateParamInstByMasterName(cv "PAD" "PAD60GU" "layout" "pad60gu_RSTN_top_17" list(150 940) "R180")
dbCreateParamInstByMasterName(cv "tphn28hpcpgv18" "PDDW16SDGZ_V_G" "layout" "EN_top_16" list(210 940) "R180")
dbCreateParamInstByMasterName(cv "PAD" "PAD60GU" "layout" "pad60gu_EN_top_16" list(210 940) "R180")
dbCreateParamInstByMasterName(cv "tphn28hpcpgv18" "PDDW16SDGZ_V_G" "layout" "CS_top_15" list(270 940) "R180")
dbCreateParamInstByMasterName(cv "PAD" "PAD60GU" "layout" "pad60gu_CS_top_15" list(270 940) "R180")
dbCreateParamInstByMasterName(cv "tphn28hpcpgv18" "PDDW16SDGZ_V_G" "layout" "D11_top_14" list(330 940) "R180")
dbCreateParamInstByMasterName(cv "PAD" "PAD60GU" "layout" "pad60gu_D11_top_14" list(330 940) "R180")
dbCreateParamInstByMasterName(cv "tphn28hpcpgv18" "PDDW16SDGZ_V_G" "layout" "D12_top_13" list(390 940) "R180")
dbCreateParamInstByMasterName(cv "PAD" "PAD60GU" "layout" "pad60gu_D12_top_13" list(390 940) "R180")
dbCreateParamInstByMasterName(cv "tphn28hpcpgv18" "PDDW16SDGZ_V_G" "layout" "D10_top_12" list(450 940) "R180")
dbCreateParamInstByMasterName(cv "PAD" "PAD60GU" "layout" "pad60gu_D10_top_12" list(450 940) "R180")
dbCreateParamInstByMasterName(cv "tphn28hpcpgv18" "PDDW16SDGZ_V_G" "layout" "D9_top_11" list(510 940) "R180")
dbCreateParamInstByMasterName(cv "PAD" "PAD60GU" "layout" "pad60gu_D9_top_11" list(510 940) "R180")
dbCreateParamInstByMasterName(cv "tphn28hpcpgv18" "PDDW16SDGZ_V_G" "layout" "D8_top_10" list(570 940) "R180")
dbCreateParamInstByMasterName(cv "PAD" "PAD60GU" "layout" "pad60gu_D8_top_10" list(570 940) "R180")
dbCreateParamInstByMasterName(cv "tphn28hpcpgv18" "PDDW16SDGZ_V_G" "layout" "D7_top_9" list(630 940) "R180")
dbCreateParamInstByMasterName(cv "PAD" "PAD60GU" "layout" "pad60gu_D7_top_9" list(630 940) "R180")
dbCreateParamInstByMasterName(cv "tphn28hpcpgv18" "PDDW16SDGZ_V_G" "layout" "D6_top_8" list(690 940) "R180")
dbCreateParamInstByMasterName(cv "PAD" "PAD60GU" "layout" "pad60gu_D6_top_8" list(690 940) "R180")
dbCreateParamInstByMasterName(cv "tphn28hpcpgv18" "PDDW16SDGZ_V_G" "layout" "D5_top_7" list(750 940) "R180")
dbCreateParamInstByMasterName(cv "PAD" "PAD60GU" "layout" "pad60gu_D5_top_7" list(750 940) "R180")
dbCreateParamInstByMasterName(cv "tphn28hpcpgv18" "PDDW16SDGZ_V_G" "layout" "D4_top_6" list(810 940) "R180")
dbCreateParamInstByMasterName(cv "PAD" "PAD60GU" "layout" "pad60gu_D4_top_6" list(810 940) "R180")
dbCreateParamInstByMasterName(cv "tphn28hpcpgv18" "PDDW16SDGZ_V_G" "layout" "D3_top_5" list(870 940) "R180")
dbCreateParamInstByMasterName(cv "PAD" "PAD60GU" "layout" "pad60gu_D3_top_5" list(870 940) "R180")
dbCreateParamInstByMasterName(cv "tphn28hpcpgv18" "PDDW16SDGZ_V_G" "layout" "D2_top_4" list(930 940) "R180")
dbCreateParamInstByMasterName(cv "PAD" "PAD60GU" "layout" "pad60gu_D2_top_4" list(930 940) "R180")
dbCreateParamInstByMasterName(cv "tphn28hpcpgv18" "PDDW16SDGZ_V_G" "layout" "D1_top_3" list(990 940) "R180")
dbCreateParamInstByMasterName(cv "PAD" "PAD60GU" "layout" "pad60gu_D1_top_3" list(990 940) "R180")
dbCreateParamInstByMasterName(cv "tphn28hpcpgv18" "PDDW16SDGZ_V_G" "layout" "D0_top_2" list(1050 940) "R180")
dbCreateParamInstByMasterName(cv "PAD" "PAD60GU" "layout" "pad60gu_D0_top_2" list(1050 940) "R180")
dbCreateParamInstByMasterName(cv "tphn28hpcpgv18" "PDDW16SDGZ_V_G" "layout" "RST_top_1" list(1110 940) "R180")
dbCreateParamInstByMasterName(cv "PAD" "PAD60GU" "layout" "pad60gu_RST_top_1" list(1110 940) "R180")
dbCreateParamInstByMasterName(cv "tphn28hpcpgv18" "PDDW16SDGZ_V_G" "layout" "SDO_top_0" list(1170 940) "R180")
dbCreateParamInstByMasterName(cv "PAD" "PAD60GU" "layout" "pad60gu_SDO_top_0" list(1170 940) "R180")
dbCreateParamInstByMasterName(cv "tphn28hpcpgv18" "PCORNER_G" "layout" "CORNER_TOPRIGHT_top_right" list(1300 940) "R180")

; ==================== Filler Components ====================
dbCreateParamInstByMasterName(cv "tphn28hpcpgv18" "PFILLER20A_G" "layout" "sep_bottom_right_corner" list(1170 0) "R0")
dbCreateParamInstByMasterName(cv "tphn28hpcpgv18" "PFILLER20A_G" "layout" "filler_bottom_left_corner" list(110 0) "R0")
dbCreateParamInstByMasterName(cv "tphn28hpcpgv18" "PFILLER20A_G" "layout" "filler_R0_1_1" list(1130 0) "R0")
dbCreateParamInstByMasterName(cv "tphn28hpcpgv18" "PFILLER20A_G" "layout" "filler_R0_1_2" list(1110 0) "R0")
dbCreateParamInstByMasterName(cv "tphn28hpcpgv18" "PFILLER20A_G" "layout" "filler_R0_2_1" list(1070 0) "R0")
dbCreateParamInstByMasterName(cv "tphn28hpcpgv18" "PFILLER20A_G" "layout" "filler_R0_2_2" list(1050 0) "R0")
dbCreateParamInstByMasterName(cv "tphn28hpcpgv18" "PFILLER20A_G" "layout" "filler_R0_3_1" list(1010 0) "R0")
dbCreateParamInstByMasterName(cv "tphn28hpcpgv18" "PFILLER20A_G" "layout" "filler_R0_3_2" list(990 0) "R0")
dbCreateParamInstByMasterName(cv "tphn28hpcpgv18" "PRCUTA_G" "layout" "filler_R0_4_1" list(950 0) "R0")
dbCreateParamInstByMasterName(cv "tphn28hpcpgv18" "PRCUTA_G" "layout" "filler_R0_4_2" list(930 0) "R0")
dbCreateParamInstByMasterName(cv "tphn28hpcpgv18" "PFILLER20A_G" "layout" "filler_R0_5_1" list(890 0) "R0")
dbCreateParamInstByMasterName(cv "tphn28hpcpgv18" "PFILLER20A_G" "layout" "filler_R0_5_2" list(870 0) "R0")
dbCreateParamInstByMasterName(cv "tphn28hpcpgv18" "PFILLER20A_G" "layout" "filler_R0_6_1" list(830 0) "R0")
dbCreateParamInstByMasterName(cv "tphn28hpcpgv18" "PFILLER20A_G" "layout" "filler_R0_6_2" list(810 0) "R0")
dbCreateParamInstByMasterName(cv "tphn28hpcpgv18" "PFILLER20A_G" "layout" "filler_R0_7_1" list(770 0) "R0")
dbCreateParamInstByMasterName(cv "tphn28hpcpgv18" "PFILLER20A_G" "layout" "filler_R0_7_2" list(750 0) "R0")
dbCreateParamInstByMasterName(cv "tphn28hpcpgv18" "PRCUTA_G" "layout" "filler_R0_8_1" list(710 0) "R0")
dbCreateParamInstByMasterName(cv "tphn28hpcpgv18" "PRCUTA_G" "layout" "filler_R0_8_2" list(690 0) "R0")
dbCreateParamInstByMasterName(cv "tphn28hpcpgv18" "PFILLER20A_G" "layout" "filler_R0_9_1" list(650 0) "R0")
dbCreateParamInstByMasterName(cv "tphn28hpcpgv18" "PFILLER20A_G" "layout" "filler_R0_9_2" list(630 0) "R0")
dbCreateParamInstByMasterName(cv "tphn28hpcpgv18" "PFILLER20A_G" "layout" "filler_R0_10_1" list(590 0) "R0")
dbCreateParamInstByMasterName(cv "tphn28hpcpgv18" "PFILLER20A_G" "layout" "filler_R0_10_2" list(570 0) "R0")
dbCreateParamInstByMasterName(cv "tphn28hpcpgv18" "PFILLER20A_G" "layout" "filler_R0_11_1" list(530 0) "R0")
dbCreateParamInstByMasterName(cv "tphn28hpcpgv18" "PFILLER20A_G" "layout" "filler_R0_11_2" list(510 0) "R0")
dbCreateParamInstByMasterName(cv "tphn28hpcpgv18" "PFILLER20A_G" "layout" "filler_R0_12_1" list(470 0) "R0")
dbCreateParamInstByMasterName(cv "tphn28hpcpgv18" "PFILLER20A_G" "layout" "filler_R0_12_2" list(450 0) "R0")
dbCreateParamInstByMasterName(cv "tphn28hpcpgv18" "PFILLER20A_G" "layout" "filler_R0_13_1" list(410 0) "R0")
dbCreateParamInstByMasterName(cv "tphn28hpcpgv18" "PFILLER20A_G" "layout" "filler_R0_13_2" list(390 0) "R0")
dbCreateParamInstByMasterName(cv "tphn28hpcpgv18" "PFILLER20A_G" "layout" "filler_R0_14_1" list(350 0) "R0")
dbCreateParamInstByMasterName(cv "tphn28hpcpgv18" "PFILLER20A_G" "layout" "filler_R0_14_2" list(330 0) "R0")
dbCreateParamInstByMasterName(cv "tphn28hpcpgv18" "PFILLER20A_G" "layout" "filler_R0_15_1" list(290 0) "R0")
dbCreateParamInstByMasterName(cv "tphn28hpcpgv18" "PFILLER20A_G" "layout" "filler_R0_15_2" list(270 0) "R0")
dbCreateParamInstByMasterName(cv "tphn28hpcpgv18" "PFILLER20A_G" "layout" "filler_R0_16_1" list(230 0) "R0")
dbCreateParamInstByMasterName(cv "tphn28hpcpgv18" "PFILLER20A_G" "layout" "filler_R0_16_2" list(210 0) "R0")
dbCreateParamInstByMasterName(cv "tphn28hpcpgv18" "PFILLER20A_G" "layout" "filler_R0_17_1" list(170 0) "R0")
dbCreateParamInstByMasterName(cv "tphn28hpcpgv18" "PFILLER20A_G" "layout" "filler_R0_17_2" list(150 0) "R0")
dbCreateParamInstByMasterName(cv "tphn28hpcpgv18" "PFILLER20_G" "layout" "filler_right_top_corner" list(1300 810) "R90")
dbCreateParamInstByMasterName(cv "tphn28hpcpgv18" "PFILLER20A_G" "layout" "filler_right_bottom_corner" list(1300 110) "R90")
dbCreateParamInstByMasterName(cv "tphn28hpcpgv18" "PFILLER20_G" "layout" "filler_R90_1_1" list(1300 770) "R90")
dbCreateParamInstByMasterName(cv "tphn28hpcpgv18" "PFILLER20_G" "layout" "filler_R90_1_2" list(1300 750) "R90")
dbCreateParamInstByMasterName(cv "tphn28hpcpgv18" "PFILLER20_G" "layout" "filler_R90_2_1" list(1300 710) "R90")
dbCreateParamInstByMasterName(cv "tphn28hpcpgv18" "PFILLER20_G" "layout" "filler_R90_2_2" list(1300 690) "R90")
dbCreateParamInstByMasterName(cv "tphn28hpcpgv18" "PRCUTA_G" "layout" "filler_R90_3_1" list(1300 650) "R90")
dbCreateParamInstByMasterName(cv "tphn28hpcpgv18" "PRCUTA_G" "layout" "filler_R90_3_2" list(1300 630) "R90")
dbCreateParamInstByMasterName(cv "tphn28hpcpgv18" "PFILLER20A_G" "layout" "filler_R90_4_1" list(1300 590) "R90")
dbCreateParamInstByMasterName(cv "tphn28hpcpgv18" "PFILLER20A_G" "layout" "filler_R90_4_2" list(1300 570) "R90")
dbCreateParamInstByMasterName(cv "tphn28hpcpgv18" "PFILLER20A_G" "layout" "filler_R90_5_1" list(1300 530) "R90")
dbCreateParamInstByMasterName(cv "tphn28hpcpgv18" "PFILLER20A_G" "layout" "filler_R90_5_2" list(1300 510) "R90")
dbCreateParamInstByMasterName(cv "tphn28hpcpgv18" "PFILLER20A_G" "layout" "filler_R90_6_1" list(1300 470) "R90")
dbCreateParamInstByMasterName(cv "tphn28hpcpgv18" "PFILLER20A_G" "layout" "filler_R90_6_2" list(1300 450) "R90")
dbCreateParamInstByMasterName(cv "tphn28hpcpgv18" "PFILLER20A_G" "layout" "filler_R90_7_1" list(1300 410) "R90")
dbCreateParamInstByMasterName(cv "tphn28hpcpgv18" "PFILLER20A_G" "layout" "filler_R90_7_2" list(1300 390) "R90")
dbCreateParamInstByMasterName(cv "tphn28hpcpgv18" "PFILLER20A_G" "layout" "filler_R90_8_1" list(1300 350) "R90")
dbCreateParamInstByMasterName(cv "tphn28hpcpgv18" "PFILLER20A_G" "layout" "filler_R90_8_2" list(1300 330) "R90")
dbCreateParamInstByMasterName(cv "tphn28hpcpgv18" "PFILLER20A_G" "layout" "filler_R90_9_1" list(1300 290) "R90")
dbCreateParamInstByMasterName(cv "tphn28hpcpgv18" "PFILLER20A_G" "layout" "filler_R90_9_2" list(1300 270) "R90")
dbCreateParamInstByMasterName(cv "tphn28hpcpgv18" "PFILLER20A_G" "layout" "filler_R90_10_1" list(1300 230) "R90")
dbCreateParamInstByMasterName(cv "tphn28hpcpgv18" "PFILLER20A_G" "layout" "filler_R90_10_2" list(1300 210) "R90")
dbCreateParamInstByMasterName(cv "tphn28hpcpgv18" "PFILLER20A_G" "layout" "filler_R90_11_1" list(1300 170) "R90")
dbCreateParamInstByMasterName(cv "tphn28hpcpgv18" "PFILLER20A_G" "layout" "filler_R90_11_2" list(1300 150) "R90")
dbCreateParamInstByMasterName(cv "tphn28hpcpgv18" "PFILLER20_G" "layout" "sep_top_left_corner" list(130 940) "R180")
dbCreateParamInstByMasterName(cv "tphn28hpcpgv18" "PFILLER20_G" "layout" "filler_top_right_corner" list(1190 940) "R180")
dbCreateParamInstByMasterName(cv "tphn28hpcpgv18" "PFILLER20_G" "layout" "filler_R180_1_1" list(170 940) "R180")
dbCreateParamInstByMasterName(cv "tphn28hpcpgv18" "PFILLER20_G" "layout" "filler_R180_1_2" list(190 940) "R180")
dbCreateParamInstByMasterName(cv "tphn28hpcpgv18" "PFILLER20_G" "layout" "filler_R180_2_1" list(230 940) "R180")
dbCreateParamInstByMasterName(cv "tphn28hpcpgv18" "PFILLER20_G" "layout" "filler_R180_2_2" list(250 940) "R180")
dbCreateParamInstByMasterName(cv "tphn28hpcpgv18" "PFILLER20_G" "layout" "filler_R180_3_1" list(290 940) "R180")
dbCreateParamInstByMasterName(cv "tphn28hpcpgv18" "PFILLER20_G" "layout" "filler_R180_3_2" list(310 940) "R180")
dbCreateParamInstByMasterName(cv "tphn28hpcpgv18" "PFILLER20_G" "layout" "filler_R180_4_1" list(350 940) "R180")
dbCreateParamInstByMasterName(cv "tphn28hpcpgv18" "PFILLER20_G" "layout" "filler_R180_4_2" list(370 940) "R180")
dbCreateParamInstByMasterName(cv "tphn28hpcpgv18" "PFILLER20_G" "layout" "filler_R180_5_1" list(410 940) "R180")
dbCreateParamInstByMasterName(cv "tphn28hpcpgv18" "PFILLER20_G" "layout" "filler_R180_5_2" list(430 940) "R180")
dbCreateParamInstByMasterName(cv "tphn28hpcpgv18" "PFILLER20_G" "layout" "filler_R180_6_1" list(470 940) "R180")
dbCreateParamInstByMasterName(cv "tphn28hpcpgv18" "PFILLER20_G" "layout" "filler_R180_6_2" list(490 940) "R180")
dbCreateParamInstByMasterName(cv "tphn28hpcpgv18" "PFILLER20_G" "layout" "filler_R180_7_1" list(530 940) "R180")
dbCreateParamInstByMasterName(cv "tphn28hpcpgv18" "PFILLER20_G" "layout" "filler_R180_7_2" list(550 940) "R180")
dbCreateParamInstByMasterName(cv "tphn28hpcpgv18" "PFILLER20_G" "layout" "filler_R180_8_1" list(590 940) "R180")
dbCreateParamInstByMasterName(cv "tphn28hpcpgv18" "PFILLER20_G" "layout" "filler_R180_8_2" list(610 940) "R180")
dbCreateParamInstByMasterName(cv "tphn28hpcpgv18" "PFILLER20_G" "layout" "filler_R180_9_1" list(650 940) "R180")
dbCreateParamInstByMasterName(cv "tphn28hpcpgv18" "PFILLER20_G" "layout" "filler_R180_9_2" list(670 940) "R180")
dbCreateParamInstByMasterName(cv "tphn28hpcpgv18" "PFILLER20_G" "layout" "filler_R180_10_1" list(710 940) "R180")
dbCreateParamInstByMasterName(cv "tphn28hpcpgv18" "PFILLER20_G" "layout" "filler_R180_10_2" list(730 940) "R180")
dbCreateParamInstByMasterName(cv "tphn28hpcpgv18" "PFILLER20_G" "layout" "filler_R180_11_1" list(770 940) "R180")
dbCreateParamInstByMasterName(cv "tphn28hpcpgv18" "PFILLER20_G" "layout" "filler_R180_11_2" list(790 940) "R180")
dbCreateParamInstByMasterName(cv "tphn28hpcpgv18" "PFILLER20_G" "layout" "filler_R180_12_1" list(830 940) "R180")
dbCreateParamInstByMasterName(cv "tphn28hpcpgv18" "PFILLER20_G" "layout" "filler_R180_12_2" list(850 940) "R180")
dbCreateParamInstByMasterName(cv "tphn28hpcpgv18" "PFILLER20_G" "layout" "filler_R180_13_1" list(890 940) "R180")
dbCreateParamInstByMasterName(cv "tphn28hpcpgv18" "PFILLER20_G" "layout" "filler_R180_13_2" list(910 940) "R180")
dbCreateParamInstByMasterName(cv "tphn28hpcpgv18" "PFILLER20_G" "layout" "filler_R180_14_1" list(950 940) "R180")
dbCreateParamInstByMasterName(cv "tphn28hpcpgv18" "PFILLER20_G" "layout" "filler_R180_14_2" list(970 940) "R180")
dbCreateParamInstByMasterName(cv "tphn28hpcpgv18" "PFILLER20_G" "layout" "filler_R180_15_1" list(1010 940) "R180")
dbCreateParamInstByMasterName(cv "tphn28hpcpgv18" "PFILLER20_G" "layout" "filler_R180_15_2" list(1030 940) "R180")
dbCreateParamInstByMasterName(cv "tphn28hpcpgv18" "PFILLER20_G" "layout" "filler_R180_16_1" list(1070 940) "R180")
dbCreateParamInstByMasterName(cv "tphn28hpcpgv18" "PFILLER20_G" "layout" "filler_R180_16_2" list(1090 940) "R180")
dbCreateParamInstByMasterName(cv "tphn28hpcpgv18" "PFILLER20_G" "layout" "filler_R180_17_1" list(1130 940) "R180")
dbCreateParamInstByMasterName(cv "tphn28hpcpgv18" "PFILLER20_G" "layout" "filler_R180_17_2" list(1150 940) "R180")
dbCreateParamInstByMasterName(cv "tphn28hpcpgv18" "PFILLER20A_G" "layout" "filler_left_bottom_corner" list(0 130) "R270")
dbCreateParamInstByMasterName(cv "tphn28hpcpgv18" "PFILLER20_G" "layout" "sep_left_top_corner" list(0 830) "R270")
dbCreateParamInstByMasterName(cv "tphn28hpcpgv18" "PFILLER20A_G" "layout" "filler_R270_1_1" list(0 170) "R270")
dbCreateParamInstByMasterName(cv "tphn28hpcpgv18" "PFILLER20A_G" "layout" "filler_R270_1_2" list(0 190) "R270")
dbCreateParamInstByMasterName(cv "tphn28hpcpgv18" "PFILLER20A_G" "layout" "filler_R270_2_1" list(0 230) "R270")
dbCreateParamInstByMasterName(cv "tphn28hpcpgv18" "PFILLER20A_G" "layout" "filler_R270_2_2" list(0 250) "R270")
dbCreateParamInstByMasterName(cv "tphn28hpcpgv18" "PFILLER20A_G" "layout" "filler_R270_3_1" list(0 290) "R270")
dbCreateParamInstByMasterName(cv "tphn28hpcpgv18" "PFILLER20A_G" "layout" "filler_R270_3_2" list(0 310) "R270")
dbCreateParamInstByMasterName(cv "tphn28hpcpgv18" "PFILLER20A_G" "layout" "filler_R270_4_1" list(0 350) "R270")
dbCreateParamInstByMasterName(cv "tphn28hpcpgv18" "PFILLER20A_G" "layout" "filler_R270_4_2" list(0 370) "R270")
dbCreateParamInstByMasterName(cv "tphn28hpcpgv18" "PFILLER20A_G" "layout" "filler_R270_5_1" list(0 410) "R270")
dbCreateParamInstByMasterName(cv "tphn28hpcpgv18" "PFILLER20A_G" "layout" "filler_R270_5_2" list(0 430) "R270")
dbCreateParamInstByMasterName(cv "tphn28hpcpgv18" "PRCUTA_G" "layout" "filler_R270_6_1" list(0 470) "R270")
dbCreateParamInstByMasterName(cv "tphn28hpcpgv18" "PRCUTA_G" "layout" "filler_R270_6_2" list(0 490) "R270")
dbCreateParamInstByMasterName(cv "tphn28hpcpgv18" "PFILLER20_G" "layout" "filler_R270_7_1" list(0 530) "R270")
dbCreateParamInstByMasterName(cv "tphn28hpcpgv18" "PFILLER20_G" "layout" "filler_R270_7_2" list(0 550) "R270")
dbCreateParamInstByMasterName(cv "tphn28hpcpgv18" "PFILLER20_G" "layout" "filler_R270_8_1" list(0 590) "R270")
dbCreateParamInstByMasterName(cv "tphn28hpcpgv18" "PFILLER20_G" "layout" "filler_R270_8_2" list(0 610) "R270")
dbCreateParamInstByMasterName(cv "tphn28hpcpgv18" "PFILLER20_G" "layout" "filler_R270_9_1" list(0 650) "R270")
dbCreateParamInstByMasterName(cv "tphn28hpcpgv18" "PFILLER20_G" "layout" "filler_R270_9_2" list(0 670) "R270")
dbCreateParamInstByMasterName(cv "tphn28hpcpgv18" "PFILLER20_G" "layout" "filler_R270_10_1" list(0 710) "R270")
dbCreateParamInstByMasterName(cv "tphn28hpcpgv18" "PFILLER20_G" "layout" "filler_R270_10_2" list(0 730) "R270")
dbCreateParamInstByMasterName(cv "tphn28hpcpgv18" "PFILLER20_G" "layout" "filler_R270_11_1" list(0 770) "R270")
dbCreateParamInstByMasterName(cv "tphn28hpcpgv18" "PFILLER20_G" "layout" "filler_R270_11_2" list(0 790) "R270")

; ==================== Digital IO Features (with Inner Pad Support) ====================
dbCreatePath(cv list("M3" "drawing") list(list(1189.5 670) list(1189.5 810)) 0.2)
dbCreatePath(cv list("M3" "drawing") list(list(1190.76 670) list(1190.76 810)) 0.2)
dbCreatePath(cv list("M3" "drawing") list(list(130 829.5) list(1170 829.5)) 0.2)
dbCreatePath(cv list("M3" "drawing") list(list(130 830.76) list(1170 830.76)) 0.2)
dbCreatePath(cv list("M3" "drawing") list(list(110.5 490) list(110.5 810)) 0.2)
dbCreatePath(cv list("M3" "drawing") list(list(109.24 490) list(109.24 810)) 0.2)
dbCreatePath(cv list("M3" "drawing") list(list(130 829.5) list(110.5 829.5)) 0.2 "extendExtend")
dbCreatePath(cv list("M3" "drawing") list(list(110.5 829.5) list(110.5 810)) 0.2 "extendExtend")
dbCreatePath(cv list("M3" "drawing") list(list(130 830.76) list(109.24 830.76)) 0.2 "extendExtend")
dbCreatePath(cv list("M3" "drawing") list(list(109.24 830.76) list(109.24 810)) 0.2 "extendExtend")
dbCreatePath(cv list("M3" "drawing") list(list(1170 829.5) list(1189.5 829.5)) 0.2 "extendExtend")
dbCreatePath(cv list("M3" "drawing") list(list(1189.5 829.5) list(1189.5 810)) 0.2 "extendExtend")
dbCreatePath(cv list("M3" "drawing") list(list(1170 830.76) list(1190.76 830.76)) 0.2 "extendExtend")
dbCreatePath(cv list("M3" "drawing") list(list(1190.76 830.76) list(1190.76 810)) 0.2 "extendExtend")
dbCreatePath(cv list("M3" "drawing") list(list(110.12 687.655) list(110.5 687.655)) 0.2)
tech = techGetTechFile(cv)
viaParams = list(list("cutRows" 2) list("cutColumns" 4))
viaDefId = techFindViaDefByName(tech "M3_M2")
newVia = dbCreateVia(cv viaDefId list(110.12 687.655) "R270" viaParams)
dbCreatePath(cv list("M3" "drawing") list(list(110.12 627.61) list(109.24 627.61)) 0.2)
tech = techGetTechFile(cv)
viaParams = list(list("cutRows" 2) list("cutColumns" 4))
viaDefId = techFindViaDefByName(tech "M3_M2")
newVia = dbCreateVia(cv viaDefId list(110.12 627.61) "R270" viaParams)
dbCreatePath(cv list("M3" "drawing") list(list(109.875 799.8) list(110.5 799.8)) 0.26)
dbCreatePath(cv list("M3" "drawing") list(list(109.875 804.1) list(109.24 804.1)) 0.26)
dbCreateLabel(cv list("M4" "pin") list(109.875 808.275) "DCLK_CORE" "centerLeft" "R0" "roman" 2)
dbCreatePath(cv list("M3" "drawing") list(list(109.875 739.8) list(110.5 739.8)) 0.26)
dbCreatePath(cv list("M3" "drawing") list(list(109.875 744.1) list(109.24 744.1)) 0.26)
dbCreateLabel(cv list("M4" "pin") list(109.875 748.275) "SYNC_CORE" "centerLeft" "R0" "roman" 2)
dbCreatePath(cv list("M3" "drawing") list(list(1190.76 680.2) list(1190.125 680.2)) 0.26)
dbCreatePath(cv list("M3" "drawing") list(list(1190.76 671.725) list(1190.125 671.725)) 0.26)
dbCreatePath(cv list("M3" "drawing") list(list(1189.5 675.9) list(1190.125 675.9)) 0.26)
dbCreateLabel(cv list("M4" "pin") list(1190.125 684.33) "SLP_CORE" "centerRight" "R0" "roman" 2)
dbCreatePath(cv list("M3" "drawing") list(list(1190.76 740.2) list(1190.125 740.2)) 0.26)
dbCreatePath(cv list("M3" "drawing") list(list(1190.76 731.725) list(1190.125 731.725)) 0.26)
dbCreatePath(cv list("M3" "drawing") list(list(1189.5 735.9) list(1190.125 735.9)) 0.26)
dbCreateLabel(cv list("M4" "pin") list(1190.125 744.33) "SDI_CORE" "centerRight" "R0" "roman" 2)
dbCreatePath(cv list("M3" "drawing") list(list(1190.76 800.2) list(1190.125 800.2)) 0.26)
dbCreatePath(cv list("M3" "drawing") list(list(1190.76 791.725) list(1190.125 791.725)) 0.26)
dbCreatePath(cv list("M3" "drawing") list(list(1189.5 795.9) list(1190.125 795.9)) 0.26)
dbCreateLabel(cv list("M4" "pin") list(1190.125 804.33) "SCK_CORE" "centerRight" "R0" "roman" 2)
dbCreatePath(cv list("M3" "drawing") list(list(1159.8 830.125) list(1159.8 829.5)) 0.26)
dbCreatePath(cv list("M3" "drawing") list(list(1164.1 830.125) list(1164.1 830.76)) 0.26)
dbCreateLabel(cv list("M4" "pin") list(1168.275 830.125) "SDO_CORE" "centerRight" "R90" "roman" 2)
dbCreatePath(cv list("M3" "drawing") list(list(1099.8 830.125) list(1099.8 830.76)) 0.26)
dbCreatePath(cv list("M3" "drawing") list(list(1108.275 830.125) list(1108.275 830.76)) 0.26)
dbCreatePath(cv list("M3" "drawing") list(list(1104.1 830.125) list(1104.1 829.5)) 0.26)
dbCreateLabel(cv list("M4" "pin") list(1095.67 830.125) "RST_CORE" "centerRight" "R90" "roman" 2)
dbCreatePath(cv list("M3" "drawing") list(list(1039.8 830.125) list(1039.8 829.5)) 0.26)
dbCreatePath(cv list("M3" "drawing") list(list(1044.1 830.125) list(1044.1 830.76)) 0.26)
dbCreateLabel(cv list("M4" "pin") list(1048.275 830.125) "D0_CORE" "centerRight" "R90" "roman" 2)
dbCreatePath(cv list("M3" "drawing") list(list(979.8 830.125) list(979.8 829.5)) 0.26)
dbCreatePath(cv list("M3" "drawing") list(list(984.1 830.125) list(984.1 830.76)) 0.26)
dbCreateLabel(cv list("M4" "pin") list(988.275 830.125) "D1_CORE" "centerRight" "R90" "roman" 2)
dbCreatePath(cv list("M3" "drawing") list(list(919.8 830.125) list(919.8 829.5)) 0.26)
dbCreatePath(cv list("M3" "drawing") list(list(924.1 830.125) list(924.1 830.76)) 0.26)
dbCreateLabel(cv list("M4" "pin") list(928.275 830.125) "D2_CORE" "centerRight" "R90" "roman" 2)
dbCreatePath(cv list("M3" "drawing") list(list(859.8 830.125) list(859.8 829.5)) 0.26)
dbCreatePath(cv list("M3" "drawing") list(list(864.1 830.125) list(864.1 830.76)) 0.26)
dbCreateLabel(cv list("M4" "pin") list(868.275 830.125) "D3_CORE" "centerRight" "R90" "roman" 2)
dbCreatePath(cv list("M3" "drawing") list(list(799.8 830.125) list(799.8 829.5)) 0.26)
dbCreatePath(cv list("M3" "drawing") list(list(804.1 830.125) list(804.1 830.76)) 0.26)
dbCreateLabel(cv list("M4" "pin") list(808.275 830.125) "D4_CORE" "centerRight" "R90" "roman" 2)
dbCreatePath(cv list("M3" "drawing") list(list(739.8 830.125) list(739.8 829.5)) 0.26)
dbCreatePath(cv list("M3" "drawing") list(list(744.1 830.125) list(744.1 830.76)) 0.26)
dbCreateLabel(cv list("M4" "pin") list(748.275 830.125) "D5_CORE" "centerRight" "R90" "roman" 2)
dbCreatePath(cv list("M3" "drawing") list(list(679.8 830.125) list(679.8 829.5)) 0.26)
dbCreatePath(cv list("M3" "drawing") list(list(684.1 830.125) list(684.1 830.76)) 0.26)
dbCreateLabel(cv list("M4" "pin") list(688.275 830.125) "D6_CORE" "centerRight" "R90" "roman" 2)
dbCreatePath(cv list("M3" "drawing") list(list(619.8 830.125) list(619.8 829.5)) 0.26)
dbCreatePath(cv list("M3" "drawing") list(list(624.1 830.125) list(624.1 830.76)) 0.26)
dbCreateLabel(cv list("M4" "pin") list(628.275 830.125) "D7_CORE" "centerRight" "R90" "roman" 2)
dbCreatePath(cv list("M3" "drawing") list(list(559.8 830.125) list(559.8 829.5)) 0.26)
dbCreatePath(cv list("M3" "drawing") list(list(564.1 830.125) list(564.1 830.76)) 0.26)
dbCreateLabel(cv list("M4" "pin") list(568.275 830.125) "D8_CORE" "centerRight" "R90" "roman" 2)
dbCreatePath(cv list("M3" "drawing") list(list(499.8 830.125) list(499.8 829.5)) 0.26)
dbCreatePath(cv list("M3" "drawing") list(list(504.1 830.125) list(504.1 830.76)) 0.26)
dbCreateLabel(cv list("M4" "pin") list(508.275 830.125) "D9_CORE" "centerRight" "R90" "roman" 2)
dbCreatePath(cv list("M3" "drawing") list(list(439.8 830.125) list(439.8 829.5)) 0.26)
dbCreatePath(cv list("M3" "drawing") list(list(444.1 830.125) list(444.1 830.76)) 0.26)
dbCreateLabel(cv list("M4" "pin") list(448.275 830.125) "D10_CORE" "centerRight" "R90" "roman" 2)
dbCreatePath(cv list("M3" "drawing") list(list(379.8 830.125) list(379.8 829.5)) 0.26)
dbCreatePath(cv list("M3" "drawing") list(list(384.1 830.125) list(384.1 830.76)) 0.26)
dbCreateLabel(cv list("M4" "pin") list(388.275 830.125) "D12_CORE" "centerRight" "R90" "roman" 2)
dbCreatePath(cv list("M3" "drawing") list(list(319.8 830.125) list(319.8 829.5)) 0.26)
dbCreatePath(cv list("M3" "drawing") list(list(324.1 830.125) list(324.1 830.76)) 0.26)
dbCreateLabel(cv list("M4" "pin") list(328.275 830.125) "D11_CORE" "centerRight" "R90" "roman" 2)
dbCreatePath(cv list("M3" "drawing") list(list(259.8 830.125) list(259.8 830.76)) 0.26)
dbCreatePath(cv list("M3" "drawing") list(list(268.275 830.125) list(268.275 830.76)) 0.26)
dbCreatePath(cv list("M3" "drawing") list(list(264.1 830.125) list(264.1 829.5)) 0.26)
dbCreateLabel(cv list("M4" "pin") list(255.67 830.125) "CS_CORE" "centerRight" "R90" "roman" 2)
dbCreatePath(cv list("M3" "drawing") list(list(199.8 830.125) list(199.8 830.76)) 0.26)
dbCreatePath(cv list("M3" "drawing") list(list(208.275 830.125) list(208.275 830.76)) 0.26)
dbCreatePath(cv list("M3" "drawing") list(list(204.1 830.125) list(204.1 829.5)) 0.26)
dbCreateLabel(cv list("M4" "pin") list(195.67 830.125) "EN_CORE" "centerRight" "R90" "roman" 2)
dbCreatePath(cv list("M3" "drawing") list(list(139.8 830.125) list(139.8 830.76)) 0.26)
dbCreatePath(cv list("M3" "drawing") list(list(148.275 830.125) list(148.275 830.76)) 0.26)
dbCreatePath(cv list("M3" "drawing") list(list(144.1 830.125) list(144.1 829.5)) 0.26)
dbCreateLabel(cv list("M4" "pin") list(135.67 830.125) "RSTN_CORE" "centerRight" "R90" "roman" 2)

; ==================== Pin Labels (with Inner Pad Support) ====================
dbCreateLabel(cv list("AP" "pin") list(-11 800) "DCLK" "centerRight" "R0" "roman" 10)
dbCreateLabel(cv list("AP" "pin") list(-11 740) "SYNC" "centerRight" "R0" "roman" 10)
dbCreateLabel(cv list("AP" "pin") list(-11 680) "VIOL" "centerRight" "R0" "roman" 10)
dbCreateLabel(cv list("AP" "pin") list(-11 620) "GIOL" "centerRight" "R0" "roman" 10)
dbCreateLabel(cv list("AP" "pin") list(-11 560) "VIOH" "centerRight" "R0" "roman" 10)
dbCreateLabel(cv list("AP" "pin") list(-11 500) "GIOH" "centerRight" "R0" "roman" 10)
dbCreateLabel(cv list("AP" "pin") list(-11 440) "VDD3" "centerRight" "R0" "roman" 10)
dbCreateLabel(cv list("AP" "pin") list(-11 380) "IB3" "centerRight" "R0" "roman" 10)
dbCreateLabel(cv list("AP" "pin") list(-11 320) "VDD12" "centerRight" "R0" "roman" 10)
dbCreateLabel(cv list("AP" "pin") list(-11 260) "IB12" "centerRight" "R0" "roman" 10)
dbCreateLabel(cv list("AP" "pin") list(-11 200) "VDD_CDAC" "centerRight" "R0" "roman" 10)
dbCreateLabel(cv list("AP" "pin") list(-11 140) "VSS_CDAC" "centerRight" "R0" "roman" 10)
dbCreateLabel(cv list("AP" "pin") list(140 -11) "VREFDES" "centerRight" "R90" "roman" 10)
dbCreateLabel(cv list("AP" "pin") list(200 -11) "IBREF" "centerRight" "R90" "roman" 10)
dbCreateLabel(cv list("AP" "pin") list(260 -11) "VSS" "centerRight" "R90" "roman" 10)
dbCreateLabel(cv list("AP" "pin") list(320 -11) "IBUF_IBIAS" "centerRight" "R90" "roman" 10)
dbCreateLabel(cv list("AP" "pin") list(380 -11) "BIAS2" "centerRight" "R90" "roman" 10)
dbCreateLabel(cv list("AP" "pin") list(440 -11) "VDDIB" "centerRight" "R90" "roman" 10)
dbCreateLabel(cv list("M2" "pin") list(440 109.9) "VDDIB_CORE" "centerLeft" "R90" "roman" 2)
dbCreateLabel(cv list("AP" "pin") list(500 -11) "VSSIB" "centerRight" "R90" "roman" 10)
dbCreateLabel(cv list("M2" "pin") list(500 109.9) "VSSIB_CORE" "centerLeft" "R90" "roman" 2)
dbCreateLabel(cv list("AP" "pin") list(560 -11) "VINP" "centerRight" "R90" "roman" 10)
dbCreateLabel(cv list("AP" "pin") list(620 -11) "VINN" "centerRight" "R90" "roman" 10)
dbCreateLabel(cv list("AP" "pin") list(680 -11) "VINCM" "centerRight" "R90" "roman" 10)
dbCreateLabel(cv list("AP" "pin") list(740 -11) "GND_CKB" "centerRight" "R90" "roman" 10)
dbCreateLabel(cv list("M2" "pin") list(740 109.9) "GND_CKB_CORE" "centerLeft" "R90" "roman" 2)
dbCreateLabel(cv list("AP" "pin") list(800 -11) "VDD_CKB" "centerRight" "R90" "roman" 10)
dbCreateLabel(cv list("M2" "pin") list(800 109.9) "VDD_CKB_CORE" "centerLeft" "R90" "roman" 2)
dbCreateLabel(cv list("AP" "pin") list(860 -11) "CLKP" "centerRight" "R90" "roman" 10)
dbCreateLabel(cv list("AP" "pin") list(920 -11) "CLKN" "centerRight" "R90" "roman" 10)
dbCreateLabel(cv list("AP" "pin") list(980 -11) "VDD_DAT" "centerRight" "R90" "roman" 10)
dbCreateLabel(cv list("M2" "pin") list(980 109.9) "VDD_DAT_CORE" "centerLeft" "R90" "roman" 2)
dbCreateLabel(cv list("AP" "pin") list(1040 -11) "GND_DAT" "centerRight" "R90" "roman" 10)
dbCreateLabel(cv list("M2" "pin") list(1040 109.9) "GND_DAT_CORE" "centerLeft" "R90" "roman" 2)
dbCreateLabel(cv list("AP" "pin") list(1100 -11) "VCM" "centerRight" "R90" "roman" 10)
dbCreateLabel(cv list("AP" "pin") list(1160 -11) "VSSCLK" "centerRight" "R90" "roman" 10)
dbCreateLabel(cv list("AP" "pin") list(1311 140) "VDDCLK" "centerLeft" "R0" "roman" 10)
dbCreateLabel(cv list("AP" "pin") list(1311 200) "AVDD" "centerLeft" "R0" "roman" 10)
dbCreateLabel(cv list("AP" "pin") list(1311 260) "AVSS" "centerLeft" "R0" "roman" 10)
dbCreateLabel(cv list("AP" "pin") list(1311 320) "VDDSAR" "centerLeft" "R0" "roman" 10)
dbCreateLabel(cv list("AP" "pin") list(1311 380) "VSSSAR" "centerLeft" "R0" "roman" 10)
dbCreateLabel(cv list("AP" "pin") list(1311 440) "VREFDES2" "centerLeft" "R0" "roman" 10)
dbCreateLabel(cv list("AP" "pin") list(1311 500) "IBREF2" "centerLeft" "R0" "roman" 10)
dbCreateLabel(cv list("AP" "pin") list(1311 560) "VREFDES3" "centerLeft" "R0" "roman" 10)
dbCreateLabel(cv list("AP" "pin") list(1311 620) "IBREF3" "centerLeft" "R0" "roman" 10)
dbCreateLabel(cv list("AP" "pin") list(1311 680) "SLP" "centerLeft" "R0" "roman" 10)
dbCreateLabel(cv list("AP" "pin") list(1311 740) "SDI" "centerLeft" "R0" "roman" 10)
dbCreateLabel(cv list("AP" "pin") list(1311 800) "SCK" "centerLeft" "R0" "roman" 10)
dbCreateLabel(cv list("AP" "pin") list(1160 951) "SDO" "centerLeft" "R90" "roman" 10)
dbCreateLabel(cv list("AP" "pin") list(1100 951) "RST" "centerLeft" "R90" "roman" 10)
dbCreateLabel(cv list("AP" "pin") list(1040 951) "D0" "centerLeft" "R90" "roman" 10)
dbCreateLabel(cv list("AP" "pin") list(980 951) "D1" "centerLeft" "R90" "roman" 10)
dbCreateLabel(cv list("AP" "pin") list(920 951) "D2" "centerLeft" "R90" "roman" 10)
dbCreateLabel(cv list("AP" "pin") list(860 951) "D3" "centerLeft" "R90" "roman" 10)
dbCreateLabel(cv list("AP" "pin") list(800 951) "D4" "centerLeft" "R90" "roman" 10)
dbCreateLabel(cv list("AP" "pin") list(740 951) "D5" "centerLeft" "R90" "roman" 10)
dbCreateLabel(cv list("AP" "pin") list(680 951) "D6" "centerLeft" "R90" "roman" 10)
dbCreateLabel(cv list("AP" "pin") list(620 951) "D7" "centerLeft" "R90" "roman" 10)
dbCreateLabel(cv list("AP" "pin") list(560 951) "D8" "centerLeft" "R90" "roman" 10)
dbCreateLabel(cv list("AP" "pin") list(500 951) "D9" "centerLeft" "R90" "roman" 10)
dbCreateLabel(cv list("AP" "pin") list(440 951) "D10" "centerLeft" "R90" "roman" 10)
dbCreateLabel(cv list("AP" "pin") list(380 951) "D12" "centerLeft" "R90" "roman" 10)
dbCreateLabel(cv list("AP" "pin") list(320 951) "D11" "centerLeft" "R90" "roman" 10)
dbCreateLabel(cv list("AP" "pin") list(260 951) "CS" "centerLeft" "R90" "roman" 10)
dbCreateLabel(cv list("AP" "pin") list(200 951) "EN" "centerLeft" "R90" "roman" 10)
dbCreateLabel(cv list("AP" "pin") list(140 951) "RSTN" "centerLeft" "R90" "roman" 10)

dbSave(cv)
t
