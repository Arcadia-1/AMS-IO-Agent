pdb3ac_h_gMaster = dbOpenCellView("tphn28hpcpgv18" "PDB3AC_H_G" "symbol")
dbCreateInst(cv pdb3ac_h_gMaster "VIN_left0" '(0 6.8125) "R270")
schCreateWire(cv "route" "full" '((0.000 7.000) (-0.750 7.000)) 0 0 0 nil nil)
schCreateWireLabel(cv nil '(-0.250 7.000) "VIN" "lowerRight" "R0" "stick" 0.0625 nil)
schCreatePin(cv nil "VIN" "inputOutput" nil '(-0.750 7.000) "R0")
schCreateWire(cv "route" "full" '((0.875 7.062) (1.625 7.062)) 0 0 0 nil nil)
schCreateWireLabel(cv nil '(1.125 7.062) "VSSIB" "lowerLeft" "R0" "stick" 0.0625 nil)
schCreateWire(cv "route" "full" '((0.875 6.688) (1.625 6.688)) 0 0 0 nil nil)
schCreateWireLabel(cv nil '(1.125 6.688) "GIOL" "lowerLeft" "R0" "stick" 0.0625 nil)
schCreateWire(cv "route" "full" '((0.875 7.438) (1.625 7.438)) 0 0 0 nil nil)
schCreateWireLabel(cv nil '(1.125 7.438) "VDDIB" "lowerLeft" "R0" "stick" 0.0625 nil)
pvss3ac_h_gMaster = dbOpenCellView("tphn28hpcpgv18" "PVSS3AC_H_G" "symbol")
dbCreateInst(cv pvss3ac_h_gMaster "VSSIB_left1" '(0 4.8125) "R270")
schCreateWire(cv "route" "full" '((0.000 5.000) (-0.750 5.000)) 0 0 0 nil nil)
schCreateWireLabel(cv nil '(-0.250 5.000) "VSSIB" "lowerRight" "R0" "stick" 0.0625 nil)
schCreatePin(cv nil "VSSIB" "inputOutput" nil '(-0.750 5.000) "R0")
schCreateWire(cv "route" "full" '((0.875 4.688) (1.625 4.688)) 0 0 0 nil nil)
schCreateWireLabel(cv nil '(1.125 4.688) "GIOL" "lowerLeft" "R0" "stick" 0.0625 nil)
schCreateWire(cv "route" "full" '((0.875 5.438) (1.625 5.438)) 0 0 0 nil nil)
schCreateWireLabel(cv nil '(1.125 5.438) "VSSIB_CORE" "lowerLeft" "R0" "stick" 0.0625 nil)
schCreatePin(cv nil "VSSIB_CORE" "inputOutput" nil '(1.625 5.438) "R180")
schCreateWire(cv "route" "full" '((0.875 5.062) (1.625 5.062)) 0 0 0 nil nil)
schCreateWireLabel(cv nil '(1.125 5.062) "VDDIB" "lowerLeft" "R0" "stick" 0.0625 nil)
pvdd3ac_h_gMaster = dbOpenCellView("tphn28hpcpgv18" "PVDD3AC_H_G" "symbol")
dbCreateInst(cv pvdd3ac_h_gMaster "VDDIB_left2" '(0 2.8125) "R270")
schCreateWire(cv "route" "full" '((0.875 3.438) (1.625 3.438)) 0 0 0 nil nil)
schCreateWireLabel(cv nil '(1.125 3.438) "VDDIB_CORE" "lowerLeft" "R0" "stick" 0.0625 nil)
schCreatePin(cv nil "VDDIB_CORE" "inputOutput" nil '(1.625 3.438) "R180")
schCreateWire(cv "route" "full" '((0.875 3.062) (1.625 3.062)) 0 0 0 nil nil)
schCreateWireLabel(cv nil '(1.125 3.062) "VSSIB" "lowerLeft" "R0" "stick" 0.0625 nil)
schCreateWire(cv "route" "full" '((0.875 2.688) (1.625 2.688)) 0 0 0 nil nil)
schCreateWireLabel(cv nil '(1.125 2.688) "GIOL" "lowerLeft" "R0" "stick" 0.0625 nil)
schCreateWire(cv "route" "full" '((0.000 3.001) (-0.750 3.001)) 0 0 0 nil nil)
schCreateWireLabel(cv nil '(-0.250 3.001) "VDDIB" "lowerRight" "R0" "stick" 0.0625 nil)
schCreatePin(cv nil "VDDIB" "inputOutput" nil '(-0.750 3.001) "R0")
pdb3ac_v_gMaster = dbOpenCellView("tphn28hpcpgv18" "PDB3AC_V_G" "symbol")
dbCreateInst(cv pdb3ac_v_gMaster "VCM_bottom0" '(3.1875 0) "R0")
schCreateWire(cv "route" "full" '((2.999 0.000) (2.999 -0.750)) 0 0 0 nil nil)
schCreateWireLabel(cv nil '(2.999 -0.250) "VCM" "lowerRight" "R90" "stick" 0.0625 nil)
schCreatePin(cv nil "VCM" "inputOutput" nil '(2.999 -0.750) "R90")
schCreateWire(cv "route" "full" '((2.938 0.875) (2.938 1.625)) 0 0 0 nil nil)
schCreateWireLabel(cv nil '(2.938 1.125) "VSSIB" "lowerLeft" "R90" "stick" 0.0625 nil)
schCreateWire(cv "route" "full" '((3.312 0.875) (3.312 1.625)) 0 0 0 nil nil)
schCreateWireLabel(cv nil '(3.312 1.125) "GIOL" "lowerLeft" "R90" "stick" 0.0625 nil)
schCreateWire(cv "route" "full" '((2.562 0.875) (2.562 1.625)) 0 0 0 nil nil)
schCreateWireLabel(cv nil '(2.562 1.125) "VDDIB" "lowerLeft" "R90" "stick" 0.0625 nil)
pddw16sdgz_v_gMaster = dbOpenCellView("tphn28hpcpgv18" "PDDW16SDGZ_V_G" "symbol")
dbCreateInst(cv pddw16sdgz_v_gMaster "D4_bottom1" '(4.3125 0) "R0")
schCreateWire(cv "route" "full" '((4.438 1.000) (4.438 1.750)) 0 0 0 nil nil)
schCreateWireLabel(cv nil '(4.438 1.250) "VIOL" "lowerLeft" "R90" "stick" 0.0625 nil)
noConnMaster = dbOpenCellView("basic" "noConn" "symbol")
schCreateWire(cv "route" "full" '((4.562 1.000) (4.562 1.750)) 0 0 0 nil nil)
dbCreateInst(cv noConnMaster "noConn_D4_bottom1_C" '(4.562 1.750) "R180")
schCreateWire(cv "route" "full" '((4.188 1.000) (4.188 1.750)) 0 0 0 nil nil)
schCreateWireLabel(cv nil '(4.188 1.250) "GIOL" "lowerLeft" "R90" "stick" 0.0625 nil)
schCreateWire(cv "route" "full" '((4.062 1.000) (4.062 1.750)) 0 0 0 nil nil)
schCreateWireLabel(cv nil '(4.062 1.250) "D4_CORE" "lowerLeft" "R90" "stick" 0.0625 nil)
schCreatePin(cv nil "D4_CORE" "inputOutput" nil '(4.062 1.750) "R270")
schCreateWire(cv "route" "full" '((5.000 0.000) (5.000 -0.750)) 0 0 0 nil nil)
schCreateWireLabel(cv nil '(5.000 -0.250) "D4" "lowerRight" "R90" "stick" 0.0625 nil)
schCreatePin(cv nil "D4" "inputOutput" nil '(5.000 -0.750) "R90")
schCreateWire(cv "route" "full" '((4.688 1.000) (4.688 1.750)) 0 0 0 nil nil)
schCreateWireLabel(cv nil '(4.688 1.250) "POC" "lowerLeft" "R90" "stick" 0.0625 nil)
schCreateWire(cv "route" "full" '((4.875 1.000) (4.875 1.750)) 0 0 0 nil nil)
schCreateWireLabel(cv nil '(4.875 1.250) "VIOL" "lowerLeft" "R90" "stick" 0.0625 nil)
schCreateWire(cv "route" "full" '((5.062 1.000) (5.062 1.750)) 0 0 0 nil nil)
schCreateWireLabel(cv nil '(5.062 1.250) "GIOL" "lowerLeft" "R90" "stick" 0.0625 nil)
schCreateWire(cv "route" "full" '((5.250 1.000) (5.250 1.750)) 0 0 0 nil nil)
schCreateWireLabel(cv nil '(5.250 1.250) "VIOH" "lowerLeft" "R90" "stick" 0.0625 nil)
schCreateWire(cv "route" "full" '((5.625 1.000) (5.625 1.750)) 0 0 0 nil nil)
schCreateWireLabel(cv nil '(5.625 1.250) "GIOH" "lowerLeft" "R90" "stick" 0.0625 nil)
dbCreateInst(cv pddw16sdgz_v_gMaster "D3_bottom2" '(6.3125 0) "R0")
schCreateWire(cv "route" "full" '((6.438 1.000) (6.438 1.750)) 0 0 0 nil nil)
schCreateWireLabel(cv nil '(6.438 1.250) "VIOL" "lowerLeft" "R90" "stick" 0.0625 nil)
schCreateWire(cv "route" "full" '((6.562 1.000) (6.562 1.750)) 0 0 0 nil nil)
dbCreateInst(cv noConnMaster "noConn_D3_bottom2_C" '(6.562 1.750) "R180")
schCreateWire(cv "route" "full" '((6.188 1.000) (6.188 1.750)) 0 0 0 nil nil)
schCreateWireLabel(cv nil '(6.188 1.250) "GIOL" "lowerLeft" "R90" "stick" 0.0625 nil)
schCreateWire(cv "route" "full" '((6.062 1.000) (6.062 1.750)) 0 0 0 nil nil)
schCreateWireLabel(cv nil '(6.062 1.250) "D3_CORE" "lowerLeft" "R90" "stick" 0.0625 nil)
schCreatePin(cv nil "D3_CORE" "inputOutput" nil '(6.062 1.750) "R270")
schCreateWire(cv "route" "full" '((7.000 0.000) (7.000 -0.750)) 0 0 0 nil nil)
schCreateWireLabel(cv nil '(7.000 -0.250) "D3" "lowerRight" "R90" "stick" 0.0625 nil)
schCreatePin(cv nil "D3" "inputOutput" nil '(7.000 -0.750) "R90")
schCreateWire(cv "route" "full" '((6.688 1.000) (6.688 1.750)) 0 0 0 nil nil)
schCreateWireLabel(cv nil '(6.688 1.250) "POC" "lowerLeft" "R90" "stick" 0.0625 nil)
schCreateWire(cv "route" "full" '((6.875 1.000) (6.875 1.750)) 0 0 0 nil nil)
schCreateWireLabel(cv nil '(6.875 1.250) "VIOL" "lowerLeft" "R90" "stick" 0.0625 nil)
schCreateWire(cv "route" "full" '((7.062 1.000) (7.062 1.750)) 0 0 0 nil nil)
schCreateWireLabel(cv nil '(7.062 1.250) "GIOL" "lowerLeft" "R90" "stick" 0.0625 nil)
schCreateWire(cv "route" "full" '((7.250 1.000) (7.250 1.750)) 0 0 0 nil nil)
schCreateWireLabel(cv nil '(7.250 1.250) "VIOH" "lowerLeft" "R90" "stick" 0.0625 nil)
schCreateWire(cv "route" "full" '((7.625 1.000) (7.625 1.750)) 0 0 0 nil nil)
schCreateWireLabel(cv nil '(7.625 1.250) "GIOH" "lowerLeft" "R90" "stick" 0.0625 nil)
pddw16sdgz_h_gMaster = dbOpenCellView("tphn28hpcpgv18" "PDDW16SDGZ_H_G" "symbol")
dbCreateInst(cv pddw16sdgz_h_gMaster "D2_right0" '(10.0 2.3125) "R90")
schCreateWire(cv "route" "full" '((9.000 2.438) (8.250 2.438)) 0 0 0 nil nil)
schCreateWireLabel(cv nil '(8.750 2.438) "VIOL" "lowerRight" "R0" "stick" 0.0625 nil)
schCreateWire(cv "route" "full" '((9.000 2.562) (8.250 2.562)) 0 0 0 nil nil)
dbCreateInst(cv noConnMaster "noConn_D2_right0_C" '(8.250 2.562) "R270")
schCreateWire(cv "route" "full" '((9.000 2.188) (8.250 2.188)) 0 0 0 nil nil)
schCreateWireLabel(cv nil '(8.750 2.188) "GIOL" "lowerRight" "R0" "stick" 0.0625 nil)
schCreateWire(cv "route" "full" '((9.000 2.062) (8.250 2.062)) 0 0 0 nil nil)
schCreateWireLabel(cv nil '(8.750 2.062) "D2_CORE" "lowerRight" "R0" "stick" 0.0625 nil)
schCreatePin(cv nil "D2_CORE" "inputOutput" nil '(8.250 2.062) "R0")
schCreateWire(cv "route" "full" '((10.000 3.000) (10.750 3.000)) 0 0 0 nil nil)
schCreateWireLabel(cv nil '(10.250 3.000) "D2" "lowerLeft" "R0" "stick" 0.0625 nil)
schCreatePin(cv nil "D2" "inputOutput" nil '(10.750 3.000) "R180")
schCreateWire(cv "route" "full" '((9.000 2.688) (8.250 2.688)) 0 0 0 nil nil)
schCreateWireLabel(cv nil '(8.750 2.688) "POC" "lowerRight" "R0" "stick" 0.0625 nil)
schCreateWire(cv "route" "full" '((9.000 2.875) (8.250 2.875)) 0 0 0 nil nil)
schCreateWireLabel(cv nil '(8.750 2.875) "VIOL" "lowerRight" "R0" "stick" 0.0625 nil)
schCreateWire(cv "route" "full" '((9.000 3.062) (8.250 3.062)) 0 0 0 nil nil)
schCreateWireLabel(cv nil '(8.750 3.062) "GIOL" "lowerRight" "R0" "stick" 0.0625 nil)
schCreateWire(cv "route" "full" '((9.000 3.250) (8.250 3.250)) 0 0 0 nil nil)
schCreateWireLabel(cv nil '(8.750 3.250) "VIOH" "lowerRight" "R0" "stick" 0.0625 nil)
schCreateWire(cv "route" "full" '((9.000 3.625) (8.250 3.625)) 0 0 0 nil nil)
schCreateWireLabel(cv nil '(8.750 3.625) "GIOH" "lowerRight" "R0" "stick" 0.0625 nil)
dbCreateInst(cv pddw16sdgz_h_gMaster "D1_right1" '(10.0 4.3125) "R90")
schCreateWire(cv "route" "full" '((9.000 4.438) (8.250 4.438)) 0 0 0 nil nil)
schCreateWireLabel(cv nil '(8.750 4.438) "VIOL" "lowerRight" "R0" "stick" 0.0625 nil)
schCreateWire(cv "route" "full" '((9.000 4.562) (8.250 4.562)) 0 0 0 nil nil)
dbCreateInst(cv noConnMaster "noConn_D1_right1_C" '(8.250 4.562) "R270")
schCreateWire(cv "route" "full" '((9.000 4.188) (8.250 4.188)) 0 0 0 nil nil)
schCreateWireLabel(cv nil '(8.750 4.188) "GIOL" "lowerRight" "R0" "stick" 0.0625 nil)
schCreateWire(cv "route" "full" '((9.000 4.062) (8.250 4.062)) 0 0 0 nil nil)
schCreateWireLabel(cv nil '(8.750 4.062) "D1_CORE" "lowerRight" "R0" "stick" 0.0625 nil)
schCreatePin(cv nil "D1_CORE" "inputOutput" nil '(8.250 4.062) "R0")
schCreateWire(cv "route" "full" '((10.000 5.000) (10.750 5.000)) 0 0 0 nil nil)
schCreateWireLabel(cv nil '(10.250 5.000) "D1" "lowerLeft" "R0" "stick" 0.0625 nil)
schCreatePin(cv nil "D1" "inputOutput" nil '(10.750 5.000) "R180")
schCreateWire(cv "route" "full" '((9.000 4.688) (8.250 4.688)) 0 0 0 nil nil)
schCreateWireLabel(cv nil '(8.750 4.688) "POC" "lowerRight" "R0" "stick" 0.0625 nil)
schCreateWire(cv "route" "full" '((9.000 4.875) (8.250 4.875)) 0 0 0 nil nil)
schCreateWireLabel(cv nil '(8.750 4.875) "VIOL" "lowerRight" "R0" "stick" 0.0625 nil)
schCreateWire(cv "route" "full" '((9.000 5.062) (8.250 5.062)) 0 0 0 nil nil)
schCreateWireLabel(cv nil '(8.750 5.062) "GIOL" "lowerRight" "R0" "stick" 0.0625 nil)
schCreateWire(cv "route" "full" '((9.000 5.250) (8.250 5.250)) 0 0 0 nil nil)
schCreateWireLabel(cv nil '(8.750 5.250) "VIOH" "lowerRight" "R0" "stick" 0.0625 nil)
schCreateWire(cv "route" "full" '((9.000 5.625) (8.250 5.625)) 0 0 0 nil nil)
schCreateWireLabel(cv nil '(8.750 5.625) "GIOH" "lowerRight" "R0" "stick" 0.0625 nil)
pvdd1dgz_h_gMaster = dbOpenCellView("tphn28hpcpgv18" "PVDD1DGZ_H_G" "symbol")
dbCreateInst(cv pvdd1dgz_h_gMaster "VIOL_right2" '(10.0 6.0) "R90")
schCreateWire(cv "route" "full" '((9.000 6.375) (8.250 6.375)) 0 0 0 nil nil)
schCreateWireLabel(cv nil '(8.750 6.375) "POC" "lowerRight" "R0" "stick" 0.0625 nil)
schCreateWire(cv "route" "full" '((10.000 7.000) (10.750 7.000)) 0 0 0 nil nil)
schCreateWireLabel(cv nil '(10.250 7.000) "VIOL" "lowerLeft" "R0" "stick" 0.0625 nil)
schCreatePin(cv nil "VIOL" "inputOutput" nil '(10.750 7.000) "R180")
schCreateWire(cv "route" "full" '((9.000 6.750) (8.250 6.750)) 0 0 0 nil nil)
schCreateWireLabel(cv nil '(8.750 6.750) "GIOL" "lowerRight" "R0" "stick" 0.0625 nil)
schCreateWire(cv "route" "full" '((9.000 6.938) (8.250 6.938)) 0 0 0 nil nil)
schCreateWireLabel(cv nil '(8.750 6.938) "VIOH" "lowerRight" "R0" "stick" 0.0625 nil)
schCreateWire(cv "route" "full" '((9.000 7.312) (8.250 7.312)) 0 0 0 nil nil)
schCreateWireLabel(cv nil '(8.750 7.312) "GIOH" "lowerRight" "R0" "stick" 0.0625 nil)
pvss1dgz_v_gMaster = dbOpenCellView("tphn28hpcpgv18" "PVSS1DGZ_V_G" "symbol")
dbCreateInst(cv pvss1dgz_v_gMaster "GIOL_top0" '(8.0 10.0) "R180")
schCreateWire(cv "route" "full" '((7.625 9.000) (7.625 8.250)) 0 0 0 nil nil)
schCreateWireLabel(cv nil '(7.625 8.750) "POC" "lowerRight" "R90" "stick" 0.0625 nil)
schCreateWire(cv "route" "full" '((7.438 9.000) (7.438 8.250)) 0 0 0 nil nil)
schCreateWireLabel(cv nil '(7.438 8.750) "VIOL" "lowerRight" "R90" "stick" 0.0625 nil)
schCreateWire(cv "route" "full" '((7.000 10.000) (7.000 10.750)) 0 0 0 nil nil)
schCreateWireLabel(cv nil '(7.000 10.250) "GIOL" "lowerLeft" "R90" "stick" 0.0625 nil)
schCreatePin(cv nil "GIOL" "inputOutput" nil '(7.000 10.750) "R270")
schCreateWire(cv "route" "full" '((7.062 9.000) (7.062 8.250)) 0 0 0 nil nil)
schCreateWireLabel(cv nil '(7.062 8.750) "VIOH" "lowerRight" "R90" "stick" 0.0625 nil)
schCreateWire(cv "route" "full" '((6.688 9.000) (6.688 8.250)) 0 0 0 nil nil)
schCreateWireLabel(cv nil '(6.688 8.750) "GIOH" "lowerRight" "R90" "stick" 0.0625 nil)
pvdd2poc_v_gMaster = dbOpenCellView("tphn28hpcpgv18" "PVDD2POC_V_G" "symbol")
dbCreateInst(cv pvdd2poc_v_gMaster "VIOH_top1" '(6.0 10.0) "R180")
schCreateWire(cv "route" "full" '((5.625 9.000) (5.625 8.250)) 0 0 0 nil nil)
schCreateWireLabel(cv nil '(5.625 8.750) "POC" "lowerRight" "R90" "stick" 0.0625 nil)
schCreateWire(cv "route" "full" '((5.438 9.000) (5.438 8.250)) 0 0 0 nil nil)
schCreateWireLabel(cv nil '(5.438 8.750) "VIOL" "lowerRight" "R90" "stick" 0.0625 nil)
schCreateWire(cv "route" "full" '((5.250 9.000) (5.250 8.250)) 0 0 0 nil nil)
schCreateWireLabel(cv nil '(5.250 8.750) "GIOL" "lowerRight" "R90" "stick" 0.0625 nil)
schCreateWire(cv "route" "full" '((5.000 10.000) (5.000 10.750)) 0 0 0 nil nil)
schCreateWireLabel(cv nil '(5.000 10.250) "VIOH" "lowerLeft" "R90" "stick" 0.0625 nil)
schCreatePin(cv nil "VIOH" "inputOutput" nil '(5.000 10.750) "R270")
schCreateWire(cv "route" "full" '((4.688 9.000) (4.688 8.250)) 0 0 0 nil nil)
schCreateWireLabel(cv nil '(4.688 8.750) "GIOH" "lowerRight" "R90" "stick" 0.0625 nil)
pvss2dgz_v_gMaster = dbOpenCellView("tphn28hpcpgv18" "PVSS2DGZ_V_G" "symbol")
dbCreateInst(cv pvss2dgz_v_gMaster "GIOH_top2" '(4.0 10.0) "R180")
schCreateWire(cv "route" "full" '((3.625 9.000) (3.625 8.250)) 0 0 0 nil nil)
schCreateWireLabel(cv nil '(3.625 8.750) "POC" "lowerRight" "R90" "stick" 0.0625 nil)
schCreateWire(cv "route" "full" '((3.438 9.000) (3.438 8.250)) 0 0 0 nil nil)
schCreateWireLabel(cv nil '(3.438 8.750) "VIOL" "lowerRight" "R90" "stick" 0.0625 nil)
schCreateWire(cv "route" "full" '((3.250 9.000) (3.250 8.250)) 0 0 0 nil nil)
schCreateWireLabel(cv nil '(3.250 8.750) "GIOL" "lowerRight" "R90" "stick" 0.0625 nil)
schCreateWire(cv "route" "full" '((3.062 9.000) (3.062 8.250)) 0 0 0 nil nil)
schCreateWireLabel(cv nil '(3.062 8.750) "VIOH" "lowerRight" "R90" "stick" 0.0625 nil)
schCreateWire(cv "route" "full" '((3.000 10.000) (3.000 10.750)) 0 0 0 nil nil)
schCreateWireLabel(cv nil '(3.000 10.250) "GIOH" "lowerLeft" "R90" "stick" 0.0625 nil)
schCreatePin(cv nil "GIOH" "inputOutput" nil '(3.000 10.750) "R270")
schCheck(cv)
dbSave(cv)
t
