; Generated Layout Script with Dual Ring Support

; ==================== All Components (Sorted by Placement Order) ====================
dbCreateParamInstByMasterName(cv "tphn28hpcpgv18" "PDDW16SDGZ_H_G" "layout" "EN_left_17" list(0 150) "R270")
dbCreateParamInstByMasterName(cv "PAD" "PAD60GU" "layout" "pad60gu_EN_left_17" list(0 150) "R270")
dbCreateParamInstByMasterName(cv "tphn28hpcpgv18" "PDDW16SDGZ_H_G" "layout" "CS_left_16" list(0 210) "R270")
dbCreateParamInstByMasterName(cv "PAD" "PAD60GU" "layout" "pad60gu_CS_left_16" list(0 210) "R270")
dbCreateParamInstByMasterName(cv "tphn28hpcpgv18" "PDDW16SDGZ_H_G" "layout" "D15_left_15" list(0 270) "R270")
dbCreateParamInstByMasterName(cv "PAD" "PAD60GU" "layout" "pad60gu_D15_left_15" list(0 270) "R270")
dbCreateParamInstByMasterName(cv "tphn28hpcpgv18" "PDDW16SDGZ_H_G" "layout" "D14_left_14" list(0 330) "R270")
dbCreateParamInstByMasterName(cv "PAD" "PAD60GU" "layout" "pad60gu_D14_left_14" list(0 330) "R270")
dbCreateParamInstByMasterName(cv "tphn28hpcpgv18" "PDDW16SDGZ_H_G" "layout" "D13_left_13" list(0 390) "R270")
dbCreateParamInstByMasterName(cv "PAD" "PAD60GU" "layout" "pad60gu_D13_left_13" list(0 390) "R270")
dbCreateParamInstByMasterName(cv "tphn28hpcpgv18" "PDDW16SDGZ_H_G" "layout" "D12_left_12" list(0 450) "R270")
dbCreateParamInstByMasterName(cv "PAD" "PAD60GU" "layout" "pad60gu_D12_left_12" list(0 450) "R270")
dbCreateParamInstByMasterName(cv "tphn28hpcpgv18" "PDDW16SDGZ_H_G" "layout" "D11_left_11" list(0 510) "R270")
dbCreateParamInstByMasterName(cv "PAD" "PAD60GU" "layout" "pad60gu_D11_left_11" list(0 510) "R270")
dbCreateParamInstByMasterName(cv "tphn28hpcpgv18" "PDDW16SDGZ_H_G" "layout" "D10_left_10" list(0 570) "R270")
dbCreateParamInstByMasterName(cv "PAD" "PAD60GU" "layout" "pad60gu_D10_left_10" list(0 570) "R270")
dbCreateParamInstByMasterName(cv "tphn28hpcpgv18" "PDDW16SDGZ_H_G" "layout" "D9_left_9" list(0 630) "R270")
dbCreateParamInstByMasterName(cv "PAD" "PAD60GU" "layout" "pad60gu_D9_left_9" list(0 630) "R270")
dbCreateParamInstByMasterName(cv "tphn28hpcpgv18" "PDDW16SDGZ_H_G" "layout" "D8_left_8" list(0 690) "R270")
dbCreateParamInstByMasterName(cv "PAD" "PAD60GU" "layout" "pad60gu_D8_left_8" list(0 690) "R270")
dbCreateParamInstByMasterName(cv "tphn28hpcpgv18" "PDDW16SDGZ_H_G" "layout" "D7_left_7" list(0 750) "R270")
dbCreateParamInstByMasterName(cv "PAD" "PAD60GU" "layout" "pad60gu_D7_left_7" list(0 750) "R270")
dbCreateParamInstByMasterName(cv "tphn28hpcpgv18" "PDDW16SDGZ_H_G" "layout" "D6_left_6" list(0 810) "R270")
dbCreateParamInstByMasterName(cv "PAD" "PAD60GU" "layout" "pad60gu_D6_left_6" list(0 810) "R270")
dbCreateParamInstByMasterName(cv "tphn28hpcpgv18" "PDDW16SDGZ_H_G" "layout" "D5_left_5" list(0 870) "R270")
dbCreateParamInstByMasterName(cv "PAD" "PAD60GU" "layout" "pad60gu_D5_left_5" list(0 870) "R270")
dbCreateParamInstByMasterName(cv "tphn28hpcpgv18" "PDDW16SDGZ_H_G" "layout" "D4_left_4" list(0 930) "R270")
dbCreateParamInstByMasterName(cv "PAD" "PAD60GU" "layout" "pad60gu_D4_left_4" list(0 930) "R270")
dbCreateParamInstByMasterName(cv "tphn28hpcpgv18" "PDDW16SDGZ_H_G" "layout" "D3_left_3" list(0 990) "R270")
dbCreateParamInstByMasterName(cv "PAD" "PAD60GU" "layout" "pad60gu_D3_left_3" list(0 990) "R270")
dbCreateParamInstByMasterName(cv "tphn28hpcpgv18" "PDDW16SDGZ_H_G" "layout" "D2_left_2" list(0 1050) "R270")
dbCreateParamInstByMasterName(cv "PAD" "PAD60GU" "layout" "pad60gu_D2_left_2" list(0 1050) "R270")
dbCreateParamInstByMasterName(cv "tphn28hpcpgv18" "PDDW16SDGZ_H_G" "layout" "D1_left_1" list(0 1110) "R270")
dbCreateParamInstByMasterName(cv "PAD" "PAD60GU" "layout" "pad60gu_D1_left_1" list(0 1110) "R270")
dbCreateParamInstByMasterName(cv "tphn28hpcpgv18" "PDDW16SDGZ_H_G" "layout" "D0_left_0" list(0 1170) "R270")
dbCreateParamInstByMasterName(cv "PAD" "PAD60GU" "layout" "pad60gu_D0_left_0" list(0 1170) "R270")
dbCreateParamInstByMasterName(cv "tphn28hpcpgv18" "PCORNERA_G" "layout" "CORNER_TL_top_left" list(0 1300) "R270")
dbCreateParamInstByMasterName(cv "tphn28hpcpgv18" "PDB3AC_V_G" "layout" "IBIAS_bottom_11" list(790 0) "R0")
dbCreateParamInstByMasterName(cv "PAD" "PAD60GU" "layout" "pad60gu_IBIAS_bottom_11" list(790 0) "R0")
dbCreateParamInstByMasterName(cv "tphn28hpcpgv18" "PDB3AC_V_G" "layout" "VINCM_bottom_10" list(730 0) "R0")
dbCreateParamInstByMasterName(cv "PAD" "PAD60GU" "layout" "pad60gu_VINCM_bottom_10" list(730 0) "R0")
dbCreateParamInstByMasterName(cv "tphn28hpcpgv18" "PDB3AC_V_G" "layout" "VCM_bottom_9" list(670 0) "R0")
dbCreateParamInstByMasterName(cv "PAD" "PAD60GU" "layout" "pad60gu_VCM_bottom_9" list(670 0) "R0")
dbCreateParamInstByMasterName(cv "tphn28hpcpgv18" "PDB3AC_V_G" "layout" "VIN_bottom_8" list(610 0) "R0")
dbCreateParamInstByMasterName(cv "PAD" "PAD60GU" "layout" "pad60gu_VIN_bottom_8" list(610 0) "R0")
dbCreateParamInstByMasterName(cv "tphn28hpcpgv18" "PDB3AC_V_G" "layout" "VIP_bottom_7" list(550 0) "R0")
dbCreateParamInstByMasterName(cv "PAD" "PAD60GU" "layout" "pad60gu_VIP_bottom_7" list(550 0) "R0")
dbCreateParamInstByMasterName(cv "tphn28hpcpgv18" "PVDD3AC_V_G" "layout" "VDDSAR_bottom_6" list(490 0) "R0")
dbCreateParamInstByMasterName(cv "PAD" "PAD60GU" "layout" "pad60gu_VDDSAR_bottom_6" list(490 0) "R0")
dbCreateParamInstByMasterName(cv "tphn28hpcpgv18" "PVSS3AC_V_G" "layout" "VSSSAR_bottom_5" list(430 0) "R0")
dbCreateParamInstByMasterName(cv "PAD" "PAD60GU" "layout" "pad60gu_VSSSAR_bottom_5" list(430 0) "R0")
dbCreateParamInstByMasterName(cv "tphn28hpcpgv18" "PVDD1DGZ_V_G" "layout" "VIOL_bottom_4" list(370 0) "R0")
dbCreateParamInstByMasterName(cv "PAD" "PAD60GU" "layout" "pad60gu_VIOL_bottom_4" list(370 0) "R0")
dbCreateParamInstByMasterName(cv "tphn28hpcpgv18" "PVSS2DGZ_V_G" "layout" "GIOH_bottom_3" list(310 0) "R0")
dbCreateParamInstByMasterName(cv "PAD" "PAD60GU" "layout" "pad60gu_GIOH_bottom_3" list(310 0) "R0")
dbCreateParamInstByMasterName(cv "tphn28hpcpgv18" "PVSS1DGZ_V_G" "layout" "GIOL_bottom_2" list(250 0) "R0")
dbCreateParamInstByMasterName(cv "PAD" "PAD60GU" "layout" "pad60gu_GIOL_bottom_2" list(250 0) "R0")
dbCreateParamInstByMasterName(cv "tphn28hpcpgv18" "PVDD2POC_V_G" "layout" "VIOH_bottom_1" list(190 0) "R0")
dbCreateParamInstByMasterName(cv "PAD" "PAD60GU" "layout" "pad60gu_VIOH_bottom_1" list(190 0) "R0")
dbCreateParamInstByMasterName(cv "tphn28hpcpgv18" "PDDW16SDGZ_V_G" "layout" "TEST_bottom_0" list(130 0) "R0")
dbCreateParamInstByMasterName(cv "PAD" "PAD60GU" "layout" "pad60gu_TEST_bottom_0" list(130 0) "R0")
dbCreateParamInstByMasterName(cv "tphn28hpcpgv18" "PCORNER_G" "layout" "CORNER_BL_bottom_left" list(0 0) "R0")
dbCreateParamInstByMasterName(cv "tphn28hpcpgv18" "PDB3AC_H_G" "layout" "IB14_right_17" list(940 1150) "R90")
dbCreateParamInstByMasterName(cv "PAD" "PAD60GU" "layout" "pad60gu_IB14_right_17" list(940 1150) "R90")
dbCreateParamInstByMasterName(cv "tphn28hpcpgv18" "PDB3AC_H_G" "layout" "IB13_right_16" list(940 1090) "R90")
dbCreateParamInstByMasterName(cv "PAD" "PAD60GU" "layout" "pad60gu_IB13_right_16" list(940 1090) "R90")
dbCreateParamInstByMasterName(cv "tphn28hpcpgv18" "PDB3AC_H_G" "layout" "IB12_right_15" list(940 1030) "R90")
dbCreateParamInstByMasterName(cv "PAD" "PAD60GU" "layout" "pad60gu_IB12_right_15" list(940 1030) "R90")
dbCreateParamInstByMasterName(cv "tphn28hpcpgv18" "PDB3AC_H_G" "layout" "IB11_right_14" list(940 970) "R90")
dbCreateParamInstByMasterName(cv "PAD" "PAD60GU" "layout" "pad60gu_IB11_right_14" list(940 970) "R90")
dbCreateParamInstByMasterName(cv "tphn28hpcpgv18" "PDB3AC_H_G" "layout" "IB10_right_13" list(940 910) "R90")
dbCreateParamInstByMasterName(cv "PAD" "PAD60GU" "layout" "pad60gu_IB10_right_13" list(940 910) "R90")
dbCreateParamInstByMasterName(cv "tphn28hpcpgv18" "PDB3AC_H_G" "layout" "IB9_right_12" list(940 850) "R90")
dbCreateParamInstByMasterName(cv "PAD" "PAD60GU" "layout" "pad60gu_IB9_right_12" list(940 850) "R90")
dbCreateParamInstByMasterName(cv "tphn28hpcpgv18" "PDB3AC_H_G" "layout" "IB8_right_11" list(940 790) "R90")
dbCreateParamInstByMasterName(cv "PAD" "PAD60GU" "layout" "pad60gu_IB8_right_11" list(940 790) "R90")
dbCreateParamInstByMasterName(cv "tphn28hpcpgv18" "PDB3AC_H_G" "layout" "IB7_right_10" list(940 730) "R90")
dbCreateParamInstByMasterName(cv "PAD" "PAD60GU" "layout" "pad60gu_IB7_right_10" list(940 730) "R90")
dbCreateParamInstByMasterName(cv "tphn28hpcpgv18" "PDB3AC_H_G" "layout" "IB6_right_9" list(940 670) "R90")
dbCreateParamInstByMasterName(cv "PAD" "PAD60GU" "layout" "pad60gu_IB6_right_9" list(940 670) "R90")
dbCreateParamInstByMasterName(cv "tphn28hpcpgv18" "PDB3AC_H_G" "layout" "IB5_right_8" list(940 610) "R90")
dbCreateParamInstByMasterName(cv "PAD" "PAD60GU" "layout" "pad60gu_IB5_right_8" list(940 610) "R90")
dbCreateParamInstByMasterName(cv "tphn28hpcpgv18" "PDB3AC_H_G" "layout" "IB4_right_7" list(940 550) "R90")
dbCreateParamInstByMasterName(cv "PAD" "PAD60GU" "layout" "pad60gu_IB4_right_7" list(940 550) "R90")
dbCreateParamInstByMasterName(cv "tphn28hpcpgv18" "PDB3AC_H_G" "layout" "IB3_right_6" list(940 490) "R90")
dbCreateParamInstByMasterName(cv "PAD" "PAD60GU" "layout" "pad60gu_IB3_right_6" list(940 490) "R90")
dbCreateParamInstByMasterName(cv "tphn28hpcpgv18" "PDB3AC_H_G" "layout" "IB2_right_5" list(940 430) "R90")
dbCreateParamInstByMasterName(cv "PAD" "PAD60GU" "layout" "pad60gu_IB2_right_5" list(940 430) "R90")
dbCreateParamInstByMasterName(cv "tphn28hpcpgv18" "PDB3AC_H_G" "layout" "IB1_right_4" list(940 370) "R90")
dbCreateParamInstByMasterName(cv "PAD" "PAD60GU" "layout" "pad60gu_IB1_right_4" list(940 370) "R90")
dbCreateParamInstByMasterName(cv "tphn28hpcpgv18" "PDB3AC_H_G" "layout" "IB0_right_3" list(940 310) "R90")
dbCreateParamInstByMasterName(cv "PAD" "PAD60GU" "layout" "pad60gu_IB0_right_3" list(940 310) "R90")
dbCreateParamInstByMasterName(cv "tphn28hpcpgv18" "PDB3AC_H_G" "layout" "VREF2_right_2" list(940 250) "R90")
dbCreateParamInstByMasterName(cv "PAD" "PAD60GU" "layout" "pad60gu_VREF2_right_2" list(940 250) "R90")
dbCreateParamInstByMasterName(cv "tphn28hpcpgv18" "PDB3AC_H_G" "layout" "VREF_right_1" list(940 190) "R90")
dbCreateParamInstByMasterName(cv "PAD" "PAD60GU" "layout" "pad60gu_VREF_right_1" list(940 190) "R90")
dbCreateParamInstByMasterName(cv "tphn28hpcpgv18" "PDB3AC_H_G" "layout" "IBIAS2_right_0" list(940 130) "R90")
dbCreateParamInstByMasterName(cv "PAD" "PAD60GU" "layout" "pad60gu_IBIAS2_right_0" list(940 130) "R90")
dbCreateParamInstByMasterName(cv "tphn28hpcpgv18" "PCORNERA_G" "layout" "CORNER_BR_bottom_right" list(940 0) "R90")
dbCreateParamInstByMasterName(cv "tphn28hpcpgv18" "PDB3AC_V_G" "layout" "IB26_top_11" list(150 1300) "R180")
dbCreateParamInstByMasterName(cv "PAD" "PAD60GU" "layout" "pad60gu_IB26_top_11" list(150 1300) "R180")
dbCreateParamInstByMasterName(cv "tphn28hpcpgv18" "PDB3AC_V_G" "layout" "IB25_top_10" list(210 1300) "R180")
dbCreateParamInstByMasterName(cv "PAD" "PAD60GU" "layout" "pad60gu_IB25_top_10" list(210 1300) "R180")
dbCreateParamInstByMasterName(cv "tphn28hpcpgv18" "PDB3AC_V_G" "layout" "IB24_top_9" list(270 1300) "R180")
dbCreateParamInstByMasterName(cv "PAD" "PAD60GU" "layout" "pad60gu_IB24_top_9" list(270 1300) "R180")
dbCreateParamInstByMasterName(cv "tphn28hpcpgv18" "PDB3AC_V_G" "layout" "IB23_top_8" list(330 1300) "R180")
dbCreateParamInstByMasterName(cv "PAD" "PAD60GU" "layout" "pad60gu_IB23_top_8" list(330 1300) "R180")
dbCreateParamInstByMasterName(cv "tphn28hpcpgv18" "PDB3AC_V_G" "layout" "IB22_top_7" list(390 1300) "R180")
dbCreateParamInstByMasterName(cv "PAD" "PAD60GU" "layout" "pad60gu_IB22_top_7" list(390 1300) "R180")
dbCreateParamInstByMasterName(cv "tphn28hpcpgv18" "PDB3AC_V_G" "layout" "IB21_top_6" list(450 1300) "R180")
dbCreateParamInstByMasterName(cv "PAD" "PAD60GU" "layout" "pad60gu_IB21_top_6" list(450 1300) "R180")
dbCreateParamInstByMasterName(cv "tphn28hpcpgv18" "PDB3AC_V_G" "layout" "IB20_top_5" list(510 1300) "R180")
dbCreateParamInstByMasterName(cv "PAD" "PAD60GU" "layout" "pad60gu_IB20_top_5" list(510 1300) "R180")
dbCreateParamInstByMasterName(cv "tphn28hpcpgv18" "PDB3AC_V_G" "layout" "IB19_top_4" list(570 1300) "R180")
dbCreateParamInstByMasterName(cv "PAD" "PAD60GU" "layout" "pad60gu_IB19_top_4" list(570 1300) "R180")
dbCreateParamInstByMasterName(cv "tphn28hpcpgv18" "PDB3AC_V_G" "layout" "IB18_top_3" list(630 1300) "R180")
dbCreateParamInstByMasterName(cv "PAD" "PAD60GU" "layout" "pad60gu_IB18_top_3" list(630 1300) "R180")
dbCreateParamInstByMasterName(cv "tphn28hpcpgv18" "PDB3AC_V_G" "layout" "IB17_top_2" list(690 1300) "R180")
dbCreateParamInstByMasterName(cv "PAD" "PAD60GU" "layout" "pad60gu_IB17_top_2" list(690 1300) "R180")
dbCreateParamInstByMasterName(cv "tphn28hpcpgv18" "PDB3AC_V_G" "layout" "IB16_top_1" list(750 1300) "R180")
dbCreateParamInstByMasterName(cv "PAD" "PAD60GU" "layout" "pad60gu_IB16_top_1" list(750 1300) "R180")
dbCreateParamInstByMasterName(cv "tphn28hpcpgv18" "PDB3AC_V_G" "layout" "IB15_top_0" list(810 1300) "R180")
dbCreateParamInstByMasterName(cv "PAD" "PAD60GU" "layout" "pad60gu_IB15_top_0" list(810 1300) "R180")
dbCreateParamInstByMasterName(cv "tphn28hpcpgv18" "PCORNERA_G" "layout" "CORNER_TR_top_right" list(940 1300) "R180")

; ==================== Filler Components ====================
dbCreateParamInstByMasterName(cv "tphn28hpcpgv18" "PFILLER20A_G" "layout" "sep_bottom_right_corner" list(810 0) "R0")
dbCreateParamInstByMasterName(cv "tphn28hpcpgv18" "PFILLER20_G" "layout" "filler_bottom_left_corner" list(110 0) "R0")
dbCreateParamInstByMasterName(cv "tphn28hpcpgv18" "PFILLER20A_G" "layout" "filler_R0_1_1" list(770 0) "R0")
dbCreateParamInstByMasterName(cv "tphn28hpcpgv18" "PFILLER20A_G" "layout" "filler_R0_1_2" list(750 0) "R0")
dbCreateParamInstByMasterName(cv "tphn28hpcpgv18" "PFILLER20A_G" "layout" "filler_R0_2_1" list(710 0) "R0")
dbCreateParamInstByMasterName(cv "tphn28hpcpgv18" "PFILLER20A_G" "layout" "filler_R0_2_2" list(690 0) "R0")
dbCreateParamInstByMasterName(cv "tphn28hpcpgv18" "PFILLER20A_G" "layout" "filler_R0_3_1" list(650 0) "R0")
dbCreateParamInstByMasterName(cv "tphn28hpcpgv18" "PFILLER20A_G" "layout" "filler_R0_3_2" list(630 0) "R0")
dbCreateParamInstByMasterName(cv "tphn28hpcpgv18" "PFILLER20A_G" "layout" "filler_R0_4_1" list(590 0) "R0")
dbCreateParamInstByMasterName(cv "tphn28hpcpgv18" "PFILLER20A_G" "layout" "filler_R0_4_2" list(570 0) "R0")
dbCreateParamInstByMasterName(cv "tphn28hpcpgv18" "PFILLER20A_G" "layout" "filler_R0_5_1" list(530 0) "R0")
dbCreateParamInstByMasterName(cv "tphn28hpcpgv18" "PFILLER20A_G" "layout" "filler_R0_5_2" list(510 0) "R0")
dbCreateParamInstByMasterName(cv "tphn28hpcpgv18" "PFILLER20A_G" "layout" "filler_R0_6_1" list(470 0) "R0")
dbCreateParamInstByMasterName(cv "tphn28hpcpgv18" "PFILLER20A_G" "layout" "filler_R0_6_2" list(450 0) "R0")
dbCreateParamInstByMasterName(cv "tphn28hpcpgv18" "PRCUTA_G" "layout" "filler_R0_7_1" list(410 0) "R0")
dbCreateParamInstByMasterName(cv "tphn28hpcpgv18" "PRCUTA_G" "layout" "filler_R0_7_2" list(390 0) "R0")
dbCreateParamInstByMasterName(cv "tphn28hpcpgv18" "PFILLER20_G" "layout" "filler_R0_8_1" list(350 0) "R0")
dbCreateParamInstByMasterName(cv "tphn28hpcpgv18" "PFILLER20_G" "layout" "filler_R0_8_2" list(330 0) "R0")
dbCreateParamInstByMasterName(cv "tphn28hpcpgv18" "PFILLER20_G" "layout" "filler_R0_9_1" list(290 0) "R0")
dbCreateParamInstByMasterName(cv "tphn28hpcpgv18" "PFILLER20_G" "layout" "filler_R0_9_2" list(270 0) "R0")
dbCreateParamInstByMasterName(cv "tphn28hpcpgv18" "PFILLER20_G" "layout" "filler_R0_10_1" list(230 0) "R0")
dbCreateParamInstByMasterName(cv "tphn28hpcpgv18" "PFILLER20_G" "layout" "filler_R0_10_2" list(210 0) "R0")
dbCreateParamInstByMasterName(cv "tphn28hpcpgv18" "PFILLER20_G" "layout" "filler_R0_11_1" list(170 0) "R0")
dbCreateParamInstByMasterName(cv "tphn28hpcpgv18" "PFILLER20_G" "layout" "filler_R0_11_2" list(150 0) "R0")
dbCreateParamInstByMasterName(cv "tphn28hpcpgv18" "PFILLER20A_G" "layout" "filler_right_top_corner" list(940 1170) "R90")
dbCreateParamInstByMasterName(cv "tphn28hpcpgv18" "PFILLER20A_G" "layout" "filler_right_bottom_corner" list(940 110) "R90")
dbCreateParamInstByMasterName(cv "tphn28hpcpgv18" "PFILLER20A_G" "layout" "filler_R90_1_1" list(940 1130) "R90")
dbCreateParamInstByMasterName(cv "tphn28hpcpgv18" "PFILLER20A_G" "layout" "filler_R90_1_2" list(940 1110) "R90")
dbCreateParamInstByMasterName(cv "tphn28hpcpgv18" "PFILLER20A_G" "layout" "filler_R90_2_1" list(940 1070) "R90")
dbCreateParamInstByMasterName(cv "tphn28hpcpgv18" "PFILLER20A_G" "layout" "filler_R90_2_2" list(940 1050) "R90")
dbCreateParamInstByMasterName(cv "tphn28hpcpgv18" "PFILLER20A_G" "layout" "filler_R90_3_1" list(940 1010) "R90")
dbCreateParamInstByMasterName(cv "tphn28hpcpgv18" "PFILLER20A_G" "layout" "filler_R90_3_2" list(940 990) "R90")
dbCreateParamInstByMasterName(cv "tphn28hpcpgv18" "PFILLER20A_G" "layout" "filler_R90_4_1" list(940 950) "R90")
dbCreateParamInstByMasterName(cv "tphn28hpcpgv18" "PFILLER20A_G" "layout" "filler_R90_4_2" list(940 930) "R90")
dbCreateParamInstByMasterName(cv "tphn28hpcpgv18" "PFILLER20A_G" "layout" "filler_R90_5_1" list(940 890) "R90")
dbCreateParamInstByMasterName(cv "tphn28hpcpgv18" "PFILLER20A_G" "layout" "filler_R90_5_2" list(940 870) "R90")
dbCreateParamInstByMasterName(cv "tphn28hpcpgv18" "PFILLER20A_G" "layout" "filler_R90_6_1" list(940 830) "R90")
dbCreateParamInstByMasterName(cv "tphn28hpcpgv18" "PFILLER20A_G" "layout" "filler_R90_6_2" list(940 810) "R90")
dbCreateParamInstByMasterName(cv "tphn28hpcpgv18" "PFILLER20A_G" "layout" "filler_R90_7_1" list(940 770) "R90")
dbCreateParamInstByMasterName(cv "tphn28hpcpgv18" "PFILLER20A_G" "layout" "filler_R90_7_2" list(940 750) "R90")
dbCreateParamInstByMasterName(cv "tphn28hpcpgv18" "PFILLER20A_G" "layout" "filler_R90_8_1" list(940 710) "R90")
dbCreateParamInstByMasterName(cv "tphn28hpcpgv18" "PFILLER20A_G" "layout" "filler_R90_8_2" list(940 690) "R90")
dbCreateParamInstByMasterName(cv "tphn28hpcpgv18" "PFILLER20A_G" "layout" "filler_R90_9_1" list(940 650) "R90")
dbCreateParamInstByMasterName(cv "tphn28hpcpgv18" "PFILLER20A_G" "layout" "filler_R90_9_2" list(940 630) "R90")
dbCreateParamInstByMasterName(cv "tphn28hpcpgv18" "PFILLER20A_G" "layout" "filler_R90_10_1" list(940 590) "R90")
dbCreateParamInstByMasterName(cv "tphn28hpcpgv18" "PFILLER20A_G" "layout" "filler_R90_10_2" list(940 570) "R90")
dbCreateParamInstByMasterName(cv "tphn28hpcpgv18" "PFILLER20A_G" "layout" "filler_R90_11_1" list(940 530) "R90")
dbCreateParamInstByMasterName(cv "tphn28hpcpgv18" "PFILLER20A_G" "layout" "filler_R90_11_2" list(940 510) "R90")
dbCreateParamInstByMasterName(cv "tphn28hpcpgv18" "PFILLER20A_G" "layout" "filler_R90_12_1" list(940 470) "R90")
dbCreateParamInstByMasterName(cv "tphn28hpcpgv18" "PFILLER20A_G" "layout" "filler_R90_12_2" list(940 450) "R90")
dbCreateParamInstByMasterName(cv "tphn28hpcpgv18" "PFILLER20A_G" "layout" "filler_R90_13_1" list(940 410) "R90")
dbCreateParamInstByMasterName(cv "tphn28hpcpgv18" "PFILLER20A_G" "layout" "filler_R90_13_2" list(940 390) "R90")
dbCreateParamInstByMasterName(cv "tphn28hpcpgv18" "PFILLER20A_G" "layout" "filler_R90_14_1" list(940 350) "R90")
dbCreateParamInstByMasterName(cv "tphn28hpcpgv18" "PFILLER20A_G" "layout" "filler_R90_14_2" list(940 330) "R90")
dbCreateParamInstByMasterName(cv "tphn28hpcpgv18" "PFILLER20A_G" "layout" "filler_R90_15_1" list(940 290) "R90")
dbCreateParamInstByMasterName(cv "tphn28hpcpgv18" "PFILLER20A_G" "layout" "filler_R90_15_2" list(940 270) "R90")
dbCreateParamInstByMasterName(cv "tphn28hpcpgv18" "PFILLER20A_G" "layout" "filler_R90_16_1" list(940 230) "R90")
dbCreateParamInstByMasterName(cv "tphn28hpcpgv18" "PFILLER20A_G" "layout" "filler_R90_16_2" list(940 210) "R90")
dbCreateParamInstByMasterName(cv "tphn28hpcpgv18" "PFILLER20A_G" "layout" "filler_R90_17_1" list(940 170) "R90")
dbCreateParamInstByMasterName(cv "tphn28hpcpgv18" "PFILLER20A_G" "layout" "filler_R90_17_2" list(940 150) "R90")
dbCreateParamInstByMasterName(cv "tphn28hpcpgv18" "PRCUTA_G" "layout" "sep_top_left_corner" list(130 1300) "R180")
dbCreateParamInstByMasterName(cv "tphn28hpcpgv18" "PFILLER20A_G" "layout" "filler_top_right_corner" list(830 1300) "R180")
dbCreateParamInstByMasterName(cv "tphn28hpcpgv18" "PFILLER20A_G" "layout" "filler_R180_1_1" list(170 1300) "R180")
dbCreateParamInstByMasterName(cv "tphn28hpcpgv18" "PFILLER20A_G" "layout" "filler_R180_1_2" list(190 1300) "R180")
dbCreateParamInstByMasterName(cv "tphn28hpcpgv18" "PFILLER20A_G" "layout" "filler_R180_2_1" list(230 1300) "R180")
dbCreateParamInstByMasterName(cv "tphn28hpcpgv18" "PFILLER20A_G" "layout" "filler_R180_2_2" list(250 1300) "R180")
dbCreateParamInstByMasterName(cv "tphn28hpcpgv18" "PFILLER20A_G" "layout" "filler_R180_3_1" list(290 1300) "R180")
dbCreateParamInstByMasterName(cv "tphn28hpcpgv18" "PFILLER20A_G" "layout" "filler_R180_3_2" list(310 1300) "R180")
dbCreateParamInstByMasterName(cv "tphn28hpcpgv18" "PFILLER20A_G" "layout" "filler_R180_4_1" list(350 1300) "R180")
dbCreateParamInstByMasterName(cv "tphn28hpcpgv18" "PFILLER20A_G" "layout" "filler_R180_4_2" list(370 1300) "R180")
dbCreateParamInstByMasterName(cv "tphn28hpcpgv18" "PFILLER20A_G" "layout" "filler_R180_5_1" list(410 1300) "R180")
dbCreateParamInstByMasterName(cv "tphn28hpcpgv18" "PFILLER20A_G" "layout" "filler_R180_5_2" list(430 1300) "R180")
dbCreateParamInstByMasterName(cv "tphn28hpcpgv18" "PFILLER20A_G" "layout" "filler_R180_6_1" list(470 1300) "R180")
dbCreateParamInstByMasterName(cv "tphn28hpcpgv18" "PFILLER20A_G" "layout" "filler_R180_6_2" list(490 1300) "R180")
dbCreateParamInstByMasterName(cv "tphn28hpcpgv18" "PFILLER20A_G" "layout" "filler_R180_7_1" list(530 1300) "R180")
dbCreateParamInstByMasterName(cv "tphn28hpcpgv18" "PFILLER20A_G" "layout" "filler_R180_7_2" list(550 1300) "R180")
dbCreateParamInstByMasterName(cv "tphn28hpcpgv18" "PFILLER20A_G" "layout" "filler_R180_8_1" list(590 1300) "R180")
dbCreateParamInstByMasterName(cv "tphn28hpcpgv18" "PFILLER20A_G" "layout" "filler_R180_8_2" list(610 1300) "R180")
dbCreateParamInstByMasterName(cv "tphn28hpcpgv18" "PFILLER20A_G" "layout" "filler_R180_9_1" list(650 1300) "R180")
dbCreateParamInstByMasterName(cv "tphn28hpcpgv18" "PFILLER20A_G" "layout" "filler_R180_9_2" list(670 1300) "R180")
dbCreateParamInstByMasterName(cv "tphn28hpcpgv18" "PFILLER20A_G" "layout" "filler_R180_10_1" list(710 1300) "R180")
dbCreateParamInstByMasterName(cv "tphn28hpcpgv18" "PFILLER20A_G" "layout" "filler_R180_10_2" list(730 1300) "R180")
dbCreateParamInstByMasterName(cv "tphn28hpcpgv18" "PFILLER20A_G" "layout" "filler_R180_11_1" list(770 1300) "R180")
dbCreateParamInstByMasterName(cv "tphn28hpcpgv18" "PFILLER20A_G" "layout" "filler_R180_11_2" list(790 1300) "R180")
dbCreateParamInstByMasterName(cv "tphn28hpcpgv18" "PFILLER20_G" "layout" "filler_left_bottom_corner" list(0 130) "R270")
dbCreateParamInstByMasterName(cv "tphn28hpcpgv18" "PRCUTA_G" "layout" "sep_left_top_corner" list(0 1190) "R270")
dbCreateParamInstByMasterName(cv "tphn28hpcpgv18" "PFILLER20_G" "layout" "filler_R270_1_1" list(0 170) "R270")
dbCreateParamInstByMasterName(cv "tphn28hpcpgv18" "PFILLER20_G" "layout" "filler_R270_1_2" list(0 190) "R270")
dbCreateParamInstByMasterName(cv "tphn28hpcpgv18" "PFILLER20_G" "layout" "filler_R270_2_1" list(0 230) "R270")
dbCreateParamInstByMasterName(cv "tphn28hpcpgv18" "PFILLER20_G" "layout" "filler_R270_2_2" list(0 250) "R270")
dbCreateParamInstByMasterName(cv "tphn28hpcpgv18" "PFILLER20_G" "layout" "filler_R270_3_1" list(0 290) "R270")
dbCreateParamInstByMasterName(cv "tphn28hpcpgv18" "PFILLER20_G" "layout" "filler_R270_3_2" list(0 310) "R270")
dbCreateParamInstByMasterName(cv "tphn28hpcpgv18" "PFILLER20_G" "layout" "filler_R270_4_1" list(0 350) "R270")
dbCreateParamInstByMasterName(cv "tphn28hpcpgv18" "PFILLER20_G" "layout" "filler_R270_4_2" list(0 370) "R270")
dbCreateParamInstByMasterName(cv "tphn28hpcpgv18" "PFILLER20_G" "layout" "filler_R270_5_1" list(0 410) "R270")
dbCreateParamInstByMasterName(cv "tphn28hpcpgv18" "PFILLER20_G" "layout" "filler_R270_5_2" list(0 430) "R270")
dbCreateParamInstByMasterName(cv "tphn28hpcpgv18" "PFILLER20_G" "layout" "filler_R270_6_1" list(0 470) "R270")
dbCreateParamInstByMasterName(cv "tphn28hpcpgv18" "PFILLER20_G" "layout" "filler_R270_6_2" list(0 490) "R270")
dbCreateParamInstByMasterName(cv "tphn28hpcpgv18" "PFILLER20_G" "layout" "filler_R270_7_1" list(0 530) "R270")
dbCreateParamInstByMasterName(cv "tphn28hpcpgv18" "PFILLER20_G" "layout" "filler_R270_7_2" list(0 550) "R270")
dbCreateParamInstByMasterName(cv "tphn28hpcpgv18" "PFILLER20_G" "layout" "filler_R270_8_1" list(0 590) "R270")
dbCreateParamInstByMasterName(cv "tphn28hpcpgv18" "PFILLER20_G" "layout" "filler_R270_8_2" list(0 610) "R270")
dbCreateParamInstByMasterName(cv "tphn28hpcpgv18" "PFILLER20_G" "layout" "filler_R270_9_1" list(0 650) "R270")
dbCreateParamInstByMasterName(cv "tphn28hpcpgv18" "PFILLER20_G" "layout" "filler_R270_9_2" list(0 670) "R270")
dbCreateParamInstByMasterName(cv "tphn28hpcpgv18" "PFILLER20_G" "layout" "filler_R270_10_1" list(0 710) "R270")
dbCreateParamInstByMasterName(cv "tphn28hpcpgv18" "PFILLER20_G" "layout" "filler_R270_10_2" list(0 730) "R270")
dbCreateParamInstByMasterName(cv "tphn28hpcpgv18" "PFILLER20_G" "layout" "filler_R270_11_1" list(0 770) "R270")
dbCreateParamInstByMasterName(cv "tphn28hpcpgv18" "PFILLER20_G" "layout" "filler_R270_11_2" list(0 790) "R270")
dbCreateParamInstByMasterName(cv "tphn28hpcpgv18" "PFILLER20_G" "layout" "filler_R270_12_1" list(0 830) "R270")
dbCreateParamInstByMasterName(cv "tphn28hpcpgv18" "PFILLER20_G" "layout" "filler_R270_12_2" list(0 850) "R270")
dbCreateParamInstByMasterName(cv "tphn28hpcpgv18" "PFILLER20_G" "layout" "filler_R270_13_1" list(0 890) "R270")
dbCreateParamInstByMasterName(cv "tphn28hpcpgv18" "PFILLER20_G" "layout" "filler_R270_13_2" list(0 910) "R270")
dbCreateParamInstByMasterName(cv "tphn28hpcpgv18" "PFILLER20_G" "layout" "filler_R270_14_1" list(0 950) "R270")
dbCreateParamInstByMasterName(cv "tphn28hpcpgv18" "PFILLER20_G" "layout" "filler_R270_14_2" list(0 970) "R270")
dbCreateParamInstByMasterName(cv "tphn28hpcpgv18" "PFILLER20_G" "layout" "filler_R270_15_1" list(0 1010) "R270")
dbCreateParamInstByMasterName(cv "tphn28hpcpgv18" "PFILLER20_G" "layout" "filler_R270_15_2" list(0 1030) "R270")
dbCreateParamInstByMasterName(cv "tphn28hpcpgv18" "PFILLER20_G" "layout" "filler_R270_16_1" list(0 1070) "R270")
dbCreateParamInstByMasterName(cv "tphn28hpcpgv18" "PFILLER20_G" "layout" "filler_R270_16_2" list(0 1090) "R270")
dbCreateParamInstByMasterName(cv "tphn28hpcpgv18" "PFILLER20_G" "layout" "filler_R270_17_1" list(0 1130) "R270")
dbCreateParamInstByMasterName(cv "tphn28hpcpgv18" "PFILLER20_G" "layout" "filler_R270_17_2" list(0 1150) "R270")

; ==================== Digital IO Features (with Inner Pad Support) ====================
dbCreatePath(cv list("M3" "drawing") list(list(130 110.5) list(390 110.5)) 0.2)
dbCreatePath(cv list("M3" "drawing") list(list(130 109.24) list(390 109.24)) 0.2)
dbCreatePath(cv list("M3" "drawing") list(list(110.5 130) list(110.5 1170)) 0.2)
dbCreatePath(cv list("M3" "drawing") list(list(109.24 130) list(109.24 1170)) 0.2)
dbCreatePath(cv list("M3" "drawing") list(list(130 110.5) list(110.5 110.5)) 0.2 "extendExtend")
dbCreatePath(cv list("M3" "drawing") list(list(110.5 110.5) list(110.5 130)) 0.2 "extendExtend")
dbCreatePath(cv list("M3" "drawing") list(list(130 109.24) list(109.24 109.24)) 0.2 "extendExtend")
dbCreatePath(cv list("M3" "drawing") list(list(109.24 109.24) list(109.24 130)) 0.2 "extendExtend")
dbCreatePath(cv list("M3" "drawing") list(list(252.39 110.12) list(252.39 109.24)) 0.2)
tech = techGetTechFile(cv)
viaParams = list(list("cutRows" 2) list("cutColumns" 4))
viaDefId = techFindViaDefByName(tech "M3_M2")
newVia = dbCreateVia(cv viaDefId list(252.39 110.12) "R0" viaParams)
dbCreatePath(cv list("M3" "drawing") list(list(372.345 110.12) list(372.345 110.5)) 0.2)
tech = techGetTechFile(cv)
viaParams = list(list("cutRows" 2) list("cutColumns" 4))
viaDefId = techFindViaDefByName(tech "M3_M2")
newVia = dbCreateVia(cv viaDefId list(372.345 110.12) "R0" viaParams)
dbCreatePath(cv list("M3" "drawing") list(list(109.875 1159.8) list(110.5 1159.8)) 0.26)
dbCreatePath(cv list("M3" "drawing") list(list(109.875 1164.1) list(109.24 1164.1)) 0.26)
dbCreateLabel(cv list("M4" "pin") list(109.875 1168.275) "D0_CORE" "centerLeft" "R0" "roman" 2)
dbCreatePath(cv list("M3" "drawing") list(list(109.875 1099.8) list(110.5 1099.8)) 0.26)
dbCreatePath(cv list("M3" "drawing") list(list(109.875 1104.1) list(109.24 1104.1)) 0.26)
dbCreateLabel(cv list("M4" "pin") list(109.875 1108.275) "D1_CORE" "centerLeft" "R0" "roman" 2)
dbCreatePath(cv list("M3" "drawing") list(list(109.875 1039.8) list(110.5 1039.8)) 0.26)
dbCreatePath(cv list("M3" "drawing") list(list(109.875 1044.1) list(109.24 1044.1)) 0.26)
dbCreateLabel(cv list("M4" "pin") list(109.875 1048.275) "D2_CORE" "centerLeft" "R0" "roman" 2)
dbCreatePath(cv list("M3" "drawing") list(list(109.875 979.8) list(110.5 979.8)) 0.26)
dbCreatePath(cv list("M3" "drawing") list(list(109.875 984.1) list(109.24 984.1)) 0.26)
dbCreateLabel(cv list("M4" "pin") list(109.875 988.275) "D3_CORE" "centerLeft" "R0" "roman" 2)
dbCreatePath(cv list("M3" "drawing") list(list(109.875 919.8) list(110.5 919.8)) 0.26)
dbCreatePath(cv list("M3" "drawing") list(list(109.875 924.1) list(109.24 924.1)) 0.26)
dbCreateLabel(cv list("M4" "pin") list(109.875 928.275) "D4_CORE" "centerLeft" "R0" "roman" 2)
dbCreatePath(cv list("M3" "drawing") list(list(109.875 859.8) list(110.5 859.8)) 0.26)
dbCreatePath(cv list("M3" "drawing") list(list(109.875 864.1) list(109.24 864.1)) 0.26)
dbCreateLabel(cv list("M4" "pin") list(109.875 868.275) "D5_CORE" "centerLeft" "R0" "roman" 2)
dbCreatePath(cv list("M3" "drawing") list(list(109.875 799.8) list(110.5 799.8)) 0.26)
dbCreatePath(cv list("M3" "drawing") list(list(109.875 804.1) list(109.24 804.1)) 0.26)
dbCreateLabel(cv list("M4" "pin") list(109.875 808.275) "D6_CORE" "centerLeft" "R0" "roman" 2)
dbCreatePath(cv list("M3" "drawing") list(list(109.875 739.8) list(110.5 739.8)) 0.26)
dbCreatePath(cv list("M3" "drawing") list(list(109.875 744.1) list(109.24 744.1)) 0.26)
dbCreateLabel(cv list("M4" "pin") list(109.875 748.275) "D7_CORE" "centerLeft" "R0" "roman" 2)
dbCreatePath(cv list("M3" "drawing") list(list(109.875 679.8) list(110.5 679.8)) 0.26)
dbCreatePath(cv list("M3" "drawing") list(list(109.875 684.1) list(109.24 684.1)) 0.26)
dbCreateLabel(cv list("M4" "pin") list(109.875 688.275) "D8_CORE" "centerLeft" "R0" "roman" 2)
dbCreatePath(cv list("M3" "drawing") list(list(109.875 619.8) list(110.5 619.8)) 0.26)
dbCreatePath(cv list("M3" "drawing") list(list(109.875 624.1) list(109.24 624.1)) 0.26)
dbCreateLabel(cv list("M4" "pin") list(109.875 628.275) "D9_CORE" "centerLeft" "R0" "roman" 2)
dbCreatePath(cv list("M3" "drawing") list(list(109.875 559.8) list(110.5 559.8)) 0.26)
dbCreatePath(cv list("M3" "drawing") list(list(109.875 564.1) list(109.24 564.1)) 0.26)
dbCreateLabel(cv list("M4" "pin") list(109.875 568.275) "D10_CORE" "centerLeft" "R0" "roman" 2)
dbCreatePath(cv list("M3" "drawing") list(list(109.875 499.8) list(110.5 499.8)) 0.26)
dbCreatePath(cv list("M3" "drawing") list(list(109.875 504.1) list(109.24 504.1)) 0.26)
dbCreateLabel(cv list("M4" "pin") list(109.875 508.275) "D11_CORE" "centerLeft" "R0" "roman" 2)
dbCreatePath(cv list("M3" "drawing") list(list(109.875 439.8) list(110.5 439.8)) 0.26)
dbCreatePath(cv list("M3" "drawing") list(list(109.875 444.1) list(109.24 444.1)) 0.26)
dbCreateLabel(cv list("M4" "pin") list(109.875 448.275) "D12_CORE" "centerLeft" "R0" "roman" 2)
dbCreatePath(cv list("M3" "drawing") list(list(109.875 379.8) list(110.5 379.8)) 0.26)
dbCreatePath(cv list("M3" "drawing") list(list(109.875 384.1) list(109.24 384.1)) 0.26)
dbCreateLabel(cv list("M4" "pin") list(109.875 388.275) "D13_CORE" "centerLeft" "R0" "roman" 2)
dbCreatePath(cv list("M3" "drawing") list(list(109.875 319.8) list(110.5 319.8)) 0.26)
dbCreatePath(cv list("M3" "drawing") list(list(109.875 324.1) list(109.24 324.1)) 0.26)
dbCreateLabel(cv list("M4" "pin") list(109.875 328.275) "D14_CORE" "centerLeft" "R0" "roman" 2)
dbCreatePath(cv list("M3" "drawing") list(list(109.875 259.8) list(110.5 259.8)) 0.26)
dbCreatePath(cv list("M3" "drawing") list(list(109.875 264.1) list(109.24 264.1)) 0.26)
dbCreateLabel(cv list("M4" "pin") list(109.875 268.275) "D15_CORE" "centerLeft" "R0" "roman" 2)
dbCreatePath(cv list("M3" "drawing") list(list(109.875 199.8) list(109.24 199.8)) 0.26)
dbCreatePath(cv list("M3" "drawing") list(list(109.875 208.275) list(109.24 208.275)) 0.26)
dbCreatePath(cv list("M3" "drawing") list(list(109.875 204.1) list(110.5 204.1)) 0.26)
dbCreateLabel(cv list("M4" "pin") list(109.875 195.67) "CS_CORE" "centerLeft" "R0" "roman" 2)
dbCreatePath(cv list("M3" "drawing") list(list(109.875 139.8) list(109.24 139.8)) 0.26)
dbCreatePath(cv list("M3" "drawing") list(list(109.875 148.275) list(109.24 148.275)) 0.26)
dbCreatePath(cv list("M3" "drawing") list(list(109.875 144.1) list(110.5 144.1)) 0.26)
dbCreateLabel(cv list("M4" "pin") list(109.875 135.67) "EN_CORE" "centerLeft" "R0" "roman" 2)
dbCreatePath(cv list("M3" "drawing") list(list(140.2 109.875) list(140.2 109.24)) 0.26)
dbCreatePath(cv list("M3" "drawing") list(list(131.725 109.875) list(131.725 109.24)) 0.26)
dbCreatePath(cv list("M3" "drawing") list(list(135.9 109.875) list(135.9 110.5)) 0.26)
dbCreateLabel(cv list("M4" "pin") list(144.33 109.875) "TEST_CORE" "centerLeft" "R90" "roman" 2)

; ==================== Pin Labels (with Inner Pad Support) ====================
dbCreateLabel(cv list("AP" "pin") list(-11 1160) "D0" "centerRight" "R0" "roman" 10)
dbCreateLabel(cv list("AP" "pin") list(-11 1100) "D1" "centerRight" "R0" "roman" 10)
dbCreateLabel(cv list("AP" "pin") list(-11 1040) "D2" "centerRight" "R0" "roman" 10)
dbCreateLabel(cv list("AP" "pin") list(-11 980) "D3" "centerRight" "R0" "roman" 10)
dbCreateLabel(cv list("AP" "pin") list(-11 920) "D4" "centerRight" "R0" "roman" 10)
dbCreateLabel(cv list("AP" "pin") list(-11 860) "D5" "centerRight" "R0" "roman" 10)
dbCreateLabel(cv list("AP" "pin") list(-11 800) "D6" "centerRight" "R0" "roman" 10)
dbCreateLabel(cv list("AP" "pin") list(-11 740) "D7" "centerRight" "R0" "roman" 10)
dbCreateLabel(cv list("AP" "pin") list(-11 680) "D8" "centerRight" "R0" "roman" 10)
dbCreateLabel(cv list("AP" "pin") list(-11 620) "D9" "centerRight" "R0" "roman" 10)
dbCreateLabel(cv list("AP" "pin") list(-11 560) "D10" "centerRight" "R0" "roman" 10)
dbCreateLabel(cv list("AP" "pin") list(-11 500) "D11" "centerRight" "R0" "roman" 10)
dbCreateLabel(cv list("AP" "pin") list(-11 440) "D12" "centerRight" "R0" "roman" 10)
dbCreateLabel(cv list("AP" "pin") list(-11 380) "D13" "centerRight" "R0" "roman" 10)
dbCreateLabel(cv list("AP" "pin") list(-11 320) "D14" "centerRight" "R0" "roman" 10)
dbCreateLabel(cv list("AP" "pin") list(-11 260) "D15" "centerRight" "R0" "roman" 10)
dbCreateLabel(cv list("AP" "pin") list(-11 200) "CS" "centerRight" "R0" "roman" 10)
dbCreateLabel(cv list("AP" "pin") list(-11 140) "EN" "centerRight" "R0" "roman" 10)
dbCreateLabel(cv list("AP" "pin") list(140 -11) "TEST" "centerRight" "R90" "roman" 10)
dbCreateLabel(cv list("AP" "pin") list(200 -11) "VIOH" "centerRight" "R90" "roman" 10)
dbCreateLabel(cv list("AP" "pin") list(260 -11) "GIOL" "centerRight" "R90" "roman" 10)
dbCreateLabel(cv list("AP" "pin") list(320 -11) "GIOH" "centerRight" "R90" "roman" 10)
dbCreateLabel(cv list("AP" "pin") list(380 -11) "VIOL" "centerRight" "R90" "roman" 10)
dbCreateLabel(cv list("AP" "pin") list(440 -11) "VSSSAR" "centerRight" "R90" "roman" 10)
dbCreateLabel(cv list("M2" "pin") list(440 109.9) "VSSSAR_CORE" "centerLeft" "R90" "roman" 2)
dbCreateLabel(cv list("AP" "pin") list(500 -11) "VDDSAR" "centerRight" "R90" "roman" 10)
dbCreateLabel(cv list("M2" "pin") list(500 109.9) "VDDSAR_CORE" "centerLeft" "R90" "roman" 2)
dbCreateLabel(cv list("AP" "pin") list(560 -11) "VIP" "centerRight" "R90" "roman" 10)
dbCreateLabel(cv list("AP" "pin") list(620 -11) "VIN" "centerRight" "R90" "roman" 10)
dbCreateLabel(cv list("AP" "pin") list(680 -11) "VCM" "centerRight" "R90" "roman" 10)
dbCreateLabel(cv list("AP" "pin") list(740 -11) "VINCM" "centerRight" "R90" "roman" 10)
dbCreateLabel(cv list("AP" "pin") list(800 -11) "IBIAS" "centerRight" "R90" "roman" 10)
dbCreateLabel(cv list("AP" "pin") list(951 140) "IBIAS2" "centerLeft" "R0" "roman" 10)
dbCreateLabel(cv list("AP" "pin") list(951 200) "VREF" "centerLeft" "R0" "roman" 10)
dbCreateLabel(cv list("AP" "pin") list(951 260) "VREF2" "centerLeft" "R0" "roman" 10)
dbCreateLabel(cv list("AP" "pin") list(951 320) "IB0" "centerLeft" "R0" "roman" 10)
dbCreateLabel(cv list("AP" "pin") list(951 380) "IB1" "centerLeft" "R0" "roman" 10)
dbCreateLabel(cv list("AP" "pin") list(951 440) "IB2" "centerLeft" "R0" "roman" 10)
dbCreateLabel(cv list("AP" "pin") list(951 500) "IB3" "centerLeft" "R0" "roman" 10)
dbCreateLabel(cv list("AP" "pin") list(951 560) "IB4" "centerLeft" "R0" "roman" 10)
dbCreateLabel(cv list("AP" "pin") list(951 620) "IB5" "centerLeft" "R0" "roman" 10)
dbCreateLabel(cv list("AP" "pin") list(951 680) "IB6" "centerLeft" "R0" "roman" 10)
dbCreateLabel(cv list("AP" "pin") list(951 740) "IB7" "centerLeft" "R0" "roman" 10)
dbCreateLabel(cv list("AP" "pin") list(951 800) "IB8" "centerLeft" "R0" "roman" 10)
dbCreateLabel(cv list("AP" "pin") list(951 860) "IB9" "centerLeft" "R0" "roman" 10)
dbCreateLabel(cv list("AP" "pin") list(951 920) "IB10" "centerLeft" "R0" "roman" 10)
dbCreateLabel(cv list("AP" "pin") list(951 980) "IB11" "centerLeft" "R0" "roman" 10)
dbCreateLabel(cv list("AP" "pin") list(951 1040) "IB12" "centerLeft" "R0" "roman" 10)
dbCreateLabel(cv list("AP" "pin") list(951 1100) "IB13" "centerLeft" "R0" "roman" 10)
dbCreateLabel(cv list("AP" "pin") list(951 1160) "IB14" "centerLeft" "R0" "roman" 10)
dbCreateLabel(cv list("AP" "pin") list(800 1311) "IB15" "centerLeft" "R90" "roman" 10)
dbCreateLabel(cv list("AP" "pin") list(740 1311) "IB16" "centerLeft" "R90" "roman" 10)
dbCreateLabel(cv list("AP" "pin") list(680 1311) "IB17" "centerLeft" "R90" "roman" 10)
dbCreateLabel(cv list("AP" "pin") list(620 1311) "IB18" "centerLeft" "R90" "roman" 10)
dbCreateLabel(cv list("AP" "pin") list(560 1311) "IB19" "centerLeft" "R90" "roman" 10)
dbCreateLabel(cv list("AP" "pin") list(500 1311) "IB20" "centerLeft" "R90" "roman" 10)
dbCreateLabel(cv list("AP" "pin") list(440 1311) "IB21" "centerLeft" "R90" "roman" 10)
dbCreateLabel(cv list("AP" "pin") list(380 1311) "IB22" "centerLeft" "R90" "roman" 10)
dbCreateLabel(cv list("AP" "pin") list(320 1311) "IB23" "centerLeft" "R90" "roman" 10)
dbCreateLabel(cv list("AP" "pin") list(260 1311) "IB24" "centerLeft" "R90" "roman" 10)
dbCreateLabel(cv list("AP" "pin") list(200 1311) "IB25" "centerLeft" "R90" "roman" 10)
dbCreateLabel(cv list("AP" "pin") list(140 1311) "IB26" "centerLeft" "R90" "roman" 10)

dbSave(cv)
t
