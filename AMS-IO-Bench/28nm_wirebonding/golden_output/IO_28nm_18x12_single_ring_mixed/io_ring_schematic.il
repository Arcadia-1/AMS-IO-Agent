pddw16sdgz_h_gMaster = dbOpenCellView("tphn28hpcpgv18" "PDDW16SDGZ_H_G" "symbol")
dbCreateInst(cv pddw16sdgz_h_gMaster "D0_left0" '(0 37.6875) "R270")
schCreateWire(cv "route" "full" '((1.000 37.562) (1.750 37.562)) 0 0 0 nil nil)
schCreateWireLabel(cv nil '(1.250 37.562) "VIOL" "lowerLeft" "R0" "stick" 0.0625 nil)
noConnMaster = dbOpenCellView("basic" "noConn" "symbol")
schCreateWire(cv "route" "full" '((1.000 37.438) (1.750 37.438)) 0 0 0 nil nil)
dbCreateInst(cv noConnMaster "noConn_D0_left0_C" '(1.750 37.438) "R90")
schCreateWire(cv "route" "full" '((1.000 37.812) (1.750 37.812)) 0 0 0 nil nil)
schCreateWireLabel(cv nil '(1.250 37.812) "GIOL" "lowerLeft" "R0" "stick" 0.0625 nil)
schCreateWire(cv "route" "full" '((1.000 37.938) (1.750 37.938)) 0 0 0 nil nil)
schCreateWireLabel(cv nil '(1.250 37.938) "D0_CORE" "lowerLeft" "R0" "stick" 0.0625 nil)
schCreatePin(cv nil "D0_CORE" "inputOutput" nil '(1.750 37.938) "R180")
schCreateWire(cv "route" "full" '((0.000 36.999) (-0.750 36.999)) 0 0 0 nil nil)
schCreateWireLabel(cv nil '(-0.250 36.999) "D0" "lowerRight" "R0" "stick" 0.0625 nil)
schCreatePin(cv nil "D0" "inputOutput" nil '(-0.750 36.999) "R0")
schCreateWire(cv "route" "full" '((1.000 37.312) (1.750 37.312)) 0 0 0 nil nil)
schCreateWireLabel(cv nil '(1.250 37.312) "POC" "lowerLeft" "R0" "stick" 0.0625 nil)
schCreateWire(cv "route" "full" '((1.000 37.126) (1.750 37.126)) 0 0 0 nil nil)
schCreateWireLabel(cv nil '(1.250 37.126) "VIOL" "lowerLeft" "R0" "stick" 0.0625 nil)
schCreateWire(cv "route" "full" '((1.000 36.938) (1.750 36.938)) 0 0 0 nil nil)
schCreateWireLabel(cv nil '(1.250 36.938) "GIOL" "lowerLeft" "R0" "stick" 0.0625 nil)
schCreateWire(cv "route" "full" '((1.000 36.749) (1.750 36.749)) 0 0 0 nil nil)
schCreateWireLabel(cv nil '(1.250 36.749) "VIOH" "lowerLeft" "R0" "stick" 0.0625 nil)
schCreateWire(cv "route" "full" '((1.000 36.376) (1.750 36.376)) 0 0 0 nil nil)
schCreateWireLabel(cv nil '(1.250 36.376) "GIOH" "lowerLeft" "R0" "stick" 0.0625 nil)
dbCreateInst(cv pddw16sdgz_h_gMaster "D1_left1" '(0 35.6875) "R270")
schCreateWire(cv "route" "full" '((1.000 35.562) (1.750 35.562)) 0 0 0 nil nil)
schCreateWireLabel(cv nil '(1.250 35.562) "VIOL" "lowerLeft" "R0" "stick" 0.0625 nil)
schCreateWire(cv "route" "full" '((1.000 35.438) (1.750 35.438)) 0 0 0 nil nil)
dbCreateInst(cv noConnMaster "noConn_D1_left1_C" '(1.750 35.438) "R90")
schCreateWire(cv "route" "full" '((1.000 35.812) (1.750 35.812)) 0 0 0 nil nil)
schCreateWireLabel(cv nil '(1.250 35.812) "GIOL" "lowerLeft" "R0" "stick" 0.0625 nil)
schCreateWire(cv "route" "full" '((1.000 35.938) (1.750 35.938)) 0 0 0 nil nil)
schCreateWireLabel(cv nil '(1.250 35.938) "D1_CORE" "lowerLeft" "R0" "stick" 0.0625 nil)
schCreatePin(cv nil "D1_CORE" "inputOutput" nil '(1.750 35.938) "R180")
schCreateWire(cv "route" "full" '((0.000 34.999) (-0.750 34.999)) 0 0 0 nil nil)
schCreateWireLabel(cv nil '(-0.250 34.999) "D1" "lowerRight" "R0" "stick" 0.0625 nil)
schCreatePin(cv nil "D1" "inputOutput" nil '(-0.750 34.999) "R0")
schCreateWire(cv "route" "full" '((1.000 35.312) (1.750 35.312)) 0 0 0 nil nil)
schCreateWireLabel(cv nil '(1.250 35.312) "POC" "lowerLeft" "R0" "stick" 0.0625 nil)
schCreateWire(cv "route" "full" '((1.000 35.126) (1.750 35.126)) 0 0 0 nil nil)
schCreateWireLabel(cv nil '(1.250 35.126) "VIOL" "lowerLeft" "R0" "stick" 0.0625 nil)
schCreateWire(cv "route" "full" '((1.000 34.938) (1.750 34.938)) 0 0 0 nil nil)
schCreateWireLabel(cv nil '(1.250 34.938) "GIOL" "lowerLeft" "R0" "stick" 0.0625 nil)
schCreateWire(cv "route" "full" '((1.000 34.749) (1.750 34.749)) 0 0 0 nil nil)
schCreateWireLabel(cv nil '(1.250 34.749) "VIOH" "lowerLeft" "R0" "stick" 0.0625 nil)
schCreateWire(cv "route" "full" '((1.000 34.376) (1.750 34.376)) 0 0 0 nil nil)
schCreateWireLabel(cv nil '(1.250 34.376) "GIOH" "lowerLeft" "R0" "stick" 0.0625 nil)
dbCreateInst(cv pddw16sdgz_h_gMaster "D2_left2" '(0 33.6875) "R270")
schCreateWire(cv "route" "full" '((1.000 33.562) (1.750 33.562)) 0 0 0 nil nil)
schCreateWireLabel(cv nil '(1.250 33.562) "VIOL" "lowerLeft" "R0" "stick" 0.0625 nil)
schCreateWire(cv "route" "full" '((1.000 33.438) (1.750 33.438)) 0 0 0 nil nil)
dbCreateInst(cv noConnMaster "noConn_D2_left2_C" '(1.750 33.438) "R90")
schCreateWire(cv "route" "full" '((1.000 33.812) (1.750 33.812)) 0 0 0 nil nil)
schCreateWireLabel(cv nil '(1.250 33.812) "GIOL" "lowerLeft" "R0" "stick" 0.0625 nil)
schCreateWire(cv "route" "full" '((1.000 33.938) (1.750 33.938)) 0 0 0 nil nil)
schCreateWireLabel(cv nil '(1.250 33.938) "D2_CORE" "lowerLeft" "R0" "stick" 0.0625 nil)
schCreatePin(cv nil "D2_CORE" "inputOutput" nil '(1.750 33.938) "R180")
schCreateWire(cv "route" "full" '((0.000 32.999) (-0.750 32.999)) 0 0 0 nil nil)
schCreateWireLabel(cv nil '(-0.250 32.999) "D2" "lowerRight" "R0" "stick" 0.0625 nil)
schCreatePin(cv nil "D2" "inputOutput" nil '(-0.750 32.999) "R0")
schCreateWire(cv "route" "full" '((1.000 33.312) (1.750 33.312)) 0 0 0 nil nil)
schCreateWireLabel(cv nil '(1.250 33.312) "POC" "lowerLeft" "R0" "stick" 0.0625 nil)
schCreateWire(cv "route" "full" '((1.000 33.126) (1.750 33.126)) 0 0 0 nil nil)
schCreateWireLabel(cv nil '(1.250 33.126) "VIOL" "lowerLeft" "R0" "stick" 0.0625 nil)
schCreateWire(cv "route" "full" '((1.000 32.938) (1.750 32.938)) 0 0 0 nil nil)
schCreateWireLabel(cv nil '(1.250 32.938) "GIOL" "lowerLeft" "R0" "stick" 0.0625 nil)
schCreateWire(cv "route" "full" '((1.000 32.749) (1.750 32.749)) 0 0 0 nil nil)
schCreateWireLabel(cv nil '(1.250 32.749) "VIOH" "lowerLeft" "R0" "stick" 0.0625 nil)
schCreateWire(cv "route" "full" '((1.000 32.376) (1.750 32.376)) 0 0 0 nil nil)
schCreateWireLabel(cv nil '(1.250 32.376) "GIOH" "lowerLeft" "R0" "stick" 0.0625 nil)
dbCreateInst(cv pddw16sdgz_h_gMaster "D3_left3" '(0 31.6875) "R270")
schCreateWire(cv "route" "full" '((1.000 31.562) (1.750 31.562)) 0 0 0 nil nil)
schCreateWireLabel(cv nil '(1.250 31.562) "VIOL" "lowerLeft" "R0" "stick" 0.0625 nil)
schCreateWire(cv "route" "full" '((1.000 31.438) (1.750 31.438)) 0 0 0 nil nil)
dbCreateInst(cv noConnMaster "noConn_D3_left3_C" '(1.750 31.438) "R90")
schCreateWire(cv "route" "full" '((1.000 31.812) (1.750 31.812)) 0 0 0 nil nil)
schCreateWireLabel(cv nil '(1.250 31.812) "GIOL" "lowerLeft" "R0" "stick" 0.0625 nil)
schCreateWire(cv "route" "full" '((1.000 31.938) (1.750 31.938)) 0 0 0 nil nil)
schCreateWireLabel(cv nil '(1.250 31.938) "D3_CORE" "lowerLeft" "R0" "stick" 0.0625 nil)
schCreatePin(cv nil "D3_CORE" "inputOutput" nil '(1.750 31.938) "R180")
schCreateWire(cv "route" "full" '((0.000 31.000) (-0.750 31.000)) 0 0 0 nil nil)
schCreateWireLabel(cv nil '(-0.250 31.000) "D3" "lowerRight" "R0" "stick" 0.0625 nil)
schCreatePin(cv nil "D3" "inputOutput" nil '(-0.750 31.000) "R0")
schCreateWire(cv "route" "full" '((1.000 31.312) (1.750 31.312)) 0 0 0 nil nil)
schCreateWireLabel(cv nil '(1.250 31.312) "POC" "lowerLeft" "R0" "stick" 0.0625 nil)
schCreateWire(cv "route" "full" '((1.000 31.125) (1.750 31.125)) 0 0 0 nil nil)
schCreateWireLabel(cv nil '(1.250 31.125) "VIOL" "lowerLeft" "R0" "stick" 0.0625 nil)
schCreateWire(cv "route" "full" '((1.000 30.938) (1.750 30.938)) 0 0 0 nil nil)
schCreateWireLabel(cv nil '(1.250 30.938) "GIOL" "lowerLeft" "R0" "stick" 0.0625 nil)
schCreateWire(cv "route" "full" '((1.000 30.750) (1.750 30.750)) 0 0 0 nil nil)
schCreateWireLabel(cv nil '(1.250 30.750) "VIOH" "lowerLeft" "R0" "stick" 0.0625 nil)
schCreateWire(cv "route" "full" '((1.000 30.375) (1.750 30.375)) 0 0 0 nil nil)
schCreateWireLabel(cv nil '(1.250 30.375) "GIOH" "lowerLeft" "R0" "stick" 0.0625 nil)
dbCreateInst(cv pddw16sdgz_h_gMaster "D4_left4" '(0 29.6875) "R270")
schCreateWire(cv "route" "full" '((1.000 29.562) (1.750 29.562)) 0 0 0 nil nil)
schCreateWireLabel(cv nil '(1.250 29.562) "VIOL" "lowerLeft" "R0" "stick" 0.0625 nil)
schCreateWire(cv "route" "full" '((1.000 29.438) (1.750 29.438)) 0 0 0 nil nil)
dbCreateInst(cv noConnMaster "noConn_D4_left4_C" '(1.750 29.438) "R90")
schCreateWire(cv "route" "full" '((1.000 29.812) (1.750 29.812)) 0 0 0 nil nil)
schCreateWireLabel(cv nil '(1.250 29.812) "GIOL" "lowerLeft" "R0" "stick" 0.0625 nil)
schCreateWire(cv "route" "full" '((1.000 29.938) (1.750 29.938)) 0 0 0 nil nil)
schCreateWireLabel(cv nil '(1.250 29.938) "D4_CORE" "lowerLeft" "R0" "stick" 0.0625 nil)
schCreatePin(cv nil "D4_CORE" "inputOutput" nil '(1.750 29.938) "R180")
schCreateWire(cv "route" "full" '((0.000 29.000) (-0.750 29.000)) 0 0 0 nil nil)
schCreateWireLabel(cv nil '(-0.250 29.000) "D4" "lowerRight" "R0" "stick" 0.0625 nil)
schCreatePin(cv nil "D4" "inputOutput" nil '(-0.750 29.000) "R0")
schCreateWire(cv "route" "full" '((1.000 29.312) (1.750 29.312)) 0 0 0 nil nil)
schCreateWireLabel(cv nil '(1.250 29.312) "POC" "lowerLeft" "R0" "stick" 0.0625 nil)
schCreateWire(cv "route" "full" '((1.000 29.125) (1.750 29.125)) 0 0 0 nil nil)
schCreateWireLabel(cv nil '(1.250 29.125) "VIOL" "lowerLeft" "R0" "stick" 0.0625 nil)
schCreateWire(cv "route" "full" '((1.000 28.938) (1.750 28.938)) 0 0 0 nil nil)
schCreateWireLabel(cv nil '(1.250 28.938) "GIOL" "lowerLeft" "R0" "stick" 0.0625 nil)
schCreateWire(cv "route" "full" '((1.000 28.750) (1.750 28.750)) 0 0 0 nil nil)
schCreateWireLabel(cv nil '(1.250 28.750) "VIOH" "lowerLeft" "R0" "stick" 0.0625 nil)
schCreateWire(cv "route" "full" '((1.000 28.375) (1.750 28.375)) 0 0 0 nil nil)
schCreateWireLabel(cv nil '(1.250 28.375) "GIOH" "lowerLeft" "R0" "stick" 0.0625 nil)
dbCreateInst(cv pddw16sdgz_h_gMaster "D5_left5" '(0 27.6875) "R270")
schCreateWire(cv "route" "full" '((1.000 27.562) (1.750 27.562)) 0 0 0 nil nil)
schCreateWireLabel(cv nil '(1.250 27.562) "VIOL" "lowerLeft" "R0" "stick" 0.0625 nil)
schCreateWire(cv "route" "full" '((1.000 27.438) (1.750 27.438)) 0 0 0 nil nil)
dbCreateInst(cv noConnMaster "noConn_D5_left5_C" '(1.750 27.438) "R90")
schCreateWire(cv "route" "full" '((1.000 27.812) (1.750 27.812)) 0 0 0 nil nil)
schCreateWireLabel(cv nil '(1.250 27.812) "GIOL" "lowerLeft" "R0" "stick" 0.0625 nil)
schCreateWire(cv "route" "full" '((1.000 27.938) (1.750 27.938)) 0 0 0 nil nil)
schCreateWireLabel(cv nil '(1.250 27.938) "D5_CORE" "lowerLeft" "R0" "stick" 0.0625 nil)
schCreatePin(cv nil "D5_CORE" "inputOutput" nil '(1.750 27.938) "R180")
schCreateWire(cv "route" "full" '((0.000 27.000) (-0.750 27.000)) 0 0 0 nil nil)
schCreateWireLabel(cv nil '(-0.250 27.000) "D5" "lowerRight" "R0" "stick" 0.0625 nil)
schCreatePin(cv nil "D5" "inputOutput" nil '(-0.750 27.000) "R0")
schCreateWire(cv "route" "full" '((1.000 27.312) (1.750 27.312)) 0 0 0 nil nil)
schCreateWireLabel(cv nil '(1.250 27.312) "POC" "lowerLeft" "R0" "stick" 0.0625 nil)
schCreateWire(cv "route" "full" '((1.000 27.125) (1.750 27.125)) 0 0 0 nil nil)
schCreateWireLabel(cv nil '(1.250 27.125) "VIOL" "lowerLeft" "R0" "stick" 0.0625 nil)
schCreateWire(cv "route" "full" '((1.000 26.938) (1.750 26.938)) 0 0 0 nil nil)
schCreateWireLabel(cv nil '(1.250 26.938) "GIOL" "lowerLeft" "R0" "stick" 0.0625 nil)
schCreateWire(cv "route" "full" '((1.000 26.750) (1.750 26.750)) 0 0 0 nil nil)
schCreateWireLabel(cv nil '(1.250 26.750) "VIOH" "lowerLeft" "R0" "stick" 0.0625 nil)
schCreateWire(cv "route" "full" '((1.000 26.375) (1.750 26.375)) 0 0 0 nil nil)
schCreateWireLabel(cv nil '(1.250 26.375) "GIOH" "lowerLeft" "R0" "stick" 0.0625 nil)
dbCreateInst(cv pddw16sdgz_h_gMaster "D6_left6" '(0 25.6875) "R270")
schCreateWire(cv "route" "full" '((1.000 25.562) (1.750 25.562)) 0 0 0 nil nil)
schCreateWireLabel(cv nil '(1.250 25.562) "VIOL" "lowerLeft" "R0" "stick" 0.0625 nil)
schCreateWire(cv "route" "full" '((1.000 25.438) (1.750 25.438)) 0 0 0 nil nil)
dbCreateInst(cv noConnMaster "noConn_D6_left6_C" '(1.750 25.438) "R90")
schCreateWire(cv "route" "full" '((1.000 25.812) (1.750 25.812)) 0 0 0 nil nil)
schCreateWireLabel(cv nil '(1.250 25.812) "GIOL" "lowerLeft" "R0" "stick" 0.0625 nil)
schCreateWire(cv "route" "full" '((1.000 25.938) (1.750 25.938)) 0 0 0 nil nil)
schCreateWireLabel(cv nil '(1.250 25.938) "D6_CORE" "lowerLeft" "R0" "stick" 0.0625 nil)
schCreatePin(cv nil "D6_CORE" "inputOutput" nil '(1.750 25.938) "R180")
schCreateWire(cv "route" "full" '((0.000 25.000) (-0.750 25.000)) 0 0 0 nil nil)
schCreateWireLabel(cv nil '(-0.250 25.000) "D6" "lowerRight" "R0" "stick" 0.0625 nil)
schCreatePin(cv nil "D6" "inputOutput" nil '(-0.750 25.000) "R0")
schCreateWire(cv "route" "full" '((1.000 25.312) (1.750 25.312)) 0 0 0 nil nil)
schCreateWireLabel(cv nil '(1.250 25.312) "POC" "lowerLeft" "R0" "stick" 0.0625 nil)
schCreateWire(cv "route" "full" '((1.000 25.125) (1.750 25.125)) 0 0 0 nil nil)
schCreateWireLabel(cv nil '(1.250 25.125) "VIOL" "lowerLeft" "R0" "stick" 0.0625 nil)
schCreateWire(cv "route" "full" '((1.000 24.938) (1.750 24.938)) 0 0 0 nil nil)
schCreateWireLabel(cv nil '(1.250 24.938) "GIOL" "lowerLeft" "R0" "stick" 0.0625 nil)
schCreateWire(cv "route" "full" '((1.000 24.750) (1.750 24.750)) 0 0 0 nil nil)
schCreateWireLabel(cv nil '(1.250 24.750) "VIOH" "lowerLeft" "R0" "stick" 0.0625 nil)
schCreateWire(cv "route" "full" '((1.000 24.375) (1.750 24.375)) 0 0 0 nil nil)
schCreateWireLabel(cv nil '(1.250 24.375) "GIOH" "lowerLeft" "R0" "stick" 0.0625 nil)
dbCreateInst(cv pddw16sdgz_h_gMaster "D7_left7" '(0 23.6875) "R270")
schCreateWire(cv "route" "full" '((1.000 23.562) (1.750 23.562)) 0 0 0 nil nil)
schCreateWireLabel(cv nil '(1.250 23.562) "VIOL" "lowerLeft" "R0" "stick" 0.0625 nil)
schCreateWire(cv "route" "full" '((1.000 23.438) (1.750 23.438)) 0 0 0 nil nil)
dbCreateInst(cv noConnMaster "noConn_D7_left7_C" '(1.750 23.438) "R90")
schCreateWire(cv "route" "full" '((1.000 23.812) (1.750 23.812)) 0 0 0 nil nil)
schCreateWireLabel(cv nil '(1.250 23.812) "GIOL" "lowerLeft" "R0" "stick" 0.0625 nil)
schCreateWire(cv "route" "full" '((1.000 23.938) (1.750 23.938)) 0 0 0 nil nil)
schCreateWireLabel(cv nil '(1.250 23.938) "D7_CORE" "lowerLeft" "R0" "stick" 0.0625 nil)
schCreatePin(cv nil "D7_CORE" "inputOutput" nil '(1.750 23.938) "R180")
schCreateWire(cv "route" "full" '((0.000 23.000) (-0.750 23.000)) 0 0 0 nil nil)
schCreateWireLabel(cv nil '(-0.250 23.000) "D7" "lowerRight" "R0" "stick" 0.0625 nil)
schCreatePin(cv nil "D7" "inputOutput" nil '(-0.750 23.000) "R0")
schCreateWire(cv "route" "full" '((1.000 23.312) (1.750 23.312)) 0 0 0 nil nil)
schCreateWireLabel(cv nil '(1.250 23.312) "POC" "lowerLeft" "R0" "stick" 0.0625 nil)
schCreateWire(cv "route" "full" '((1.000 23.125) (1.750 23.125)) 0 0 0 nil nil)
schCreateWireLabel(cv nil '(1.250 23.125) "VIOL" "lowerLeft" "R0" "stick" 0.0625 nil)
schCreateWire(cv "route" "full" '((1.000 22.938) (1.750 22.938)) 0 0 0 nil nil)
schCreateWireLabel(cv nil '(1.250 22.938) "GIOL" "lowerLeft" "R0" "stick" 0.0625 nil)
schCreateWire(cv "route" "full" '((1.000 22.750) (1.750 22.750)) 0 0 0 nil nil)
schCreateWireLabel(cv nil '(1.250 22.750) "VIOH" "lowerLeft" "R0" "stick" 0.0625 nil)
schCreateWire(cv "route" "full" '((1.000 22.375) (1.750 22.375)) 0 0 0 nil nil)
schCreateWireLabel(cv nil '(1.250 22.375) "GIOH" "lowerLeft" "R0" "stick" 0.0625 nil)
dbCreateInst(cv pddw16sdgz_h_gMaster "D8_left8" '(0 21.6875) "R270")
schCreateWire(cv "route" "full" '((1.000 21.562) (1.750 21.562)) 0 0 0 nil nil)
schCreateWireLabel(cv nil '(1.250 21.562) "VIOL" "lowerLeft" "R0" "stick" 0.0625 nil)
schCreateWire(cv "route" "full" '((1.000 21.438) (1.750 21.438)) 0 0 0 nil nil)
dbCreateInst(cv noConnMaster "noConn_D8_left8_C" '(1.750 21.438) "R90")
schCreateWire(cv "route" "full" '((1.000 21.812) (1.750 21.812)) 0 0 0 nil nil)
schCreateWireLabel(cv nil '(1.250 21.812) "GIOL" "lowerLeft" "R0" "stick" 0.0625 nil)
schCreateWire(cv "route" "full" '((1.000 21.938) (1.750 21.938)) 0 0 0 nil nil)
schCreateWireLabel(cv nil '(1.250 21.938) "D8_CORE" "lowerLeft" "R0" "stick" 0.0625 nil)
schCreatePin(cv nil "D8_CORE" "inputOutput" nil '(1.750 21.938) "R180")
schCreateWire(cv "route" "full" '((0.000 21.000) (-0.750 21.000)) 0 0 0 nil nil)
schCreateWireLabel(cv nil '(-0.250 21.000) "D8" "lowerRight" "R0" "stick" 0.0625 nil)
schCreatePin(cv nil "D8" "inputOutput" nil '(-0.750 21.000) "R0")
schCreateWire(cv "route" "full" '((1.000 21.312) (1.750 21.312)) 0 0 0 nil nil)
schCreateWireLabel(cv nil '(1.250 21.312) "POC" "lowerLeft" "R0" "stick" 0.0625 nil)
schCreateWire(cv "route" "full" '((1.000 21.125) (1.750 21.125)) 0 0 0 nil nil)
schCreateWireLabel(cv nil '(1.250 21.125) "VIOL" "lowerLeft" "R0" "stick" 0.0625 nil)
schCreateWire(cv "route" "full" '((1.000 20.938) (1.750 20.938)) 0 0 0 nil nil)
schCreateWireLabel(cv nil '(1.250 20.938) "GIOL" "lowerLeft" "R0" "stick" 0.0625 nil)
schCreateWire(cv "route" "full" '((1.000 20.750) (1.750 20.750)) 0 0 0 nil nil)
schCreateWireLabel(cv nil '(1.250 20.750) "VIOH" "lowerLeft" "R0" "stick" 0.0625 nil)
schCreateWire(cv "route" "full" '((1.000 20.375) (1.750 20.375)) 0 0 0 nil nil)
schCreateWireLabel(cv nil '(1.250 20.375) "GIOH" "lowerLeft" "R0" "stick" 0.0625 nil)
dbCreateInst(cv pddw16sdgz_h_gMaster "D9_left9" '(0 19.6875) "R270")
schCreateWire(cv "route" "full" '((1.000 19.562) (1.750 19.562)) 0 0 0 nil nil)
schCreateWireLabel(cv nil '(1.250 19.562) "VIOL" "lowerLeft" "R0" "stick" 0.0625 nil)
schCreateWire(cv "route" "full" '((1.000 19.438) (1.750 19.438)) 0 0 0 nil nil)
dbCreateInst(cv noConnMaster "noConn_D9_left9_C" '(1.750 19.438) "R90")
schCreateWire(cv "route" "full" '((1.000 19.812) (1.750 19.812)) 0 0 0 nil nil)
schCreateWireLabel(cv nil '(1.250 19.812) "GIOL" "lowerLeft" "R0" "stick" 0.0625 nil)
schCreateWire(cv "route" "full" '((1.000 19.938) (1.750 19.938)) 0 0 0 nil nil)
schCreateWireLabel(cv nil '(1.250 19.938) "D9_CORE" "lowerLeft" "R0" "stick" 0.0625 nil)
schCreatePin(cv nil "D9_CORE" "inputOutput" nil '(1.750 19.938) "R180")
schCreateWire(cv "route" "full" '((0.000 19.000) (-0.750 19.000)) 0 0 0 nil nil)
schCreateWireLabel(cv nil '(-0.250 19.000) "D9" "lowerRight" "R0" "stick" 0.0625 nil)
schCreatePin(cv nil "D9" "inputOutput" nil '(-0.750 19.000) "R0")
schCreateWire(cv "route" "full" '((1.000 19.312) (1.750 19.312)) 0 0 0 nil nil)
schCreateWireLabel(cv nil '(1.250 19.312) "POC" "lowerLeft" "R0" "stick" 0.0625 nil)
schCreateWire(cv "route" "full" '((1.000 19.125) (1.750 19.125)) 0 0 0 nil nil)
schCreateWireLabel(cv nil '(1.250 19.125) "VIOL" "lowerLeft" "R0" "stick" 0.0625 nil)
schCreateWire(cv "route" "full" '((1.000 18.938) (1.750 18.938)) 0 0 0 nil nil)
schCreateWireLabel(cv nil '(1.250 18.938) "GIOL" "lowerLeft" "R0" "stick" 0.0625 nil)
schCreateWire(cv "route" "full" '((1.000 18.750) (1.750 18.750)) 0 0 0 nil nil)
schCreateWireLabel(cv nil '(1.250 18.750) "VIOH" "lowerLeft" "R0" "stick" 0.0625 nil)
schCreateWire(cv "route" "full" '((1.000 18.375) (1.750 18.375)) 0 0 0 nil nil)
schCreateWireLabel(cv nil '(1.250 18.375) "GIOH" "lowerLeft" "R0" "stick" 0.0625 nil)
dbCreateInst(cv pddw16sdgz_h_gMaster "D10_left10" '(0 17.6875) "R270")
schCreateWire(cv "route" "full" '((1.000 17.562) (1.750 17.562)) 0 0 0 nil nil)
schCreateWireLabel(cv nil '(1.250 17.562) "VIOL" "lowerLeft" "R0" "stick" 0.0625 nil)
schCreateWire(cv "route" "full" '((1.000 17.438) (1.750 17.438)) 0 0 0 nil nil)
dbCreateInst(cv noConnMaster "noConn_D10_left10_C" '(1.750 17.438) "R90")
schCreateWire(cv "route" "full" '((1.000 17.812) (1.750 17.812)) 0 0 0 nil nil)
schCreateWireLabel(cv nil '(1.250 17.812) "GIOL" "lowerLeft" "R0" "stick" 0.0625 nil)
schCreateWire(cv "route" "full" '((1.000 17.938) (1.750 17.938)) 0 0 0 nil nil)
schCreateWireLabel(cv nil '(1.250 17.938) "D10_CORE" "lowerLeft" "R0" "stick" 0.0625 nil)
schCreatePin(cv nil "D10_CORE" "inputOutput" nil '(1.750 17.938) "R180")
schCreateWire(cv "route" "full" '((0.000 17.000) (-0.750 17.000)) 0 0 0 nil nil)
schCreateWireLabel(cv nil '(-0.250 17.000) "D10" "lowerRight" "R0" "stick" 0.0625 nil)
schCreatePin(cv nil "D10" "inputOutput" nil '(-0.750 17.000) "R0")
schCreateWire(cv "route" "full" '((1.000 17.312) (1.750 17.312)) 0 0 0 nil nil)
schCreateWireLabel(cv nil '(1.250 17.312) "POC" "lowerLeft" "R0" "stick" 0.0625 nil)
schCreateWire(cv "route" "full" '((1.000 17.125) (1.750 17.125)) 0 0 0 nil nil)
schCreateWireLabel(cv nil '(1.250 17.125) "VIOL" "lowerLeft" "R0" "stick" 0.0625 nil)
schCreateWire(cv "route" "full" '((1.000 16.938) (1.750 16.938)) 0 0 0 nil nil)
schCreateWireLabel(cv nil '(1.250 16.938) "GIOL" "lowerLeft" "R0" "stick" 0.0625 nil)
schCreateWire(cv "route" "full" '((1.000 16.750) (1.750 16.750)) 0 0 0 nil nil)
schCreateWireLabel(cv nil '(1.250 16.750) "VIOH" "lowerLeft" "R0" "stick" 0.0625 nil)
schCreateWire(cv "route" "full" '((1.000 16.375) (1.750 16.375)) 0 0 0 nil nil)
schCreateWireLabel(cv nil '(1.250 16.375) "GIOH" "lowerLeft" "R0" "stick" 0.0625 nil)
dbCreateInst(cv pddw16sdgz_h_gMaster "D11_left11" '(0 15.6875) "R270")
schCreateWire(cv "route" "full" '((1.000 15.562) (1.750 15.562)) 0 0 0 nil nil)
schCreateWireLabel(cv nil '(1.250 15.562) "VIOL" "lowerLeft" "R0" "stick" 0.0625 nil)
schCreateWire(cv "route" "full" '((1.000 15.438) (1.750 15.438)) 0 0 0 nil nil)
dbCreateInst(cv noConnMaster "noConn_D11_left11_C" '(1.750 15.438) "R90")
schCreateWire(cv "route" "full" '((1.000 15.812) (1.750 15.812)) 0 0 0 nil nil)
schCreateWireLabel(cv nil '(1.250 15.812) "GIOL" "lowerLeft" "R0" "stick" 0.0625 nil)
schCreateWire(cv "route" "full" '((1.000 15.938) (1.750 15.938)) 0 0 0 nil nil)
schCreateWireLabel(cv nil '(1.250 15.938) "D11_CORE" "lowerLeft" "R0" "stick" 0.0625 nil)
schCreatePin(cv nil "D11_CORE" "inputOutput" nil '(1.750 15.938) "R180")
schCreateWire(cv "route" "full" '((0.000 14.999) (-0.750 14.999)) 0 0 0 nil nil)
schCreateWireLabel(cv nil '(-0.250 14.999) "D11" "lowerRight" "R0" "stick" 0.0625 nil)
schCreatePin(cv nil "D11" "inputOutput" nil '(-0.750 14.999) "R0")
schCreateWire(cv "route" "full" '((1.000 15.312) (1.750 15.312)) 0 0 0 nil nil)
schCreateWireLabel(cv nil '(1.250 15.312) "POC" "lowerLeft" "R0" "stick" 0.0625 nil)
schCreateWire(cv "route" "full" '((1.000 15.126) (1.750 15.126)) 0 0 0 nil nil)
schCreateWireLabel(cv nil '(1.250 15.126) "VIOL" "lowerLeft" "R0" "stick" 0.0625 nil)
schCreateWire(cv "route" "full" '((1.000 14.938) (1.750 14.938)) 0 0 0 nil nil)
schCreateWireLabel(cv nil '(1.250 14.938) "GIOL" "lowerLeft" "R0" "stick" 0.0625 nil)
schCreateWire(cv "route" "full" '((1.000 14.749) (1.750 14.749)) 0 0 0 nil nil)
schCreateWireLabel(cv nil '(1.250 14.749) "VIOH" "lowerLeft" "R0" "stick" 0.0625 nil)
schCreateWire(cv "route" "full" '((1.000 14.376) (1.750 14.376)) 0 0 0 nil nil)
schCreateWireLabel(cv nil '(1.250 14.376) "GIOH" "lowerLeft" "R0" "stick" 0.0625 nil)
dbCreateInst(cv pddw16sdgz_h_gMaster "D12_left12" '(0 13.6875) "R270")
schCreateWire(cv "route" "full" '((1.000 13.562) (1.750 13.562)) 0 0 0 nil nil)
schCreateWireLabel(cv nil '(1.250 13.562) "VIOL" "lowerLeft" "R0" "stick" 0.0625 nil)
schCreateWire(cv "route" "full" '((1.000 13.438) (1.750 13.438)) 0 0 0 nil nil)
dbCreateInst(cv noConnMaster "noConn_D12_left12_C" '(1.750 13.438) "R90")
schCreateWire(cv "route" "full" '((1.000 13.812) (1.750 13.812)) 0 0 0 nil nil)
schCreateWireLabel(cv nil '(1.250 13.812) "GIOL" "lowerLeft" "R0" "stick" 0.0625 nil)
schCreateWire(cv "route" "full" '((1.000 13.938) (1.750 13.938)) 0 0 0 nil nil)
schCreateWireLabel(cv nil '(1.250 13.938) "D12_CORE" "lowerLeft" "R0" "stick" 0.0625 nil)
schCreatePin(cv nil "D12_CORE" "inputOutput" nil '(1.750 13.938) "R180")
schCreateWire(cv "route" "full" '((0.000 12.999) (-0.750 12.999)) 0 0 0 nil nil)
schCreateWireLabel(cv nil '(-0.250 12.999) "D12" "lowerRight" "R0" "stick" 0.0625 nil)
schCreatePin(cv nil "D12" "inputOutput" nil '(-0.750 12.999) "R0")
schCreateWire(cv "route" "full" '((1.000 13.312) (1.750 13.312)) 0 0 0 nil nil)
schCreateWireLabel(cv nil '(1.250 13.312) "POC" "lowerLeft" "R0" "stick" 0.0625 nil)
schCreateWire(cv "route" "full" '((1.000 13.126) (1.750 13.126)) 0 0 0 nil nil)
schCreateWireLabel(cv nil '(1.250 13.126) "VIOL" "lowerLeft" "R0" "stick" 0.0625 nil)
schCreateWire(cv "route" "full" '((1.000 12.938) (1.750 12.938)) 0 0 0 nil nil)
schCreateWireLabel(cv nil '(1.250 12.938) "GIOL" "lowerLeft" "R0" "stick" 0.0625 nil)
schCreateWire(cv "route" "full" '((1.000 12.749) (1.750 12.749)) 0 0 0 nil nil)
schCreateWireLabel(cv nil '(1.250 12.749) "VIOH" "lowerLeft" "R0" "stick" 0.0625 nil)
schCreateWire(cv "route" "full" '((1.000 12.376) (1.750 12.376)) 0 0 0 nil nil)
schCreateWireLabel(cv nil '(1.250 12.376) "GIOH" "lowerLeft" "R0" "stick" 0.0625 nil)
dbCreateInst(cv pddw16sdgz_h_gMaster "D13_left13" '(0 11.6875) "R270")
schCreateWire(cv "route" "full" '((1.000 11.562) (1.750 11.562)) 0 0 0 nil nil)
schCreateWireLabel(cv nil '(1.250 11.562) "VIOL" "lowerLeft" "R0" "stick" 0.0625 nil)
schCreateWire(cv "route" "full" '((1.000 11.438) (1.750 11.438)) 0 0 0 nil nil)
dbCreateInst(cv noConnMaster "noConn_D13_left13_C" '(1.750 11.438) "R90")
schCreateWire(cv "route" "full" '((1.000 11.812) (1.750 11.812)) 0 0 0 nil nil)
schCreateWireLabel(cv nil '(1.250 11.812) "GIOL" "lowerLeft" "R0" "stick" 0.0625 nil)
schCreateWire(cv "route" "full" '((1.000 11.938) (1.750 11.938)) 0 0 0 nil nil)
schCreateWireLabel(cv nil '(1.250 11.938) "D13_CORE" "lowerLeft" "R0" "stick" 0.0625 nil)
schCreatePin(cv nil "D13_CORE" "inputOutput" nil '(1.750 11.938) "R180")
schCreateWire(cv "route" "full" '((0.000 10.999) (-0.750 10.999)) 0 0 0 nil nil)
schCreateWireLabel(cv nil '(-0.250 10.999) "D13" "lowerRight" "R0" "stick" 0.0625 nil)
schCreatePin(cv nil "D13" "inputOutput" nil '(-0.750 10.999) "R0")
schCreateWire(cv "route" "full" '((1.000 11.312) (1.750 11.312)) 0 0 0 nil nil)
schCreateWireLabel(cv nil '(1.250 11.312) "POC" "lowerLeft" "R0" "stick" 0.0625 nil)
schCreateWire(cv "route" "full" '((1.000 11.126) (1.750 11.126)) 0 0 0 nil nil)
schCreateWireLabel(cv nil '(1.250 11.126) "VIOL" "lowerLeft" "R0" "stick" 0.0625 nil)
schCreateWire(cv "route" "full" '((1.000 10.938) (1.750 10.938)) 0 0 0 nil nil)
schCreateWireLabel(cv nil '(1.250 10.938) "GIOL" "lowerLeft" "R0" "stick" 0.0625 nil)
schCreateWire(cv "route" "full" '((1.000 10.749) (1.750 10.749)) 0 0 0 nil nil)
schCreateWireLabel(cv nil '(1.250 10.749) "VIOH" "lowerLeft" "R0" "stick" 0.0625 nil)
schCreateWire(cv "route" "full" '((1.000 10.376) (1.750 10.376)) 0 0 0 nil nil)
schCreateWireLabel(cv nil '(1.250 10.376) "GIOH" "lowerLeft" "R0" "stick" 0.0625 nil)
dbCreateInst(cv pddw16sdgz_h_gMaster "D14_left14" '(0 9.6875) "R270")
schCreateWire(cv "route" "full" '((1.000 9.562) (1.750 9.562)) 0 0 0 nil nil)
schCreateWireLabel(cv nil '(1.250 9.562) "VIOL" "lowerLeft" "R0" "stick" 0.0625 nil)
schCreateWire(cv "route" "full" '((1.000 9.438) (1.750 9.438)) 0 0 0 nil nil)
dbCreateInst(cv noConnMaster "noConn_D14_left14_C" '(1.750 9.438) "R90")
schCreateWire(cv "route" "full" '((1.000 9.812) (1.750 9.812)) 0 0 0 nil nil)
schCreateWireLabel(cv nil '(1.250 9.812) "GIOL" "lowerLeft" "R0" "stick" 0.0625 nil)
schCreateWire(cv "route" "full" '((1.000 9.938) (1.750 9.938)) 0 0 0 nil nil)
schCreateWireLabel(cv nil '(1.250 9.938) "D14_CORE" "lowerLeft" "R0" "stick" 0.0625 nil)
schCreatePin(cv nil "D14_CORE" "inputOutput" nil '(1.750 9.938) "R180")
schCreateWire(cv "route" "full" '((0.000 8.999) (-0.750 8.999)) 0 0 0 nil nil)
schCreateWireLabel(cv nil '(-0.250 8.999) "D14" "lowerRight" "R0" "stick" 0.0625 nil)
schCreatePin(cv nil "D14" "inputOutput" nil '(-0.750 8.999) "R0")
schCreateWire(cv "route" "full" '((1.000 9.312) (1.750 9.312)) 0 0 0 nil nil)
schCreateWireLabel(cv nil '(1.250 9.312) "POC" "lowerLeft" "R0" "stick" 0.0625 nil)
schCreateWire(cv "route" "full" '((1.000 9.126) (1.750 9.126)) 0 0 0 nil nil)
schCreateWireLabel(cv nil '(1.250 9.126) "VIOL" "lowerLeft" "R0" "stick" 0.0625 nil)
schCreateWire(cv "route" "full" '((1.000 8.938) (1.750 8.938)) 0 0 0 nil nil)
schCreateWireLabel(cv nil '(1.250 8.938) "GIOL" "lowerLeft" "R0" "stick" 0.0625 nil)
schCreateWire(cv "route" "full" '((1.000 8.749) (1.750 8.749)) 0 0 0 nil nil)
schCreateWireLabel(cv nil '(1.250 8.749) "VIOH" "lowerLeft" "R0" "stick" 0.0625 nil)
schCreateWire(cv "route" "full" '((1.000 8.376) (1.750 8.376)) 0 0 0 nil nil)
schCreateWireLabel(cv nil '(1.250 8.376) "GIOH" "lowerLeft" "R0" "stick" 0.0625 nil)
dbCreateInst(cv pddw16sdgz_h_gMaster "D15_left15" '(0 7.6875) "R270")
schCreateWire(cv "route" "full" '((1.000 7.562) (1.750 7.562)) 0 0 0 nil nil)
schCreateWireLabel(cv nil '(1.250 7.562) "VIOL" "lowerLeft" "R0" "stick" 0.0625 nil)
schCreateWire(cv "route" "full" '((1.000 7.438) (1.750 7.438)) 0 0 0 nil nil)
dbCreateInst(cv noConnMaster "noConn_D15_left15_C" '(1.750 7.438) "R90")
schCreateWire(cv "route" "full" '((1.000 7.812) (1.750 7.812)) 0 0 0 nil nil)
schCreateWireLabel(cv nil '(1.250 7.812) "GIOL" "lowerLeft" "R0" "stick" 0.0625 nil)
schCreateWire(cv "route" "full" '((1.000 7.938) (1.750 7.938)) 0 0 0 nil nil)
schCreateWireLabel(cv nil '(1.250 7.938) "D15_CORE" "lowerLeft" "R0" "stick" 0.0625 nil)
schCreatePin(cv nil "D15_CORE" "inputOutput" nil '(1.750 7.938) "R180")
schCreateWire(cv "route" "full" '((0.000 7.000) (-0.750 7.000)) 0 0 0 nil nil)
schCreateWireLabel(cv nil '(-0.250 7.000) "D15" "lowerRight" "R0" "stick" 0.0625 nil)
schCreatePin(cv nil "D15" "inputOutput" nil '(-0.750 7.000) "R0")
schCreateWire(cv "route" "full" '((1.000 7.312) (1.750 7.312)) 0 0 0 nil nil)
schCreateWireLabel(cv nil '(1.250 7.312) "POC" "lowerLeft" "R0" "stick" 0.0625 nil)
schCreateWire(cv "route" "full" '((1.000 7.125) (1.750 7.125)) 0 0 0 nil nil)
schCreateWireLabel(cv nil '(1.250 7.125) "VIOL" "lowerLeft" "R0" "stick" 0.0625 nil)
schCreateWire(cv "route" "full" '((1.000 6.938) (1.750 6.938)) 0 0 0 nil nil)
schCreateWireLabel(cv nil '(1.250 6.938) "GIOL" "lowerLeft" "R0" "stick" 0.0625 nil)
schCreateWire(cv "route" "full" '((1.000 6.750) (1.750 6.750)) 0 0 0 nil nil)
schCreateWireLabel(cv nil '(1.250 6.750) "VIOH" "lowerLeft" "R0" "stick" 0.0625 nil)
schCreateWire(cv "route" "full" '((1.000 6.375) (1.750 6.375)) 0 0 0 nil nil)
schCreateWireLabel(cv nil '(1.250 6.375) "GIOH" "lowerLeft" "R0" "stick" 0.0625 nil)
dbCreateInst(cv pddw16sdgz_h_gMaster "CS_left16" '(0 5.6875) "R270")
schCreateWire(cv "route" "full" '((1.000 5.562) (1.750 5.562)) 0 0 0 nil nil)
schCreateWireLabel(cv nil '(1.250 5.562) "GIOL" "lowerLeft" "R0" "stick" 0.0625 nil)
schCreateWire(cv "route" "full" '((1.000 5.438) (1.750 5.438)) 0 0 0 nil nil)
schCreateWireLabel(cv nil '(1.250 5.438) "CS_CORE" "lowerLeft" "R0" "stick" 0.0625 nil)
schCreatePin(cv nil "CS_CORE" "inputOutput" nil '(1.750 5.438) "R180")
schCreateWire(cv "route" "full" '((1.000 5.812) (1.750 5.812)) 0 0 0 nil nil)
schCreateWireLabel(cv nil '(1.250 5.812) "VIOL" "lowerLeft" "R0" "stick" 0.0625 nil)
schCreateWire(cv "route" "full" '((1.000 5.938) (1.750 5.938)) 0 0 0 nil nil)
schCreateWireLabel(cv nil '(1.250 5.938) "GIOL" "lowerLeft" "R0" "stick" 0.0625 nil)
schCreateWire(cv "route" "full" '((0.000 5.000) (-0.750 5.000)) 0 0 0 nil nil)
schCreateWireLabel(cv nil '(-0.250 5.000) "CS" "lowerRight" "R0" "stick" 0.0625 nil)
schCreatePin(cv nil "CS" "inputOutput" nil '(-0.750 5.000) "R0")
schCreateWire(cv "route" "full" '((1.000 5.312) (1.750 5.312)) 0 0 0 nil nil)
schCreateWireLabel(cv nil '(1.250 5.312) "POC" "lowerLeft" "R0" "stick" 0.0625 nil)
schCreateWire(cv "route" "full" '((1.000 5.125) (1.750 5.125)) 0 0 0 nil nil)
schCreateWireLabel(cv nil '(1.250 5.125) "VIOL" "lowerLeft" "R0" "stick" 0.0625 nil)
schCreateWire(cv "route" "full" '((1.000 4.938) (1.750 4.938)) 0 0 0 nil nil)
schCreateWireLabel(cv nil '(1.250 4.938) "GIOL" "lowerLeft" "R0" "stick" 0.0625 nil)
schCreateWire(cv "route" "full" '((1.000 4.750) (1.750 4.750)) 0 0 0 nil nil)
schCreateWireLabel(cv nil '(1.250 4.750) "VIOH" "lowerLeft" "R0" "stick" 0.0625 nil)
schCreateWire(cv "route" "full" '((1.000 4.375) (1.750 4.375)) 0 0 0 nil nil)
schCreateWireLabel(cv nil '(1.250 4.375) "GIOH" "lowerLeft" "R0" "stick" 0.0625 nil)
dbCreateInst(cv pddw16sdgz_h_gMaster "EN_left17" '(0 3.6875) "R270")
schCreateWire(cv "route" "full" '((1.000 3.562) (1.750 3.562)) 0 0 0 nil nil)
schCreateWireLabel(cv nil '(1.250 3.562) "GIOL" "lowerLeft" "R0" "stick" 0.0625 nil)
schCreateWire(cv "route" "full" '((1.000 3.438) (1.750 3.438)) 0 0 0 nil nil)
schCreateWireLabel(cv nil '(1.250 3.438) "EN_CORE" "lowerLeft" "R0" "stick" 0.0625 nil)
schCreatePin(cv nil "EN_CORE" "inputOutput" nil '(1.750 3.438) "R180")
schCreateWire(cv "route" "full" '((1.000 3.812) (1.750 3.812)) 0 0 0 nil nil)
schCreateWireLabel(cv nil '(1.250 3.812) "VIOL" "lowerLeft" "R0" "stick" 0.0625 nil)
schCreateWire(cv "route" "full" '((1.000 3.938) (1.750 3.938)) 0 0 0 nil nil)
schCreateWireLabel(cv nil '(1.250 3.938) "GIOL" "lowerLeft" "R0" "stick" 0.0625 nil)
schCreateWire(cv "route" "full" '((0.000 3.000) (-0.750 3.000)) 0 0 0 nil nil)
schCreateWireLabel(cv nil '(-0.250 3.000) "EN" "lowerRight" "R0" "stick" 0.0625 nil)
schCreatePin(cv nil "EN" "inputOutput" nil '(-0.750 3.000) "R0")
schCreateWire(cv "route" "full" '((1.000 3.312) (1.750 3.312)) 0 0 0 nil nil)
schCreateWireLabel(cv nil '(1.250 3.312) "POC" "lowerLeft" "R0" "stick" 0.0625 nil)
schCreateWire(cv "route" "full" '((1.000 3.125) (1.750 3.125)) 0 0 0 nil nil)
schCreateWireLabel(cv nil '(1.250 3.125) "VIOL" "lowerLeft" "R0" "stick" 0.0625 nil)
schCreateWire(cv "route" "full" '((1.000 2.938) (1.750 2.938)) 0 0 0 nil nil)
schCreateWireLabel(cv nil '(1.250 2.938) "GIOL" "lowerLeft" "R0" "stick" 0.0625 nil)
schCreateWire(cv "route" "full" '((1.000 2.750) (1.750 2.750)) 0 0 0 nil nil)
schCreateWireLabel(cv nil '(1.250 2.750) "VIOH" "lowerLeft" "R0" "stick" 0.0625 nil)
schCreateWire(cv "route" "full" '((1.000 2.375) (1.750 2.375)) 0 0 0 nil nil)
schCreateWireLabel(cv nil '(1.250 2.375) "GIOH" "lowerLeft" "R0" "stick" 0.0625 nil)
pddw16sdgz_v_gMaster = dbOpenCellView("tphn28hpcpgv18" "PDDW16SDGZ_V_G" "symbol")
dbCreateInst(cv pddw16sdgz_v_gMaster "TEST_bottom0" '(2.3125 0) "R0")
schCreateWire(cv "route" "full" '((2.438 1.000) (2.438 1.750)) 0 0 0 nil nil)
schCreateWireLabel(cv nil '(2.438 1.250) "GIOL" "lowerLeft" "R90" "stick" 0.0625 nil)
schCreateWire(cv "route" "full" '((2.562 1.000) (2.562 1.750)) 0 0 0 nil nil)
schCreateWireLabel(cv nil '(2.562 1.250) "TEST_CORE" "lowerLeft" "R90" "stick" 0.0625 nil)
schCreatePin(cv nil "TEST_CORE" "inputOutput" nil '(2.562 1.750) "R270")
schCreateWire(cv "route" "full" '((2.188 1.000) (2.188 1.750)) 0 0 0 nil nil)
schCreateWireLabel(cv nil '(2.188 1.250) "VIOL" "lowerLeft" "R90" "stick" 0.0625 nil)
schCreateWire(cv "route" "full" '((2.062 1.000) (2.062 1.750)) 0 0 0 nil nil)
schCreateWireLabel(cv nil '(2.062 1.250) "GIOL" "lowerLeft" "R90" "stick" 0.0625 nil)
schCreateWire(cv "route" "full" '((3.000 0.000) (3.000 -0.750)) 0 0 0 nil nil)
schCreateWireLabel(cv nil '(3.000 -0.250) "TEST" "lowerRight" "R90" "stick" 0.0625 nil)
schCreatePin(cv nil "TEST" "inputOutput" nil '(3.000 -0.750) "R90")
schCreateWire(cv "route" "full" '((2.688 1.000) (2.688 1.750)) 0 0 0 nil nil)
schCreateWireLabel(cv nil '(2.688 1.250) "POC" "lowerLeft" "R90" "stick" 0.0625 nil)
schCreateWire(cv "route" "full" '((2.875 1.000) (2.875 1.750)) 0 0 0 nil nil)
schCreateWireLabel(cv nil '(2.875 1.250) "VIOL" "lowerLeft" "R90" "stick" 0.0625 nil)
schCreateWire(cv "route" "full" '((3.062 1.000) (3.062 1.750)) 0 0 0 nil nil)
schCreateWireLabel(cv nil '(3.062 1.250) "GIOL" "lowerLeft" "R90" "stick" 0.0625 nil)
schCreateWire(cv "route" "full" '((3.250 1.000) (3.250 1.750)) 0 0 0 nil nil)
schCreateWireLabel(cv nil '(3.250 1.250) "VIOH" "lowerLeft" "R90" "stick" 0.0625 nil)
schCreateWire(cv "route" "full" '((3.625 1.000) (3.625 1.750)) 0 0 0 nil nil)
schCreateWireLabel(cv nil '(3.625 1.250) "GIOH" "lowerLeft" "R90" "stick" 0.0625 nil)
pvdd2poc_v_gMaster = dbOpenCellView("tphn28hpcpgv18" "PVDD2POC_V_G" "symbol")
dbCreateInst(cv pvdd2poc_v_gMaster "VIOH_bottom1" '(4.0 0) "R0")
schCreateWire(cv "route" "full" '((4.375 1.000) (4.375 1.750)) 0 0 0 nil nil)
schCreateWireLabel(cv nil '(4.375 1.250) "POC" "lowerLeft" "R90" "stick" 0.0625 nil)
schCreateWire(cv "route" "full" '((4.562 1.000) (4.562 1.750)) 0 0 0 nil nil)
schCreateWireLabel(cv nil '(4.562 1.250) "VIOL" "lowerLeft" "R90" "stick" 0.0625 nil)
schCreateWire(cv "route" "full" '((4.750 1.000) (4.750 1.750)) 0 0 0 nil nil)
schCreateWireLabel(cv nil '(4.750 1.250) "GIOL" "lowerLeft" "R90" "stick" 0.0625 nil)
schCreateWire(cv "route" "full" '((5.000 0.000) (5.000 -0.750)) 0 0 0 nil nil)
schCreateWireLabel(cv nil '(5.000 -0.250) "VIOH" "lowerRight" "R90" "stick" 0.0625 nil)
schCreatePin(cv nil "VIOH" "inputOutput" nil '(5.000 -0.750) "R90")
schCreateWire(cv "route" "full" '((5.312 1.000) (5.312 1.750)) 0 0 0 nil nil)
schCreateWireLabel(cv nil '(5.312 1.250) "GIOH" "lowerLeft" "R90" "stick" 0.0625 nil)
pvss1dgz_v_gMaster = dbOpenCellView("tphn28hpcpgv18" "PVSS1DGZ_V_G" "symbol")
dbCreateInst(cv pvss1dgz_v_gMaster "GIOL_bottom2" '(6.0 0) "R0")
schCreateWire(cv "route" "full" '((6.375 1.000) (6.375 1.750)) 0 0 0 nil nil)
schCreateWireLabel(cv nil '(6.375 1.250) "POC" "lowerLeft" "R90" "stick" 0.0625 nil)
schCreateWire(cv "route" "full" '((6.562 1.000) (6.562 1.750)) 0 0 0 nil nil)
schCreateWireLabel(cv nil '(6.562 1.250) "VIOL" "lowerLeft" "R90" "stick" 0.0625 nil)
schCreateWire(cv "route" "full" '((7.000 0.000) (7.000 -0.750)) 0 0 0 nil nil)
schCreateWireLabel(cv nil '(7.000 -0.250) "GIOL" "lowerRight" "R90" "stick" 0.0625 nil)
schCreatePin(cv nil "GIOL" "inputOutput" nil '(7.000 -0.750) "R90")
schCreateWire(cv "route" "full" '((6.938 1.000) (6.938 1.750)) 0 0 0 nil nil)
schCreateWireLabel(cv nil '(6.938 1.250) "VIOH" "lowerLeft" "R90" "stick" 0.0625 nil)
schCreateWire(cv "route" "full" '((7.312 1.000) (7.312 1.750)) 0 0 0 nil nil)
schCreateWireLabel(cv nil '(7.312 1.250) "GIOH" "lowerLeft" "R90" "stick" 0.0625 nil)
pvss2dgz_v_gMaster = dbOpenCellView("tphn28hpcpgv18" "PVSS2DGZ_V_G" "symbol")
dbCreateInst(cv pvss2dgz_v_gMaster "GIOH_bottom3" '(8.0 0) "R0")
schCreateWire(cv "route" "full" '((8.375 1.000) (8.375 1.750)) 0 0 0 nil nil)
schCreateWireLabel(cv nil '(8.375 1.250) "POC" "lowerLeft" "R90" "stick" 0.0625 nil)
schCreateWire(cv "route" "full" '((8.562 1.000) (8.562 1.750)) 0 0 0 nil nil)
schCreateWireLabel(cv nil '(8.562 1.250) "VIOL" "lowerLeft" "R90" "stick" 0.0625 nil)
schCreateWire(cv "route" "full" '((8.750 1.000) (8.750 1.750)) 0 0 0 nil nil)
schCreateWireLabel(cv nil '(8.750 1.250) "GIOL" "lowerLeft" "R90" "stick" 0.0625 nil)
schCreateWire(cv "route" "full" '((8.938 1.000) (8.938 1.750)) 0 0 0 nil nil)
schCreateWireLabel(cv nil '(8.938 1.250) "VIOH" "lowerLeft" "R90" "stick" 0.0625 nil)
schCreateWire(cv "route" "full" '((9.000 0.000) (9.000 -0.750)) 0 0 0 nil nil)
schCreateWireLabel(cv nil '(9.000 -0.250) "GIOH" "lowerRight" "R90" "stick" 0.0625 nil)
schCreatePin(cv nil "GIOH" "inputOutput" nil '(9.000 -0.750) "R90")
pvdd1dgz_v_gMaster = dbOpenCellView("tphn28hpcpgv18" "PVDD1DGZ_V_G" "symbol")
dbCreateInst(cv pvdd1dgz_v_gMaster "VIOL_bottom4" '(10.0 0) "R0")
schCreateWire(cv "route" "full" '((10.375 1.000) (10.375 1.750)) 0 0 0 nil nil)
schCreateWireLabel(cv nil '(10.375 1.250) "POC" "lowerLeft" "R90" "stick" 0.0625 nil)
schCreateWire(cv "route" "full" '((11.000 0.000) (11.000 -0.750)) 0 0 0 nil nil)
schCreateWireLabel(cv nil '(11.000 -0.250) "VIOL" "lowerRight" "R90" "stick" 0.0625 nil)
schCreatePin(cv nil "VIOL" "inputOutput" nil '(11.000 -0.750) "R90")
schCreateWire(cv "route" "full" '((10.750 1.000) (10.750 1.750)) 0 0 0 nil nil)
schCreateWireLabel(cv nil '(10.750 1.250) "GIOL" "lowerLeft" "R90" "stick" 0.0625 nil)
schCreateWire(cv "route" "full" '((10.938 1.000) (10.938 1.750)) 0 0 0 nil nil)
schCreateWireLabel(cv nil '(10.938 1.250) "VIOH" "lowerLeft" "R90" "stick" 0.0625 nil)
schCreateWire(cv "route" "full" '((11.312 1.000) (11.312 1.750)) 0 0 0 nil nil)
schCreateWireLabel(cv nil '(11.312 1.250) "GIOH" "lowerLeft" "R90" "stick" 0.0625 nil)
pvss3ac_v_gMaster = dbOpenCellView("tphn28hpcpgv18" "PVSS3AC_V_G" "symbol")
dbCreateInst(cv pvss3ac_v_gMaster "VSSSAR_bottom5" '(13.1875 0) "R0")
schCreateWire(cv "route" "full" '((12.999 0.000) (12.999 -0.750)) 0 0 0 nil nil)
schCreateWireLabel(cv nil '(12.999 -0.250) "VSSSAR" "lowerRight" "R90" "stick" 0.0625 nil)
schCreatePin(cv nil "VSSSAR" "inputOutput" nil '(12.999 -0.750) "R90")
schCreateWire(cv "route" "full" '((13.312 0.875) (13.312 1.625)) 0 0 0 nil nil)
schCreateWireLabel(cv nil '(13.312 1.125) "GIOL" "lowerLeft" "R90" "stick" 0.0625 nil)
schCreateWire(cv "route" "full" '((12.562 0.875) (12.562 1.625)) 0 0 0 nil nil)
schCreateWireLabel(cv nil '(12.562 1.125) "VSSSAR_CORE" "lowerLeft" "R90" "stick" 0.0625 nil)
schCreatePin(cv nil "VSSSAR_CORE" "inputOutput" nil '(12.562 1.625) "R270")
schCreateWire(cv "route" "full" '((12.938 0.875) (12.938 1.625)) 0 0 0 nil nil)
schCreateWireLabel(cv nil '(12.938 1.125) "VDDSAR" "lowerLeft" "R90" "stick" 0.0625 nil)
pvdd3ac_v_gMaster = dbOpenCellView("tphn28hpcpgv18" "PVDD3AC_V_G" "symbol")
dbCreateInst(cv pvdd3ac_v_gMaster "VDDSAR_bottom6" '(15.1875 0) "R0")
schCreateWire(cv "route" "full" '((14.562 0.875) (14.562 1.625)) 0 0 0 nil nil)
schCreateWireLabel(cv nil '(14.562 1.125) "VDDSAR_CORE" "lowerLeft" "R90" "stick" 0.0625 nil)
schCreatePin(cv nil "VDDSAR_CORE" "inputOutput" nil '(14.562 1.625) "R270")
schCreateWire(cv "route" "full" '((14.938 0.875) (14.938 1.625)) 0 0 0 nil nil)
schCreateWireLabel(cv nil '(14.938 1.125) "VSSSAR" "lowerLeft" "R90" "stick" 0.0625 nil)
schCreateWire(cv "route" "full" '((15.312 0.875) (15.312 1.625)) 0 0 0 nil nil)
schCreateWireLabel(cv nil '(15.312 1.125) "GIOL" "lowerLeft" "R90" "stick" 0.0625 nil)
schCreateWire(cv "route" "full" '((14.999 0.000) (14.999 -0.750)) 0 0 0 nil nil)
schCreateWireLabel(cv nil '(14.999 -0.250) "VDDSAR" "lowerRight" "R90" "stick" 0.0625 nil)
schCreatePin(cv nil "VDDSAR" "inputOutput" nil '(14.999 -0.750) "R90")
pdb3ac_v_gMaster = dbOpenCellView("tphn28hpcpgv18" "PDB3AC_V_G" "symbol")
dbCreateInst(cv pdb3ac_v_gMaster "VIP_bottom7" '(17.1875 0) "R0")
schCreateWire(cv "route" "full" '((17.000 0.000) (17.000 -0.750)) 0 0 0 nil nil)
schCreateWireLabel(cv nil '(17.000 -0.250) "VIP" "lowerRight" "R90" "stick" 0.0625 nil)
schCreatePin(cv nil "VIP" "inputOutput" nil '(17.000 -0.750) "R90")
schCreateWire(cv "route" "full" '((16.938 0.875) (16.938 1.625)) 0 0 0 nil nil)
schCreateWireLabel(cv nil '(16.938 1.125) "VSSSAR" "lowerLeft" "R90" "stick" 0.0625 nil)
schCreateWire(cv "route" "full" '((17.312 0.875) (17.312 1.625)) 0 0 0 nil nil)
schCreateWireLabel(cv nil '(17.312 1.125) "GIOL" "lowerLeft" "R90" "stick" 0.0625 nil)
schCreateWire(cv "route" "full" '((16.562 0.875) (16.562 1.625)) 0 0 0 nil nil)
schCreateWireLabel(cv nil '(16.562 1.125) "VDDSAR" "lowerLeft" "R90" "stick" 0.0625 nil)
dbCreateInst(cv pdb3ac_v_gMaster "VIN_bottom8" '(19.1875 0) "R0")
schCreateWire(cv "route" "full" '((19.000 0.000) (19.000 -0.750)) 0 0 0 nil nil)
schCreateWireLabel(cv nil '(19.000 -0.250) "VIN" "lowerRight" "R90" "stick" 0.0625 nil)
schCreatePin(cv nil "VIN" "inputOutput" nil '(19.000 -0.750) "R90")
schCreateWire(cv "route" "full" '((18.938 0.875) (18.938 1.625)) 0 0 0 nil nil)
schCreateWireLabel(cv nil '(18.938 1.125) "VSSSAR" "lowerLeft" "R90" "stick" 0.0625 nil)
schCreateWire(cv "route" "full" '((19.312 0.875) (19.312 1.625)) 0 0 0 nil nil)
schCreateWireLabel(cv nil '(19.312 1.125) "GIOL" "lowerLeft" "R90" "stick" 0.0625 nil)
schCreateWire(cv "route" "full" '((18.562 0.875) (18.562 1.625)) 0 0 0 nil nil)
schCreateWireLabel(cv nil '(18.562 1.125) "VDDSAR" "lowerLeft" "R90" "stick" 0.0625 nil)
dbCreateInst(cv pdb3ac_v_gMaster "VCM_bottom9" '(21.1875 0) "R0")
schCreateWire(cv "route" "full" '((21.000 0.000) (21.000 -0.750)) 0 0 0 nil nil)
schCreateWireLabel(cv nil '(21.000 -0.250) "VCM" "lowerRight" "R90" "stick" 0.0625 nil)
schCreatePin(cv nil "VCM" "inputOutput" nil '(21.000 -0.750) "R90")
schCreateWire(cv "route" "full" '((20.938 0.875) (20.938 1.625)) 0 0 0 nil nil)
schCreateWireLabel(cv nil '(20.938 1.125) "VSSSAR" "lowerLeft" "R90" "stick" 0.0625 nil)
schCreateWire(cv "route" "full" '((21.312 0.875) (21.312 1.625)) 0 0 0 nil nil)
schCreateWireLabel(cv nil '(21.312 1.125) "GIOL" "lowerLeft" "R90" "stick" 0.0625 nil)
schCreateWire(cv "route" "full" '((20.562 0.875) (20.562 1.625)) 0 0 0 nil nil)
schCreateWireLabel(cv nil '(20.562 1.125) "VDDSAR" "lowerLeft" "R90" "stick" 0.0625 nil)
dbCreateInst(cv pdb3ac_v_gMaster "VINCM_bottom10" '(23.1875 0) "R0")
schCreateWire(cv "route" "full" '((23.000 0.000) (23.000 -0.750)) 0 0 0 nil nil)
schCreateWireLabel(cv nil '(23.000 -0.250) "VINCM" "lowerRight" "R90" "stick" 0.0625 nil)
schCreatePin(cv nil "VINCM" "inputOutput" nil '(23.000 -0.750) "R90")
schCreateWire(cv "route" "full" '((22.938 0.875) (22.938 1.625)) 0 0 0 nil nil)
schCreateWireLabel(cv nil '(22.938 1.125) "VSSSAR" "lowerLeft" "R90" "stick" 0.0625 nil)
schCreateWire(cv "route" "full" '((23.312 0.875) (23.312 1.625)) 0 0 0 nil nil)
schCreateWireLabel(cv nil '(23.312 1.125) "GIOL" "lowerLeft" "R90" "stick" 0.0625 nil)
schCreateWire(cv "route" "full" '((22.562 0.875) (22.562 1.625)) 0 0 0 nil nil)
schCreateWireLabel(cv nil '(22.562 1.125) "VDDSAR" "lowerLeft" "R90" "stick" 0.0625 nil)
dbCreateInst(cv pdb3ac_v_gMaster "IBIAS_bottom11" '(25.1875 0) "R0")
schCreateWire(cv "route" "full" '((25.000 0.000) (25.000 -0.750)) 0 0 0 nil nil)
schCreateWireLabel(cv nil '(25.000 -0.250) "IBIAS" "lowerRight" "R90" "stick" 0.0625 nil)
schCreatePin(cv nil "IBIAS" "inputOutput" nil '(25.000 -0.750) "R90")
schCreateWire(cv "route" "full" '((24.938 0.875) (24.938 1.625)) 0 0 0 nil nil)
schCreateWireLabel(cv nil '(24.938 1.125) "VSSSAR" "lowerLeft" "R90" "stick" 0.0625 nil)
schCreateWire(cv "route" "full" '((25.312 0.875) (25.312 1.625)) 0 0 0 nil nil)
schCreateWireLabel(cv nil '(25.312 1.125) "GIOL" "lowerLeft" "R90" "stick" 0.0625 nil)
schCreateWire(cv "route" "full" '((24.562 0.875) (24.562 1.625)) 0 0 0 nil nil)
schCreateWireLabel(cv nil '(24.562 1.125) "VDDSAR" "lowerLeft" "R90" "stick" 0.0625 nil)
pdb3ac_h_gMaster = dbOpenCellView("tphn28hpcpgv18" "PDB3AC_H_G" "symbol")
dbCreateInst(cv pdb3ac_h_gMaster "IBIAS2_right0" '(28.0 3.1875) "R90")
schCreateWire(cv "route" "full" '((28.000 2.999) (28.750 2.999)) 0 0 0 nil nil)
schCreateWireLabel(cv nil '(28.250 2.999) "IBIAS2" "lowerLeft" "R0" "stick" 0.0625 nil)
schCreatePin(cv nil "IBIAS2" "inputOutput" nil '(28.750 2.999) "R180")
schCreateWire(cv "route" "full" '((27.125 2.938) (26.375 2.938)) 0 0 0 nil nil)
schCreateWireLabel(cv nil '(26.875 2.938) "VSSSAR" "lowerRight" "R0" "stick" 0.0625 nil)
schCreateWire(cv "route" "full" '((27.125 3.312) (26.375 3.312)) 0 0 0 nil nil)
schCreateWireLabel(cv nil '(26.875 3.312) "GIOL" "lowerRight" "R0" "stick" 0.0625 nil)
schCreateWire(cv "route" "full" '((27.125 2.562) (26.375 2.562)) 0 0 0 nil nil)
schCreateWireLabel(cv nil '(26.875 2.562) "VDDSAR" "lowerRight" "R0" "stick" 0.0625 nil)
dbCreateInst(cv pdb3ac_h_gMaster "VREF_right1" '(28.0 5.1875) "R90")
schCreateWire(cv "route" "full" '((28.000 5.000) (28.750 5.000)) 0 0 0 nil nil)
schCreateWireLabel(cv nil '(28.250 5.000) "VREF" "lowerLeft" "R0" "stick" 0.0625 nil)
schCreatePin(cv nil "VREF" "inputOutput" nil '(28.750 5.000) "R180")
schCreateWire(cv "route" "full" '((27.125 4.938) (26.375 4.938)) 0 0 0 nil nil)
schCreateWireLabel(cv nil '(26.875 4.938) "VSSSAR" "lowerRight" "R0" "stick" 0.0625 nil)
schCreateWire(cv "route" "full" '((27.125 5.312) (26.375 5.312)) 0 0 0 nil nil)
schCreateWireLabel(cv nil '(26.875 5.312) "GIOL" "lowerRight" "R0" "stick" 0.0625 nil)
schCreateWire(cv "route" "full" '((27.125 4.562) (26.375 4.562)) 0 0 0 nil nil)
schCreateWireLabel(cv nil '(26.875 4.562) "VDDSAR" "lowerRight" "R0" "stick" 0.0625 nil)
dbCreateInst(cv pdb3ac_h_gMaster "VREF2_right2" '(28.0 7.1875) "R90")
schCreateWire(cv "route" "full" '((28.000 7.000) (28.750 7.000)) 0 0 0 nil nil)
schCreateWireLabel(cv nil '(28.250 7.000) "VREF2" "lowerLeft" "R0" "stick" 0.0625 nil)
schCreatePin(cv nil "VREF2" "inputOutput" nil '(28.750 7.000) "R180")
schCreateWire(cv "route" "full" '((27.125 6.938) (26.375 6.938)) 0 0 0 nil nil)
schCreateWireLabel(cv nil '(26.875 6.938) "VSSSAR" "lowerRight" "R0" "stick" 0.0625 nil)
schCreateWire(cv "route" "full" '((27.125 7.312) (26.375 7.312)) 0 0 0 nil nil)
schCreateWireLabel(cv nil '(26.875 7.312) "GIOL" "lowerRight" "R0" "stick" 0.0625 nil)
schCreateWire(cv "route" "full" '((27.125 6.562) (26.375 6.562)) 0 0 0 nil nil)
schCreateWireLabel(cv nil '(26.875 6.562) "VDDSAR" "lowerRight" "R0" "stick" 0.0625 nil)
dbCreateInst(cv pdb3ac_h_gMaster "IB0_right3" '(28.0 9.1875) "R90")
schCreateWire(cv "route" "full" '((28.000 8.999) (28.750 8.999)) 0 0 0 nil nil)
schCreateWireLabel(cv nil '(28.250 8.999) "IB0" "lowerLeft" "R0" "stick" 0.0625 nil)
schCreatePin(cv nil "IB0" "inputOutput" nil '(28.750 8.999) "R180")
schCreateWire(cv "route" "full" '((27.125 8.938) (26.375 8.938)) 0 0 0 nil nil)
schCreateWireLabel(cv nil '(26.875 8.938) "VSSSAR" "lowerRight" "R0" "stick" 0.0625 nil)
schCreateWire(cv "route" "full" '((27.125 9.312) (26.375 9.312)) 0 0 0 nil nil)
schCreateWireLabel(cv nil '(26.875 9.312) "GIOL" "lowerRight" "R0" "stick" 0.0625 nil)
schCreateWire(cv "route" "full" '((27.125 8.562) (26.375 8.562)) 0 0 0 nil nil)
schCreateWireLabel(cv nil '(26.875 8.562) "VDDSAR" "lowerRight" "R0" "stick" 0.0625 nil)
dbCreateInst(cv pdb3ac_h_gMaster "IB1_right4" '(28.0 11.1875) "R90")
schCreateWire(cv "route" "full" '((28.000 10.999) (28.750 10.999)) 0 0 0 nil nil)
schCreateWireLabel(cv nil '(28.250 10.999) "IB1" "lowerLeft" "R0" "stick" 0.0625 nil)
schCreatePin(cv nil "IB1" "inputOutput" nil '(28.750 10.999) "R180")
schCreateWire(cv "route" "full" '((27.125 10.938) (26.375 10.938)) 0 0 0 nil nil)
schCreateWireLabel(cv nil '(26.875 10.938) "VSSSAR" "lowerRight" "R0" "stick" 0.0625 nil)
schCreateWire(cv "route" "full" '((27.125 11.312) (26.375 11.312)) 0 0 0 nil nil)
schCreateWireLabel(cv nil '(26.875 11.312) "GIOL" "lowerRight" "R0" "stick" 0.0625 nil)
schCreateWire(cv "route" "full" '((27.125 10.562) (26.375 10.562)) 0 0 0 nil nil)
schCreateWireLabel(cv nil '(26.875 10.562) "VDDSAR" "lowerRight" "R0" "stick" 0.0625 nil)
dbCreateInst(cv pdb3ac_h_gMaster "IB2_right5" '(28.0 13.1875) "R90")
schCreateWire(cv "route" "full" '((28.000 12.999) (28.750 12.999)) 0 0 0 nil nil)
schCreateWireLabel(cv nil '(28.250 12.999) "IB2" "lowerLeft" "R0" "stick" 0.0625 nil)
schCreatePin(cv nil "IB2" "inputOutput" nil '(28.750 12.999) "R180")
schCreateWire(cv "route" "full" '((27.125 12.938) (26.375 12.938)) 0 0 0 nil nil)
schCreateWireLabel(cv nil '(26.875 12.938) "VSSSAR" "lowerRight" "R0" "stick" 0.0625 nil)
schCreateWire(cv "route" "full" '((27.125 13.312) (26.375 13.312)) 0 0 0 nil nil)
schCreateWireLabel(cv nil '(26.875 13.312) "GIOL" "lowerRight" "R0" "stick" 0.0625 nil)
schCreateWire(cv "route" "full" '((27.125 12.562) (26.375 12.562)) 0 0 0 nil nil)
schCreateWireLabel(cv nil '(26.875 12.562) "VDDSAR" "lowerRight" "R0" "stick" 0.0625 nil)
dbCreateInst(cv pdb3ac_h_gMaster "IB3_right6" '(28.0 15.1875) "R90")
schCreateWire(cv "route" "full" '((28.000 14.999) (28.750 14.999)) 0 0 0 nil nil)
schCreateWireLabel(cv nil '(28.250 14.999) "IB3" "lowerLeft" "R0" "stick" 0.0625 nil)
schCreatePin(cv nil "IB3" "inputOutput" nil '(28.750 14.999) "R180")
schCreateWire(cv "route" "full" '((27.125 14.938) (26.375 14.938)) 0 0 0 nil nil)
schCreateWireLabel(cv nil '(26.875 14.938) "VSSSAR" "lowerRight" "R0" "stick" 0.0625 nil)
schCreateWire(cv "route" "full" '((27.125 15.312) (26.375 15.312)) 0 0 0 nil nil)
schCreateWireLabel(cv nil '(26.875 15.312) "GIOL" "lowerRight" "R0" "stick" 0.0625 nil)
schCreateWire(cv "route" "full" '((27.125 14.562) (26.375 14.562)) 0 0 0 nil nil)
schCreateWireLabel(cv nil '(26.875 14.562) "VDDSAR" "lowerRight" "R0" "stick" 0.0625 nil)
dbCreateInst(cv pdb3ac_h_gMaster "IB4_right7" '(28.0 17.1875) "R90")
schCreateWire(cv "route" "full" '((28.000 17.000) (28.750 17.000)) 0 0 0 nil nil)
schCreateWireLabel(cv nil '(28.250 17.000) "IB4" "lowerLeft" "R0" "stick" 0.0625 nil)
schCreatePin(cv nil "IB4" "inputOutput" nil '(28.750 17.000) "R180")
schCreateWire(cv "route" "full" '((27.125 16.938) (26.375 16.938)) 0 0 0 nil nil)
schCreateWireLabel(cv nil '(26.875 16.938) "VSSSAR" "lowerRight" "R0" "stick" 0.0625 nil)
schCreateWire(cv "route" "full" '((27.125 17.312) (26.375 17.312)) 0 0 0 nil nil)
schCreateWireLabel(cv nil '(26.875 17.312) "GIOL" "lowerRight" "R0" "stick" 0.0625 nil)
schCreateWire(cv "route" "full" '((27.125 16.562) (26.375 16.562)) 0 0 0 nil nil)
schCreateWireLabel(cv nil '(26.875 16.562) "VDDSAR" "lowerRight" "R0" "stick" 0.0625 nil)
dbCreateInst(cv pdb3ac_h_gMaster "IB5_right8" '(28.0 19.1875) "R90")
schCreateWire(cv "route" "full" '((28.000 19.000) (28.750 19.000)) 0 0 0 nil nil)
schCreateWireLabel(cv nil '(28.250 19.000) "IB5" "lowerLeft" "R0" "stick" 0.0625 nil)
schCreatePin(cv nil "IB5" "inputOutput" nil '(28.750 19.000) "R180")
schCreateWire(cv "route" "full" '((27.125 18.938) (26.375 18.938)) 0 0 0 nil nil)
schCreateWireLabel(cv nil '(26.875 18.938) "VSSSAR" "lowerRight" "R0" "stick" 0.0625 nil)
schCreateWire(cv "route" "full" '((27.125 19.312) (26.375 19.312)) 0 0 0 nil nil)
schCreateWireLabel(cv nil '(26.875 19.312) "GIOL" "lowerRight" "R0" "stick" 0.0625 nil)
schCreateWire(cv "route" "full" '((27.125 18.562) (26.375 18.562)) 0 0 0 nil nil)
schCreateWireLabel(cv nil '(26.875 18.562) "VDDSAR" "lowerRight" "R0" "stick" 0.0625 nil)
dbCreateInst(cv pdb3ac_h_gMaster "IB6_right9" '(28.0 21.1875) "R90")
schCreateWire(cv "route" "full" '((28.000 21.000) (28.750 21.000)) 0 0 0 nil nil)
schCreateWireLabel(cv nil '(28.250 21.000) "IB6" "lowerLeft" "R0" "stick" 0.0625 nil)
schCreatePin(cv nil "IB6" "inputOutput" nil '(28.750 21.000) "R180")
schCreateWire(cv "route" "full" '((27.125 20.938) (26.375 20.938)) 0 0 0 nil nil)
schCreateWireLabel(cv nil '(26.875 20.938) "VSSSAR" "lowerRight" "R0" "stick" 0.0625 nil)
schCreateWire(cv "route" "full" '((27.125 21.312) (26.375 21.312)) 0 0 0 nil nil)
schCreateWireLabel(cv nil '(26.875 21.312) "GIOL" "lowerRight" "R0" "stick" 0.0625 nil)
schCreateWire(cv "route" "full" '((27.125 20.562) (26.375 20.562)) 0 0 0 nil nil)
schCreateWireLabel(cv nil '(26.875 20.562) "VDDSAR" "lowerRight" "R0" "stick" 0.0625 nil)
dbCreateInst(cv pdb3ac_h_gMaster "IB7_right10" '(28.0 23.1875) "R90")
schCreateWire(cv "route" "full" '((28.000 23.000) (28.750 23.000)) 0 0 0 nil nil)
schCreateWireLabel(cv nil '(28.250 23.000) "IB7" "lowerLeft" "R0" "stick" 0.0625 nil)
schCreatePin(cv nil "IB7" "inputOutput" nil '(28.750 23.000) "R180")
schCreateWire(cv "route" "full" '((27.125 22.938) (26.375 22.938)) 0 0 0 nil nil)
schCreateWireLabel(cv nil '(26.875 22.938) "VSSSAR" "lowerRight" "R0" "stick" 0.0625 nil)
schCreateWire(cv "route" "full" '((27.125 23.312) (26.375 23.312)) 0 0 0 nil nil)
schCreateWireLabel(cv nil '(26.875 23.312) "GIOL" "lowerRight" "R0" "stick" 0.0625 nil)
schCreateWire(cv "route" "full" '((27.125 22.562) (26.375 22.562)) 0 0 0 nil nil)
schCreateWireLabel(cv nil '(26.875 22.562) "VDDSAR" "lowerRight" "R0" "stick" 0.0625 nil)
dbCreateInst(cv pdb3ac_h_gMaster "IB8_right11" '(28.0 25.1875) "R90")
schCreateWire(cv "route" "full" '((28.000 25.000) (28.750 25.000)) 0 0 0 nil nil)
schCreateWireLabel(cv nil '(28.250 25.000) "IB8" "lowerLeft" "R0" "stick" 0.0625 nil)
schCreatePin(cv nil "IB8" "inputOutput" nil '(28.750 25.000) "R180")
schCreateWire(cv "route" "full" '((27.125 24.938) (26.375 24.938)) 0 0 0 nil nil)
schCreateWireLabel(cv nil '(26.875 24.938) "VSSSAR" "lowerRight" "R0" "stick" 0.0625 nil)
schCreateWire(cv "route" "full" '((27.125 25.312) (26.375 25.312)) 0 0 0 nil nil)
schCreateWireLabel(cv nil '(26.875 25.312) "GIOL" "lowerRight" "R0" "stick" 0.0625 nil)
schCreateWire(cv "route" "full" '((27.125 24.562) (26.375 24.562)) 0 0 0 nil nil)
schCreateWireLabel(cv nil '(26.875 24.562) "VDDSAR" "lowerRight" "R0" "stick" 0.0625 nil)
dbCreateInst(cv pdb3ac_h_gMaster "IB9_right12" '(28.0 27.1875) "R90")
schCreateWire(cv "route" "full" '((28.000 27.000) (28.750 27.000)) 0 0 0 nil nil)
schCreateWireLabel(cv nil '(28.250 27.000) "IB9" "lowerLeft" "R0" "stick" 0.0625 nil)
schCreatePin(cv nil "IB9" "inputOutput" nil '(28.750 27.000) "R180")
schCreateWire(cv "route" "full" '((27.125 26.938) (26.375 26.938)) 0 0 0 nil nil)
schCreateWireLabel(cv nil '(26.875 26.938) "VSSSAR" "lowerRight" "R0" "stick" 0.0625 nil)
schCreateWire(cv "route" "full" '((27.125 27.312) (26.375 27.312)) 0 0 0 nil nil)
schCreateWireLabel(cv nil '(26.875 27.312) "GIOL" "lowerRight" "R0" "stick" 0.0625 nil)
schCreateWire(cv "route" "full" '((27.125 26.562) (26.375 26.562)) 0 0 0 nil nil)
schCreateWireLabel(cv nil '(26.875 26.562) "VDDSAR" "lowerRight" "R0" "stick" 0.0625 nil)
dbCreateInst(cv pdb3ac_h_gMaster "IB10_right13" '(28.0 29.1875) "R90")
schCreateWire(cv "route" "full" '((28.000 29.000) (28.750 29.000)) 0 0 0 nil nil)
schCreateWireLabel(cv nil '(28.250 29.000) "IB10" "lowerLeft" "R0" "stick" 0.0625 nil)
schCreatePin(cv nil "IB10" "inputOutput" nil '(28.750 29.000) "R180")
schCreateWire(cv "route" "full" '((27.125 28.938) (26.375 28.938)) 0 0 0 nil nil)
schCreateWireLabel(cv nil '(26.875 28.938) "VSSSAR" "lowerRight" "R0" "stick" 0.0625 nil)
schCreateWire(cv "route" "full" '((27.125 29.312) (26.375 29.312)) 0 0 0 nil nil)
schCreateWireLabel(cv nil '(26.875 29.312) "GIOL" "lowerRight" "R0" "stick" 0.0625 nil)
schCreateWire(cv "route" "full" '((27.125 28.562) (26.375 28.562)) 0 0 0 nil nil)
schCreateWireLabel(cv nil '(26.875 28.562) "VDDSAR" "lowerRight" "R0" "stick" 0.0625 nil)
dbCreateInst(cv pdb3ac_h_gMaster "IB11_right14" '(28.0 31.1875) "R90")
schCreateWire(cv "route" "full" '((28.000 31.000) (28.750 31.000)) 0 0 0 nil nil)
schCreateWireLabel(cv nil '(28.250 31.000) "IB11" "lowerLeft" "R0" "stick" 0.0625 nil)
schCreatePin(cv nil "IB11" "inputOutput" nil '(28.750 31.000) "R180")
schCreateWire(cv "route" "full" '((27.125 30.938) (26.375 30.938)) 0 0 0 nil nil)
schCreateWireLabel(cv nil '(26.875 30.938) "VSSSAR" "lowerRight" "R0" "stick" 0.0625 nil)
schCreateWire(cv "route" "full" '((27.125 31.312) (26.375 31.312)) 0 0 0 nil nil)
schCreateWireLabel(cv nil '(26.875 31.312) "GIOL" "lowerRight" "R0" "stick" 0.0625 nil)
schCreateWire(cv "route" "full" '((27.125 30.562) (26.375 30.562)) 0 0 0 nil nil)
schCreateWireLabel(cv nil '(26.875 30.562) "VDDSAR" "lowerRight" "R0" "stick" 0.0625 nil)
dbCreateInst(cv pdb3ac_h_gMaster "IB12_right15" '(28.0 33.1875) "R90")
schCreateWire(cv "route" "full" '((28.000 32.999) (28.750 32.999)) 0 0 0 nil nil)
schCreateWireLabel(cv nil '(28.250 32.999) "IB12" "lowerLeft" "R0" "stick" 0.0625 nil)
schCreatePin(cv nil "IB12" "inputOutput" nil '(28.750 32.999) "R180")
schCreateWire(cv "route" "full" '((27.125 32.938) (26.375 32.938)) 0 0 0 nil nil)
schCreateWireLabel(cv nil '(26.875 32.938) "VSSSAR" "lowerRight" "R0" "stick" 0.0625 nil)
schCreateWire(cv "route" "full" '((27.125 33.312) (26.375 33.312)) 0 0 0 nil nil)
schCreateWireLabel(cv nil '(26.875 33.312) "GIOL" "lowerRight" "R0" "stick" 0.0625 nil)
schCreateWire(cv "route" "full" '((27.125 32.562) (26.375 32.562)) 0 0 0 nil nil)
schCreateWireLabel(cv nil '(26.875 32.562) "VDDSAR" "lowerRight" "R0" "stick" 0.0625 nil)
dbCreateInst(cv pdb3ac_h_gMaster "IB13_right16" '(28.0 35.1875) "R90")
schCreateWire(cv "route" "full" '((28.000 34.999) (28.750 34.999)) 0 0 0 nil nil)
schCreateWireLabel(cv nil '(28.250 34.999) "IB13" "lowerLeft" "R0" "stick" 0.0625 nil)
schCreatePin(cv nil "IB13" "inputOutput" nil '(28.750 34.999) "R180")
schCreateWire(cv "route" "full" '((27.125 34.938) (26.375 34.938)) 0 0 0 nil nil)
schCreateWireLabel(cv nil '(26.875 34.938) "VSSSAR" "lowerRight" "R0" "stick" 0.0625 nil)
schCreateWire(cv "route" "full" '((27.125 35.312) (26.375 35.312)) 0 0 0 nil nil)
schCreateWireLabel(cv nil '(26.875 35.312) "GIOL" "lowerRight" "R0" "stick" 0.0625 nil)
schCreateWire(cv "route" "full" '((27.125 34.562) (26.375 34.562)) 0 0 0 nil nil)
schCreateWireLabel(cv nil '(26.875 34.562) "VDDSAR" "lowerRight" "R0" "stick" 0.0625 nil)
dbCreateInst(cv pdb3ac_h_gMaster "IB14_right17" '(28.0 37.1875) "R90")
schCreateWire(cv "route" "full" '((28.000 36.999) (28.750 36.999)) 0 0 0 nil nil)
schCreateWireLabel(cv nil '(28.250 36.999) "IB14" "lowerLeft" "R0" "stick" 0.0625 nil)
schCreatePin(cv nil "IB14" "inputOutput" nil '(28.750 36.999) "R180")
schCreateWire(cv "route" "full" '((27.125 36.938) (26.375 36.938)) 0 0 0 nil nil)
schCreateWireLabel(cv nil '(26.875 36.938) "VSSSAR" "lowerRight" "R0" "stick" 0.0625 nil)
schCreateWire(cv "route" "full" '((27.125 37.312) (26.375 37.312)) 0 0 0 nil nil)
schCreateWireLabel(cv nil '(26.875 37.312) "GIOL" "lowerRight" "R0" "stick" 0.0625 nil)
schCreateWire(cv "route" "full" '((27.125 36.562) (26.375 36.562)) 0 0 0 nil nil)
schCreateWireLabel(cv nil '(26.875 36.562) "VDDSAR" "lowerRight" "R0" "stick" 0.0625 nil)
dbCreateInst(cv pdb3ac_v_gMaster "IB15_top0" '(24.8125 40.0) "R180")
schCreateWire(cv "route" "full" '((25.000 40.000) (25.000 40.750)) 0 0 0 nil nil)
schCreateWireLabel(cv nil '(25.000 40.250) "IB15" "lowerLeft" "R90" "stick" 0.0625 nil)
schCreatePin(cv nil "IB15" "inputOutput" nil '(25.000 40.750) "R270")
schCreateWire(cv "route" "full" '((25.062 39.125) (25.062 38.375)) 0 0 0 nil nil)
schCreateWireLabel(cv nil '(25.062 38.875) "VSSSAR" "lowerRight" "R90" "stick" 0.0625 nil)
schCreateWire(cv "route" "full" '((24.688 39.125) (24.688 38.375)) 0 0 0 nil nil)
schCreateWireLabel(cv nil '(24.688 38.875) "GIOL" "lowerRight" "R90" "stick" 0.0625 nil)
schCreateWire(cv "route" "full" '((25.438 39.125) (25.438 38.375)) 0 0 0 nil nil)
schCreateWireLabel(cv nil '(25.438 38.875) "VDDSAR" "lowerRight" "R90" "stick" 0.0625 nil)
dbCreateInst(cv pdb3ac_v_gMaster "IB16_top1" '(22.8125 40.0) "R180")
schCreateWire(cv "route" "full" '((23.000 40.000) (23.000 40.750)) 0 0 0 nil nil)
schCreateWireLabel(cv nil '(23.000 40.250) "IB16" "lowerLeft" "R90" "stick" 0.0625 nil)
schCreatePin(cv nil "IB16" "inputOutput" nil '(23.000 40.750) "R270")
schCreateWire(cv "route" "full" '((23.062 39.125) (23.062 38.375)) 0 0 0 nil nil)
schCreateWireLabel(cv nil '(23.062 38.875) "VSSSAR" "lowerRight" "R90" "stick" 0.0625 nil)
schCreateWire(cv "route" "full" '((22.688 39.125) (22.688 38.375)) 0 0 0 nil nil)
schCreateWireLabel(cv nil '(22.688 38.875) "GIOL" "lowerRight" "R90" "stick" 0.0625 nil)
schCreateWire(cv "route" "full" '((23.438 39.125) (23.438 38.375)) 0 0 0 nil nil)
schCreateWireLabel(cv nil '(23.438 38.875) "VDDSAR" "lowerRight" "R90" "stick" 0.0625 nil)
dbCreateInst(cv pdb3ac_v_gMaster "IB17_top2" '(20.8125 40.0) "R180")
schCreateWire(cv "route" "full" '((21.000 40.000) (21.000 40.750)) 0 0 0 nil nil)
schCreateWireLabel(cv nil '(21.000 40.250) "IB17" "lowerLeft" "R90" "stick" 0.0625 nil)
schCreatePin(cv nil "IB17" "inputOutput" nil '(21.000 40.750) "R270")
schCreateWire(cv "route" "full" '((21.062 39.125) (21.062 38.375)) 0 0 0 nil nil)
schCreateWireLabel(cv nil '(21.062 38.875) "VSSSAR" "lowerRight" "R90" "stick" 0.0625 nil)
schCreateWire(cv "route" "full" '((20.688 39.125) (20.688 38.375)) 0 0 0 nil nil)
schCreateWireLabel(cv nil '(20.688 38.875) "GIOL" "lowerRight" "R90" "stick" 0.0625 nil)
schCreateWire(cv "route" "full" '((21.438 39.125) (21.438 38.375)) 0 0 0 nil nil)
schCreateWireLabel(cv nil '(21.438 38.875) "VDDSAR" "lowerRight" "R90" "stick" 0.0625 nil)
dbCreateInst(cv pdb3ac_v_gMaster "IB18_top3" '(18.8125 40.0) "R180")
schCreateWire(cv "route" "full" '((19.000 40.000) (19.000 40.750)) 0 0 0 nil nil)
schCreateWireLabel(cv nil '(19.000 40.250) "IB18" "lowerLeft" "R90" "stick" 0.0625 nil)
schCreatePin(cv nil "IB18" "inputOutput" nil '(19.000 40.750) "R270")
schCreateWire(cv "route" "full" '((19.062 39.125) (19.062 38.375)) 0 0 0 nil nil)
schCreateWireLabel(cv nil '(19.062 38.875) "VSSSAR" "lowerRight" "R90" "stick" 0.0625 nil)
schCreateWire(cv "route" "full" '((18.688 39.125) (18.688 38.375)) 0 0 0 nil nil)
schCreateWireLabel(cv nil '(18.688 38.875) "GIOL" "lowerRight" "R90" "stick" 0.0625 nil)
schCreateWire(cv "route" "full" '((19.438 39.125) (19.438 38.375)) 0 0 0 nil nil)
schCreateWireLabel(cv nil '(19.438 38.875) "VDDSAR" "lowerRight" "R90" "stick" 0.0625 nil)
dbCreateInst(cv pdb3ac_v_gMaster "IB19_top4" '(16.8125 40.0) "R180")
schCreateWire(cv "route" "full" '((17.000 40.000) (17.000 40.750)) 0 0 0 nil nil)
schCreateWireLabel(cv nil '(17.000 40.250) "IB19" "lowerLeft" "R90" "stick" 0.0625 nil)
schCreatePin(cv nil "IB19" "inputOutput" nil '(17.000 40.750) "R270")
schCreateWire(cv "route" "full" '((17.062 39.125) (17.062 38.375)) 0 0 0 nil nil)
schCreateWireLabel(cv nil '(17.062 38.875) "VSSSAR" "lowerRight" "R90" "stick" 0.0625 nil)
schCreateWire(cv "route" "full" '((16.688 39.125) (16.688 38.375)) 0 0 0 nil nil)
schCreateWireLabel(cv nil '(16.688 38.875) "GIOL" "lowerRight" "R90" "stick" 0.0625 nil)
schCreateWire(cv "route" "full" '((17.438 39.125) (17.438 38.375)) 0 0 0 nil nil)
schCreateWireLabel(cv nil '(17.438 38.875) "VDDSAR" "lowerRight" "R90" "stick" 0.0625 nil)
dbCreateInst(cv pdb3ac_v_gMaster "IB20_top5" '(14.8125 40.0) "R180")
schCreateWire(cv "route" "full" '((15.001 40.000) (15.001 40.750)) 0 0 0 nil nil)
schCreateWireLabel(cv nil '(15.001 40.250) "IB20" "lowerLeft" "R90" "stick" 0.0625 nil)
schCreatePin(cv nil "IB20" "inputOutput" nil '(15.001 40.750) "R270")
schCreateWire(cv "route" "full" '((15.062 39.125) (15.062 38.375)) 0 0 0 nil nil)
schCreateWireLabel(cv nil '(15.062 38.875) "VSSSAR" "lowerRight" "R90" "stick" 0.0625 nil)
schCreateWire(cv "route" "full" '((14.688 39.125) (14.688 38.375)) 0 0 0 nil nil)
schCreateWireLabel(cv nil '(14.688 38.875) "GIOL" "lowerRight" "R90" "stick" 0.0625 nil)
schCreateWire(cv "route" "full" '((15.438 39.125) (15.438 38.375)) 0 0 0 nil nil)
schCreateWireLabel(cv nil '(15.438 38.875) "VDDSAR" "lowerRight" "R90" "stick" 0.0625 nil)
dbCreateInst(cv pdb3ac_v_gMaster "IB21_top6" '(12.8125 40.0) "R180")
schCreateWire(cv "route" "full" '((13.001 40.000) (13.001 40.750)) 0 0 0 nil nil)
schCreateWireLabel(cv nil '(13.001 40.250) "IB21" "lowerLeft" "R90" "stick" 0.0625 nil)
schCreatePin(cv nil "IB21" "inputOutput" nil '(13.001 40.750) "R270")
schCreateWire(cv "route" "full" '((13.062 39.125) (13.062 38.375)) 0 0 0 nil nil)
schCreateWireLabel(cv nil '(13.062 38.875) "VSSSAR" "lowerRight" "R90" "stick" 0.0625 nil)
schCreateWire(cv "route" "full" '((12.688 39.125) (12.688 38.375)) 0 0 0 nil nil)
schCreateWireLabel(cv nil '(12.688 38.875) "GIOL" "lowerRight" "R90" "stick" 0.0625 nil)
schCreateWire(cv "route" "full" '((13.438 39.125) (13.438 38.375)) 0 0 0 nil nil)
schCreateWireLabel(cv nil '(13.438 38.875) "VDDSAR" "lowerRight" "R90" "stick" 0.0625 nil)
dbCreateInst(cv pdb3ac_v_gMaster "IB22_top7" '(10.8125 40.0) "R180")
schCreateWire(cv "route" "full" '((11.001 40.000) (11.001 40.750)) 0 0 0 nil nil)
schCreateWireLabel(cv nil '(11.001 40.250) "IB22" "lowerLeft" "R90" "stick" 0.0625 nil)
schCreatePin(cv nil "IB22" "inputOutput" nil '(11.001 40.750) "R270")
schCreateWire(cv "route" "full" '((11.062 39.125) (11.062 38.375)) 0 0 0 nil nil)
schCreateWireLabel(cv nil '(11.062 38.875) "VSSSAR" "lowerRight" "R90" "stick" 0.0625 nil)
schCreateWire(cv "route" "full" '((10.688 39.125) (10.688 38.375)) 0 0 0 nil nil)
schCreateWireLabel(cv nil '(10.688 38.875) "GIOL" "lowerRight" "R90" "stick" 0.0625 nil)
schCreateWire(cv "route" "full" '((11.438 39.125) (11.438 38.375)) 0 0 0 nil nil)
schCreateWireLabel(cv nil '(11.438 38.875) "VDDSAR" "lowerRight" "R90" "stick" 0.0625 nil)
dbCreateInst(cv pdb3ac_v_gMaster "IB23_top8" '(8.8125 40.0) "R180")
schCreateWire(cv "route" "full" '((9.001 40.000) (9.001 40.750)) 0 0 0 nil nil)
schCreateWireLabel(cv nil '(9.001 40.250) "IB23" "lowerLeft" "R90" "stick" 0.0625 nil)
schCreatePin(cv nil "IB23" "inputOutput" nil '(9.001 40.750) "R270")
schCreateWire(cv "route" "full" '((9.062 39.125) (9.062 38.375)) 0 0 0 nil nil)
schCreateWireLabel(cv nil '(9.062 38.875) "VSSSAR" "lowerRight" "R90" "stick" 0.0625 nil)
schCreateWire(cv "route" "full" '((8.688 39.125) (8.688 38.375)) 0 0 0 nil nil)
schCreateWireLabel(cv nil '(8.688 38.875) "GIOL" "lowerRight" "R90" "stick" 0.0625 nil)
schCreateWire(cv "route" "full" '((9.438 39.125) (9.438 38.375)) 0 0 0 nil nil)
schCreateWireLabel(cv nil '(9.438 38.875) "VDDSAR" "lowerRight" "R90" "stick" 0.0625 nil)
dbCreateInst(cv pdb3ac_v_gMaster "IB24_top9" '(6.8125 40.0) "R180")
schCreateWire(cv "route" "full" '((7.000 40.000) (7.000 40.750)) 0 0 0 nil nil)
schCreateWireLabel(cv nil '(7.000 40.250) "IB24" "lowerLeft" "R90" "stick" 0.0625 nil)
schCreatePin(cv nil "IB24" "inputOutput" nil '(7.000 40.750) "R270")
schCreateWire(cv "route" "full" '((7.062 39.125) (7.062 38.375)) 0 0 0 nil nil)
schCreateWireLabel(cv nil '(7.062 38.875) "VSSSAR" "lowerRight" "R90" "stick" 0.0625 nil)
schCreateWire(cv "route" "full" '((6.688 39.125) (6.688 38.375)) 0 0 0 nil nil)
schCreateWireLabel(cv nil '(6.688 38.875) "GIOL" "lowerRight" "R90" "stick" 0.0625 nil)
schCreateWire(cv "route" "full" '((7.438 39.125) (7.438 38.375)) 0 0 0 nil nil)
schCreateWireLabel(cv nil '(7.438 38.875) "VDDSAR" "lowerRight" "R90" "stick" 0.0625 nil)
dbCreateInst(cv pdb3ac_v_gMaster "IB25_top10" '(4.8125 40.0) "R180")
schCreateWire(cv "route" "full" '((5.000 40.000) (5.000 40.750)) 0 0 0 nil nil)
schCreateWireLabel(cv nil '(5.000 40.250) "IB25" "lowerLeft" "R90" "stick" 0.0625 nil)
schCreatePin(cv nil "IB25" "inputOutput" nil '(5.000 40.750) "R270")
schCreateWire(cv "route" "full" '((5.062 39.125) (5.062 38.375)) 0 0 0 nil nil)
schCreateWireLabel(cv nil '(5.062 38.875) "VSSSAR" "lowerRight" "R90" "stick" 0.0625 nil)
schCreateWire(cv "route" "full" '((4.688 39.125) (4.688 38.375)) 0 0 0 nil nil)
schCreateWireLabel(cv nil '(4.688 38.875) "GIOL" "lowerRight" "R90" "stick" 0.0625 nil)
schCreateWire(cv "route" "full" '((5.438 39.125) (5.438 38.375)) 0 0 0 nil nil)
schCreateWireLabel(cv nil '(5.438 38.875) "VDDSAR" "lowerRight" "R90" "stick" 0.0625 nil)
dbCreateInst(cv pdb3ac_v_gMaster "IB26_top11" '(2.8125 40.0) "R180")
schCreateWire(cv "route" "full" '((3.001 40.000) (3.001 40.750)) 0 0 0 nil nil)
schCreateWireLabel(cv nil '(3.001 40.250) "IB26" "lowerLeft" "R90" "stick" 0.0625 nil)
schCreatePin(cv nil "IB26" "inputOutput" nil '(3.001 40.750) "R270")
schCreateWire(cv "route" "full" '((3.062 39.125) (3.062 38.375)) 0 0 0 nil nil)
schCreateWireLabel(cv nil '(3.062 38.875) "VSSSAR" "lowerRight" "R90" "stick" 0.0625 nil)
schCreateWire(cv "route" "full" '((2.688 39.125) (2.688 38.375)) 0 0 0 nil nil)
schCreateWireLabel(cv nil '(2.688 38.875) "GIOL" "lowerRight" "R90" "stick" 0.0625 nil)
schCreateWire(cv "route" "full" '((3.438 39.125) (3.438 38.375)) 0 0 0 nil nil)
schCreateWireLabel(cv nil '(3.438 38.875) "VDDSAR" "lowerRight" "R90" "stick" 0.0625 nil)
schCheck(cv)
dbSave(cv)
t
