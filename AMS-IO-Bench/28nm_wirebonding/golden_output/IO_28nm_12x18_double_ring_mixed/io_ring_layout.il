; Generated Layout Script with Dual Ring Support

; ==================== All Components (Sorted by Placement Order) ====================
dbCreateParamInstByMasterName(cv "tphn28hpcpgv18" "PDB3AC_H_G" "layout" "IB11_left_11" list(0 150) "R270")
dbCreateParamInstByMasterName(cv "PAD" "PAD60GU" "layout" "pad60gu_IB11_left_11" list(0 150) "R270")
dbCreateParamInstByMasterName(cv "tphn28hpcpgv18" "PDB3AC_H_G" "layout" "IB10_left_10" list(0 210) "R270")
dbCreateParamInstByMasterName(cv "PAD" "PAD60GU" "layout" "pad60gu_IB10_left_10" list(0 210) "R270")
dbCreateParamInstByMasterName(cv "tphn28hpcpgv18" "PDB3AC_H_G" "layout" "IB9_left_9" list(0 270) "R270")
dbCreateParamInstByMasterName(cv "PAD" "PAD60GU" "layout" "pad60gu_IB9_left_9" list(0 270) "R270")
dbCreateParamInstByMasterName(cv "tphn28hpcpgv18" "PDB3AC_H_G" "layout" "IB8_left_8" list(0 330) "R270")
dbCreateParamInstByMasterName(cv "PAD" "PAD60GU" "layout" "pad60gu_IB8_left_8" list(0 330) "R270")
dbCreateParamInstByMasterName(cv "tphn28hpcpgv18" "PDB3AC_H_G" "layout" "IB7_left_7" list(0 390) "R270")
dbCreateParamInstByMasterName(cv "PAD" "PAD60GU" "layout" "pad60gu_IB7_left_7" list(0 390) "R270")
dbCreateParamInstByMasterName(cv "tphn28hpcpgv18" "PDB3AC_H_G" "layout" "IB6_left_6" list(0 450) "R270")
dbCreateParamInstByMasterName(cv "PAD" "PAD60GU" "layout" "pad60gu_IB6_left_6" list(0 450) "R270")
dbCreateParamInstByMasterName(cv "tphn28hpcpgv18" "PDB3AC_H_G" "layout" "IB5_left_5" list(0 510) "R270")
dbCreateParamInstByMasterName(cv "PAD" "PAD60GU" "layout" "pad60gu_IB5_left_5" list(0 510) "R270")
dbCreateParamInstByMasterName(cv "tphn28hpcpgv18" "PDB3AC_H_G" "layout" "IB4_left_4" list(0 570) "R270")
dbCreateParamInstByMasterName(cv "PAD" "PAD60GU" "layout" "pad60gu_IB4_left_4" list(0 570) "R270")
dbCreateParamInstByMasterName(cv "tphn28hpcpgv18" "PDB3AC_H_G" "layout" "IB3_left_3" list(0 630) "R270")
dbCreateParamInstByMasterName(cv "PAD" "PAD60GU" "layout" "pad60gu_IB3_left_3" list(0 630) "R270")
dbCreateParamInstByMasterName(cv "tphn28hpcpgv18" "PDB3AC_H_G" "layout" "IB2_left_2" list(0 690) "R270")
dbCreateParamInstByMasterName(cv "PAD" "PAD60GU" "layout" "pad60gu_IB2_left_2" list(0 690) "R270")
dbCreateParamInstByMasterName(cv "tphn28hpcpgv18" "PDB3AC_H_G" "layout" "IB1_left_1" list(0 750) "R270")
dbCreateParamInstByMasterName(cv "PAD" "PAD60GU" "layout" "pad60gu_IB1_left_1" list(0 750) "R270")
dbCreateParamInstByMasterName(cv "tphn28hpcpgv18" "PDB3AC_H_G" "layout" "IB0_left_0" list(0 810) "R270")
dbCreateParamInstByMasterName(cv "PAD" "PAD60GU" "layout" "pad60gu_IB0_left_0" list(0 810) "R270")
dbCreateParamInstByMasterName(cv "tphn28hpcpgv18" "PCORNERA_G" "layout" "CORNER_TOPLEFT_top_left" list(0 940) "R270")
dbCreateParamInstByMasterName(cv "tphn28hpcpgv18" "PDB3AC_V_G" "layout" "VIN_bottom_17" list(1150 0) "R0")
dbCreateParamInstByMasterName(cv "PAD" "PAD60GU" "layout" "pad60gu_VIN_bottom_17" list(1150 0) "R0")
dbCreateParamInstByMasterName(cv "tphn28hpcpgv18" "PDB3AC_V_G" "layout" "VIP_bottom_16" list(1090 0) "R0")
dbCreateParamInstByMasterName(cv "PAD" "PAD60GU" "layout" "pad60gu_VIP_bottom_16" list(1090 0) "R0")
dbCreateParamInstByMasterName(cv "tphn28hpcpgv18" "PVSS1AC_V_G" "layout" "GND_bottom_15" list(1030 0) "R0")
dbCreateParamInstByMasterName(cv "PAD" "PAD60GU" "layout" "pad60gu_GND_bottom_15" list(1030 0) "R0")
dbCreateParamInstByMasterName(cv "tphn28hpcpgv18" "PDB3AC_V_G" "layout" "VCM_bottom_14" list(970 0) "R0")
dbCreateParamInstByMasterName(cv "PAD" "PAD60GU" "layout" "pad60gu_VCM_bottom_14" list(970 0) "R0")
dbCreateParamInstByMasterName(cv "tphn28hpcpgv18" "PVDD1AC_V_G" "layout" "VDDA18_bottom_13" list(910 0) "R0")
dbCreateParamInstByMasterName(cv "PAD" "PAD60GU" "layout" "pad60gu_VDDA18_bottom_13" list(910 0) "R0")
dbCreateParamInstByMasterName(cv "tphn28hpcpgv18" "PVSS1AC_V_G" "layout" "VSSA_bottom_12" list(850 0) "R0")
dbCreateParamInstByMasterName(cv "PAD" "PAD60GU" "layout" "pad60gu_VSSA_bottom_12" list(850 0) "R0")
dbCreateParamInstByMasterName(cv "tphn28hpcpgv18" "PVDD1AC_V_G" "layout" "VDDA09_bottom_11" list(790 0) "R0")
dbCreateParamInstByMasterName(cv "PAD" "PAD60GU" "layout" "pad60gu_VDDA09_bottom_11" list(790 0) "R0")
dbCreateParamInstByMasterName(cv "tphn28hpcpgv18" "PDB3AC_V_G" "layout" "VCMGM_bottom_10" list(730 0) "R0")
dbCreateParamInstByMasterName(cv "PAD" "PAD60GU" "layout" "pad60gu_VCMGM_bottom_10" list(730 0) "R0")
dbCreateParamInstByMasterName(cv "tphn28hpcpgv18" "PVSS3AC_V_G" "layout" "VSSGM_bottom_9" list(670 0) "R0")
dbCreateParamInstByMasterName(cv "PAD" "PAD60GU" "layout" "pad60gu_VSSGM_bottom_9" list(670 0) "R0")
dbCreateParamInstByMasterName(cv "tphn28hpcpgv18" "PVDD3AC_V_G" "layout" "VDDGM_bottom_8" list(610 0) "R0")
dbCreateParamInstByMasterName(cv "PAD" "PAD60GU" "layout" "pad60gu_VDDGM_bottom_8" list(610 0) "R0")
dbCreateParamInstByMasterName(cv "tphn28hpcpgv18" "PDB3AC_V_G" "layout" "IB19_bottom_7" list(550 0) "R0")
dbCreateParamInstByMasterName(cv "PAD" "PAD60GU" "layout" "pad60gu_IB19_bottom_7" list(550 0) "R0")
dbCreateParamInstByMasterName(cv "tphn28hpcpgv18" "PDB3AC_V_G" "layout" "IB18_bottom_6" list(490 0) "R0")
dbCreateParamInstByMasterName(cv "PAD" "PAD60GU" "layout" "pad60gu_IB18_bottom_6" list(490 0) "R0")
dbCreateParamInstByMasterName(cv "tphn28hpcpgv18" "PDB3AC_V_G" "layout" "IB17_bottom_5" list(430 0) "R0")
dbCreateParamInstByMasterName(cv "PAD" "PAD60GU" "layout" "pad60gu_IB17_bottom_5" list(430 0) "R0")
dbCreateParamInstByMasterName(cv "tphn28hpcpgv18" "PDB3AC_V_G" "layout" "IB16_bottom_4" list(370 0) "R0")
dbCreateParamInstByMasterName(cv "PAD" "PAD60GU" "layout" "pad60gu_IB16_bottom_4" list(370 0) "R0")
dbCreateParamInstByMasterName(cv "tphn28hpcpgv18" "PDB3AC_V_G" "layout" "IB15_bottom_3" list(310 0) "R0")
dbCreateParamInstByMasterName(cv "PAD" "PAD60GU" "layout" "pad60gu_IB15_bottom_3" list(310 0) "R0")
dbCreateParamInstByMasterName(cv "tphn28hpcpgv18" "PDB3AC_V_G" "layout" "IB14_bottom_2" list(250 0) "R0")
dbCreateParamInstByMasterName(cv "PAD" "PAD60GU" "layout" "pad60gu_IB14_bottom_2" list(250 0) "R0")
dbCreateParamInstByMasterName(cv "tphn28hpcpgv18" "PDB3AC_V_G" "layout" "IB13_bottom_1" list(190 0) "R0")
dbCreateParamInstByMasterName(cv "PAD" "PAD60GU" "layout" "pad60gu_IB13_bottom_1" list(190 0) "R0")
dbCreateParamInstByMasterName(cv "tphn28hpcpgv18" "PDB3AC_V_G" "layout" "IB12_bottom_0" list(130 0) "R0")
dbCreateParamInstByMasterName(cv "PAD" "PAD60GU" "layout" "pad60gu_IB12_bottom_0" list(130 0) "R0")
dbCreateParamInstByMasterName(cv "tphn28hpcpgv18" "PCORNERA_G" "layout" "CORNER_BOTTOMLEFT_bottom_left" list(0 0) "R0")
dbCreateParamInstByMasterName(cv "tphn28hpcpgv18" "PDDW16SDGZ_H_G" "layout" "D10_right_11" list(1300 790) "R90")
dbCreateParamInstByMasterName(cv "PAD" "PAD60GU" "layout" "pad60gu_D10_right_11" list(1300 790) "R90")
dbCreateParamInstByMasterName(cv "tphn28hpcpgv18" "PDDW16SDGZ_H_G" "layout" "D9_right_10" list(1300 730) "R90")
dbCreateParamInstByMasterName(cv "PAD" "PAD60GU" "layout" "pad60gu_D9_right_10" list(1300 730) "R90")
dbCreateParamInstByMasterName(cv "tphn28hpcpgv18" "PDDW16SDGZ_H_G" "layout" "D8_right_9" list(1300 670) "R90")
dbCreateParamInstByMasterName(cv "PAD" "PAD60GU" "layout" "pad60gu_D8_right_9" list(1300 670) "R90")
dbCreateParamInstByMasterName(cv "tphn28hpcpgv18" "PDDW16SDGZ_H_G" "layout" "D7_right_8" list(1300 610) "R90")
dbCreateParamInstByMasterName(cv "PAD" "PAD60GU" "layout" "pad60gu_D7_right_8" list(1300 610) "R90")
dbCreateParamInstByMasterName(cv "tphn28hpcpgv18" "PDDW16SDGZ_H_G" "layout" "D6_right_7" list(1300 550) "R90")
dbCreateParamInstByMasterName(cv "PAD" "PAD60GU" "layout" "pad60gu_D6_right_7" list(1300 550) "R90")
dbCreateParamInstByMasterName(cv "tphn28hpcpgv18" "PDDW16SDGZ_H_G" "layout" "D5_right_6" list(1300 490) "R90")
dbCreateParamInstByMasterName(cv "PAD" "PAD60GU" "layout" "pad60gu_D5_right_6" list(1300 490) "R90")
dbCreateParamInstByMasterName(cv "tphn28hpcpgv18" "PDDW16SDGZ_H_G" "layout" "D4_right_5" list(1300 430) "R90")
dbCreateParamInstByMasterName(cv "PAD" "PAD60GU" "layout" "pad60gu_D4_right_5" list(1300 430) "R90")
dbCreateParamInstByMasterName(cv "tphn28hpcpgv18" "PDDW16SDGZ_H_G" "layout" "D3_right_4" list(1300 370) "R90")
dbCreateParamInstByMasterName(cv "PAD" "PAD60GU" "layout" "pad60gu_D3_right_4" list(1300 370) "R90")
dbCreateParamInstByMasterName(cv "tphn28hpcpgv18" "PDDW16SDGZ_H_G" "layout" "D2_right_3" list(1300 310) "R90")
dbCreateParamInstByMasterName(cv "PAD" "PAD60GU" "layout" "pad60gu_D2_right_3" list(1300 310) "R90")
dbCreateParamInstByMasterName(cv "tphn28hpcpgv18" "PDDW16SDGZ_H_G" "layout" "D1_right_2" list(1300 250) "R90")
dbCreateParamInstByMasterName(cv "PAD" "PAD60GU" "layout" "pad60gu_D1_right_2" list(1300 250) "R90")
dbCreateParamInstByMasterName(cv "tphn28hpcpgv18" "PDB3AC_H_G" "layout" "VCM09_right_1" list(1300 190) "R90")
dbCreateParamInstByMasterName(cv "PAD" "PAD60GU" "layout" "pad60gu_VCM09_right_1" list(1300 190) "R90")
dbCreateParamInstByMasterName(cv "tphn28hpcpgv18" "PVSS1AC_H_G" "layout" "GND_right_0" list(1300 130) "R90")
dbCreateParamInstByMasterName(cv "PAD" "PAD60GU" "layout" "pad60gu_GND_right_0" list(1300 130) "R90")
dbCreateParamInstByMasterName(cv "tphn28hpcpgv18" "PCORNERA_G" "layout" "CORNER_BOTTOMRIGHT_bottom_right" list(1300 0) "R90")
dbCreateParamInstByMasterName(cv "tphn28hpcpgv18" "PDB3AC_V_G" "layout" "VREFIB_top_17" list(150 940) "R180")
dbCreateParamInstByMasterName(cv "PAD" "PAD60GU" "layout" "pad60gu_VREFIB_top_17" list(150 940) "R180")
dbCreateParamInstByMasterName(cv "tphn28hpcpgv18" "PDB3AC_V_G" "layout" "IBIAS2_top_16" list(210 940) "R180")
dbCreateParamInstByMasterName(cv "PAD" "PAD60GU" "layout" "pad60gu_IBIAS2_top_16" list(210 940) "R180")
dbCreateParamInstByMasterName(cv "tphn28hpcpgv18" "PDB3AC_V_G" "layout" "IBIAS_top_15" list(270 940) "R180")
dbCreateParamInstByMasterName(cv "PAD" "PAD60GU" "layout" "pad60gu_IBIAS_top_15" list(270 940) "R180")
dbCreateParamInstByMasterName(cv "tphn28hpcpgv18" "PDB3AC_V_G" "layout" "VAMP_top_14" list(330 940) "R180")
dbCreateParamInstByMasterName(cv "PAD" "PAD60GU" "layout" "pad60gu_VAMP_top_14" list(330 940) "R180")
dbCreateParamInstByMasterName(cv "tphn28hpcpgv18" "PVSS1DGZ_V_G" "layout" "GIOL_top_13" list(390 940) "R180")
dbCreateParamInstByMasterName(cv "PAD" "PAD60GU" "layout" "pad60gu_GIOL_top_13" list(390 940) "R180")
dbCreateParamInstByMasterName(cv "tphn28hpcpgv18" "PVSS2DGZ_V_G" "layout" "GIOH_top_12" list(450 940) "R180")
dbCreateParamInstByMasterName(cv "PAD" "PAD60GU" "layout" "pad60gu_GIOH_top_12" list(450 940) "R180")
dbCreateParamInstByMasterName(cv "tphn28hpcpgv18" "PVDD1DGZ_V_G" "layout" "VIOL_top_11" list(510 940) "R180")
dbCreateParamInstByMasterName(cv "PAD" "PAD60GU" "layout" "pad60gu_VIOL_top_11" list(510 940) "R180")
dbCreateParamInstByMasterName(cv "tphn28hpcpgv18" "PVDD2POC_V_G" "layout" "VIOH_top_10" list(570 940) "R180")
dbCreateParamInstByMasterName(cv "PAD" "PAD60GU" "layout" "pad60gu_VIOH_top_10" list(570 940) "R180")
dbCreateParamInstByMasterName(cv "tphn28hpcpgv18" "PDDW16SDGZ_V_G" "layout" "SDO_top_9" list(630 940) "R180")
dbCreateParamInstByMasterName(cv "PAD" "PAD60GU" "layout" "pad60gu_SDO_top_9" list(630 940) "R180")
dbCreateParamInstByMasterName(cv "tphn28hpcpgv18" "PDDW16SDGZ_V_G" "layout" "SDI_top_8" list(690 940) "R180")
dbCreateParamInstByMasterName(cv "PAD" "PAD60GU" "layout" "pad60gu_SDI_top_8" list(690 940) "R180")
dbCreateParamInstByMasterName(cv "tphn28hpcpgv18" "PDDW16SDGZ_V_G" "layout" "SCK_top_7" list(750 940) "R180")
dbCreateParamInstByMasterName(cv "PAD" "PAD60GU" "layout" "pad60gu_SCK_top_7" list(750 940) "R180")
dbCreateParamInstByMasterName(cv "tphn28hpcpgv18" "PDDW16SDGZ_V_G" "layout" "RST_top_6" list(810 940) "R180")
dbCreateParamInstByMasterName(cv "PAD" "PAD60GU" "layout" "pad60gu_RST_top_6" list(810 940) "R180")
dbCreateParamInstByMasterName(cv "tphn28hpcpgv18" "PDDW16SDGZ_V_G" "layout" "SLP_top_5" list(870 940) "R180")
dbCreateParamInstByMasterName(cv "PAD" "PAD60GU" "layout" "pad60gu_SLP_top_5" list(870 940) "R180")
dbCreateParamInstByMasterName(cv "tphn28hpcpgv18" "PDDW16SDGZ_V_G" "layout" "CLKO_top_4" list(930 940) "R180")
dbCreateParamInstByMasterName(cv "PAD" "PAD60GU" "layout" "pad60gu_CLKO_top_4" list(930 940) "R180")
dbCreateParamInstByMasterName(cv "tphn28hpcpgv18" "PDDW16SDGZ_V_G" "layout" "D13_top_3" list(990 940) "R180")
dbCreateParamInstByMasterName(cv "PAD" "PAD60GU" "layout" "pad60gu_D13_top_3" list(990 940) "R180")
dbCreateParamInstByMasterName(cv "tphn28hpcpgv18" "PDDW16SDGZ_V_G" "layout" "D14_top_2" list(1050 940) "R180")
dbCreateParamInstByMasterName(cv "PAD" "PAD60GU" "layout" "pad60gu_D14_top_2" list(1050 940) "R180")
dbCreateParamInstByMasterName(cv "tphn28hpcpgv18" "PDDW16SDGZ_V_G" "layout" "D12_top_1" list(1110 940) "R180")
dbCreateParamInstByMasterName(cv "PAD" "PAD60GU" "layout" "pad60gu_D12_top_1" list(1110 940) "R180")
dbCreateParamInstByMasterName(cv "tphn28hpcpgv18" "PDDW16SDGZ_V_G" "layout" "D11_top_0" list(1170 940) "R180")
dbCreateParamInstByMasterName(cv "PAD" "PAD60GU" "layout" "pad60gu_D11_top_0" list(1170 940) "R180")
dbCreateParamInstByMasterName(cv "tphn28hpcpgv18" "PCORNER_G" "layout" "CORNER_TOPRIGHT_top_right" list(1300 940) "R180")

; ==================== Filler Components ====================
dbCreateParamInstByMasterName(cv "tphn28hpcpgv18" "PFILLER20A_G" "layout" "sep_bottom_right_corner" list(1170 0) "R0")
dbCreateParamInstByMasterName(cv "tphn28hpcpgv18" "PFILLER20A_G" "layout" "filler_bottom_left_corner" list(110 0) "R0")
dbCreateParamInstByMasterName(cv "tphn28hpcpgv18" "PFILLER20A_G" "layout" "filler_R0_1_1" list(1130 0) "R0")
dbCreateParamInstByMasterName(cv "tphn28hpcpgv18" "PFILLER20A_G" "layout" "filler_R0_1_2" list(1110 0) "R0")
dbCreateParamInstByMasterName(cv "tphn28hpcpgv18" "PFILLER20A_G" "layout" "filler_R0_2_1" list(1070 0) "R0")
dbCreateParamInstByMasterName(cv "tphn28hpcpgv18" "PFILLER20A_G" "layout" "filler_R0_2_2" list(1050 0) "R0")
dbCreateParamInstByMasterName(cv "tphn28hpcpgv18" "PFILLER20A_G" "layout" "filler_R0_3_1" list(1010 0) "R0")
dbCreateParamInstByMasterName(cv "tphn28hpcpgv18" "PFILLER20A_G" "layout" "filler_R0_3_2" list(990 0) "R0")
dbCreateParamInstByMasterName(cv "tphn28hpcpgv18" "PFILLER20A_G" "layout" "filler_R0_4_1" list(950 0) "R0")
dbCreateParamInstByMasterName(cv "tphn28hpcpgv18" "PFILLER20A_G" "layout" "filler_R0_4_2" list(930 0) "R0")
dbCreateParamInstByMasterName(cv "tphn28hpcpgv18" "PFILLER20A_G" "layout" "filler_R0_5_1" list(890 0) "R0")
dbCreateParamInstByMasterName(cv "tphn28hpcpgv18" "PFILLER20A_G" "layout" "filler_R0_5_2" list(870 0) "R0")
dbCreateParamInstByMasterName(cv "tphn28hpcpgv18" "PFILLER20A_G" "layout" "filler_R0_6_1" list(830 0) "R0")
dbCreateParamInstByMasterName(cv "tphn28hpcpgv18" "PFILLER20A_G" "layout" "filler_R0_6_2" list(810 0) "R0")
dbCreateParamInstByMasterName(cv "tphn28hpcpgv18" "PFILLER20A_G" "layout" "filler_R0_7_1" list(770 0) "R0")
dbCreateParamInstByMasterName(cv "tphn28hpcpgv18" "PFILLER20A_G" "layout" "filler_R0_7_2" list(750 0) "R0")
dbCreateParamInstByMasterName(cv "tphn28hpcpgv18" "PFILLER20A_G" "layout" "filler_R0_8_1" list(710 0) "R0")
dbCreateParamInstByMasterName(cv "tphn28hpcpgv18" "PFILLER20A_G" "layout" "filler_R0_8_2" list(690 0) "R0")
dbCreateParamInstByMasterName(cv "tphn28hpcpgv18" "PFILLER20A_G" "layout" "filler_R0_9_1" list(650 0) "R0")
dbCreateParamInstByMasterName(cv "tphn28hpcpgv18" "PFILLER20A_G" "layout" "filler_R0_9_2" list(630 0) "R0")
dbCreateParamInstByMasterName(cv "tphn28hpcpgv18" "PFILLER20A_G" "layout" "filler_R0_10_1" list(590 0) "R0")
dbCreateParamInstByMasterName(cv "tphn28hpcpgv18" "PFILLER20A_G" "layout" "filler_R0_10_2" list(570 0) "R0")
dbCreateParamInstByMasterName(cv "tphn28hpcpgv18" "PFILLER20A_G" "layout" "filler_R0_11_1" list(530 0) "R0")
dbCreateParamInstByMasterName(cv "tphn28hpcpgv18" "PFILLER20A_G" "layout" "filler_R0_11_2" list(510 0) "R0")
dbCreateParamInstByMasterName(cv "tphn28hpcpgv18" "PFILLER20A_G" "layout" "filler_R0_12_1" list(470 0) "R0")
dbCreateParamInstByMasterName(cv "tphn28hpcpgv18" "PFILLER20A_G" "layout" "filler_R0_12_2" list(450 0) "R0")
dbCreateParamInstByMasterName(cv "tphn28hpcpgv18" "PFILLER20A_G" "layout" "filler_R0_13_1" list(410 0) "R0")
dbCreateParamInstByMasterName(cv "tphn28hpcpgv18" "PFILLER20A_G" "layout" "filler_R0_13_2" list(390 0) "R0")
dbCreateParamInstByMasterName(cv "tphn28hpcpgv18" "PFILLER20A_G" "layout" "filler_R0_14_1" list(350 0) "R0")
dbCreateParamInstByMasterName(cv "tphn28hpcpgv18" "PFILLER20A_G" "layout" "filler_R0_14_2" list(330 0) "R0")
dbCreateParamInstByMasterName(cv "tphn28hpcpgv18" "PFILLER20A_G" "layout" "filler_R0_15_1" list(290 0) "R0")
dbCreateParamInstByMasterName(cv "tphn28hpcpgv18" "PFILLER20A_G" "layout" "filler_R0_15_2" list(270 0) "R0")
dbCreateParamInstByMasterName(cv "tphn28hpcpgv18" "PFILLER20A_G" "layout" "filler_R0_16_1" list(230 0) "R0")
dbCreateParamInstByMasterName(cv "tphn28hpcpgv18" "PFILLER20A_G" "layout" "filler_R0_16_2" list(210 0) "R0")
dbCreateParamInstByMasterName(cv "tphn28hpcpgv18" "PFILLER20A_G" "layout" "filler_R0_17_1" list(170 0) "R0")
dbCreateParamInstByMasterName(cv "tphn28hpcpgv18" "PFILLER20A_G" "layout" "filler_R0_17_2" list(150 0) "R0")
dbCreateParamInstByMasterName(cv "tphn28hpcpgv18" "PFILLER20_G" "layout" "filler_right_top_corner" list(1300 810) "R90")
dbCreateParamInstByMasterName(cv "tphn28hpcpgv18" "PFILLER20A_G" "layout" "filler_right_bottom_corner" list(1300 110) "R90")
dbCreateParamInstByMasterName(cv "tphn28hpcpgv18" "PFILLER20_G" "layout" "filler_R90_1_1" list(1300 770) "R90")
dbCreateParamInstByMasterName(cv "tphn28hpcpgv18" "PFILLER20_G" "layout" "filler_R90_1_2" list(1300 750) "R90")
dbCreateParamInstByMasterName(cv "tphn28hpcpgv18" "PFILLER20_G" "layout" "filler_R90_2_1" list(1300 710) "R90")
dbCreateParamInstByMasterName(cv "tphn28hpcpgv18" "PFILLER20_G" "layout" "filler_R90_2_2" list(1300 690) "R90")
dbCreateParamInstByMasterName(cv "tphn28hpcpgv18" "PFILLER20_G" "layout" "filler_R90_3_1" list(1300 650) "R90")
dbCreateParamInstByMasterName(cv "tphn28hpcpgv18" "PFILLER20_G" "layout" "filler_R90_3_2" list(1300 630) "R90")
dbCreateParamInstByMasterName(cv "tphn28hpcpgv18" "PFILLER20_G" "layout" "filler_R90_4_1" list(1300 590) "R90")
dbCreateParamInstByMasterName(cv "tphn28hpcpgv18" "PFILLER20_G" "layout" "filler_R90_4_2" list(1300 570) "R90")
dbCreateParamInstByMasterName(cv "tphn28hpcpgv18" "PFILLER20_G" "layout" "filler_R90_5_1" list(1300 530) "R90")
dbCreateParamInstByMasterName(cv "tphn28hpcpgv18" "PFILLER20_G" "layout" "filler_R90_5_2" list(1300 510) "R90")
dbCreateParamInstByMasterName(cv "tphn28hpcpgv18" "PFILLER20_G" "layout" "filler_R90_6_1" list(1300 470) "R90")
dbCreateParamInstByMasterName(cv "tphn28hpcpgv18" "PFILLER20_G" "layout" "filler_R90_6_2" list(1300 450) "R90")
dbCreateParamInstByMasterName(cv "tphn28hpcpgv18" "PFILLER20_G" "layout" "filler_R90_7_1" list(1300 410) "R90")
dbCreateParamInstByMasterName(cv "tphn28hpcpgv18" "PFILLER20_G" "layout" "filler_R90_7_2" list(1300 390) "R90")
dbCreateParamInstByMasterName(cv "tphn28hpcpgv18" "PFILLER20_G" "layout" "filler_R90_8_1" list(1300 350) "R90")
dbCreateParamInstByMasterName(cv "tphn28hpcpgv18" "PFILLER20_G" "layout" "filler_R90_8_2" list(1300 330) "R90")
dbCreateParamInstByMasterName(cv "tphn28hpcpgv18" "PFILLER20_G" "layout" "filler_R90_9_1" list(1300 290) "R90")
dbCreateParamInstByMasterName(cv "tphn28hpcpgv18" "PFILLER20_G" "layout" "filler_R90_9_2" list(1300 270) "R90")
dbCreateParamInstByMasterName(cv "tphn28hpcpgv18" "PRCUTA_G" "layout" "filler_R90_10_1" list(1300 230) "R90")
dbCreateParamInstByMasterName(cv "tphn28hpcpgv18" "PRCUTA_G" "layout" "filler_R90_10_2" list(1300 210) "R90")
dbCreateParamInstByMasterName(cv "tphn28hpcpgv18" "PFILLER20A_G" "layout" "filler_R90_11_1" list(1300 170) "R90")
dbCreateParamInstByMasterName(cv "tphn28hpcpgv18" "PFILLER20A_G" "layout" "filler_R90_11_2" list(1300 150) "R90")
dbCreateParamInstByMasterName(cv "tphn28hpcpgv18" "PFILLER20A_G" "layout" "sep_top_left_corner" list(130 940) "R180")
dbCreateParamInstByMasterName(cv "tphn28hpcpgv18" "PFILLER20_G" "layout" "filler_top_right_corner" list(1190 940) "R180")
dbCreateParamInstByMasterName(cv "tphn28hpcpgv18" "PFILLER20A_G" "layout" "filler_R180_1_1" list(170 940) "R180")
dbCreateParamInstByMasterName(cv "tphn28hpcpgv18" "PFILLER20A_G" "layout" "filler_R180_1_2" list(190 940) "R180")
dbCreateParamInstByMasterName(cv "tphn28hpcpgv18" "PFILLER20A_G" "layout" "filler_R180_2_1" list(230 940) "R180")
dbCreateParamInstByMasterName(cv "tphn28hpcpgv18" "PFILLER20A_G" "layout" "filler_R180_2_2" list(250 940) "R180")
dbCreateParamInstByMasterName(cv "tphn28hpcpgv18" "PFILLER20A_G" "layout" "filler_R180_3_1" list(290 940) "R180")
dbCreateParamInstByMasterName(cv "tphn28hpcpgv18" "PFILLER20A_G" "layout" "filler_R180_3_2" list(310 940) "R180")
dbCreateParamInstByMasterName(cv "tphn28hpcpgv18" "PRCUTA_G" "layout" "filler_R180_4_1" list(350 940) "R180")
dbCreateParamInstByMasterName(cv "tphn28hpcpgv18" "PRCUTA_G" "layout" "filler_R180_4_2" list(370 940) "R180")
dbCreateParamInstByMasterName(cv "tphn28hpcpgv18" "PFILLER20_G" "layout" "filler_R180_5_1" list(410 940) "R180")
dbCreateParamInstByMasterName(cv "tphn28hpcpgv18" "PFILLER20_G" "layout" "filler_R180_5_2" list(430 940) "R180")
dbCreateParamInstByMasterName(cv "tphn28hpcpgv18" "PFILLER20_G" "layout" "filler_R180_6_1" list(470 940) "R180")
dbCreateParamInstByMasterName(cv "tphn28hpcpgv18" "PFILLER20_G" "layout" "filler_R180_6_2" list(490 940) "R180")
dbCreateParamInstByMasterName(cv "tphn28hpcpgv18" "PFILLER20_G" "layout" "filler_R180_7_1" list(530 940) "R180")
dbCreateParamInstByMasterName(cv "tphn28hpcpgv18" "PFILLER20_G" "layout" "filler_R180_7_2" list(550 940) "R180")
dbCreateParamInstByMasterName(cv "tphn28hpcpgv18" "PFILLER20_G" "layout" "filler_R180_8_1" list(590 940) "R180")
dbCreateParamInstByMasterName(cv "tphn28hpcpgv18" "PFILLER20_G" "layout" "filler_R180_8_2" list(610 940) "R180")
dbCreateParamInstByMasterName(cv "tphn28hpcpgv18" "PFILLER20_G" "layout" "filler_R180_9_1" list(650 940) "R180")
dbCreateParamInstByMasterName(cv "tphn28hpcpgv18" "PFILLER20_G" "layout" "filler_R180_9_2" list(670 940) "R180")
dbCreateParamInstByMasterName(cv "tphn28hpcpgv18" "PFILLER20_G" "layout" "filler_R180_10_1" list(710 940) "R180")
dbCreateParamInstByMasterName(cv "tphn28hpcpgv18" "PFILLER20_G" "layout" "filler_R180_10_2" list(730 940) "R180")
dbCreateParamInstByMasterName(cv "tphn28hpcpgv18" "PFILLER20_G" "layout" "filler_R180_11_1" list(770 940) "R180")
dbCreateParamInstByMasterName(cv "tphn28hpcpgv18" "PFILLER20_G" "layout" "filler_R180_11_2" list(790 940) "R180")
dbCreateParamInstByMasterName(cv "tphn28hpcpgv18" "PFILLER20_G" "layout" "filler_R180_12_1" list(830 940) "R180")
dbCreateParamInstByMasterName(cv "tphn28hpcpgv18" "PFILLER20_G" "layout" "filler_R180_12_2" list(850 940) "R180")
dbCreateParamInstByMasterName(cv "tphn28hpcpgv18" "PFILLER20_G" "layout" "filler_R180_13_1" list(890 940) "R180")
dbCreateParamInstByMasterName(cv "tphn28hpcpgv18" "PFILLER20_G" "layout" "filler_R180_13_2" list(910 940) "R180")
dbCreateParamInstByMasterName(cv "tphn28hpcpgv18" "PFILLER20_G" "layout" "filler_R180_14_1" list(950 940) "R180")
dbCreateParamInstByMasterName(cv "tphn28hpcpgv18" "PFILLER20_G" "layout" "filler_R180_14_2" list(970 940) "R180")
dbCreateParamInstByMasterName(cv "tphn28hpcpgv18" "PFILLER20_G" "layout" "filler_R180_15_1" list(1010 940) "R180")
dbCreateParamInstByMasterName(cv "tphn28hpcpgv18" "PFILLER20_G" "layout" "filler_R180_15_2" list(1030 940) "R180")
dbCreateParamInstByMasterName(cv "tphn28hpcpgv18" "PFILLER20_G" "layout" "filler_R180_16_1" list(1070 940) "R180")
dbCreateParamInstByMasterName(cv "tphn28hpcpgv18" "PFILLER20_G" "layout" "filler_R180_16_2" list(1090 940) "R180")
dbCreateParamInstByMasterName(cv "tphn28hpcpgv18" "PFILLER20_G" "layout" "filler_R180_17_1" list(1130 940) "R180")
dbCreateParamInstByMasterName(cv "tphn28hpcpgv18" "PFILLER20_G" "layout" "filler_R180_17_2" list(1150 940) "R180")
dbCreateParamInstByMasterName(cv "tphn28hpcpgv18" "PFILLER20A_G" "layout" "filler_left_bottom_corner" list(0 130) "R270")
dbCreateParamInstByMasterName(cv "tphn28hpcpgv18" "PFILLER20A_G" "layout" "sep_left_top_corner" list(0 830) "R270")
dbCreateParamInstByMasterName(cv "tphn28hpcpgv18" "PFILLER20A_G" "layout" "filler_R270_1_1" list(0 170) "R270")
dbCreateParamInstByMasterName(cv "tphn28hpcpgv18" "PFILLER20A_G" "layout" "filler_R270_1_2" list(0 190) "R270")
dbCreateParamInstByMasterName(cv "tphn28hpcpgv18" "PFILLER20A_G" "layout" "filler_R270_2_1" list(0 230) "R270")
dbCreateParamInstByMasterName(cv "tphn28hpcpgv18" "PFILLER20A_G" "layout" "filler_R270_2_2" list(0 250) "R270")
dbCreateParamInstByMasterName(cv "tphn28hpcpgv18" "PFILLER20A_G" "layout" "filler_R270_3_1" list(0 290) "R270")
dbCreateParamInstByMasterName(cv "tphn28hpcpgv18" "PFILLER20A_G" "layout" "filler_R270_3_2" list(0 310) "R270")
dbCreateParamInstByMasterName(cv "tphn28hpcpgv18" "PFILLER20A_G" "layout" "filler_R270_4_1" list(0 350) "R270")
dbCreateParamInstByMasterName(cv "tphn28hpcpgv18" "PFILLER20A_G" "layout" "filler_R270_4_2" list(0 370) "R270")
dbCreateParamInstByMasterName(cv "tphn28hpcpgv18" "PFILLER20A_G" "layout" "filler_R270_5_1" list(0 410) "R270")
dbCreateParamInstByMasterName(cv "tphn28hpcpgv18" "PFILLER20A_G" "layout" "filler_R270_5_2" list(0 430) "R270")
dbCreateParamInstByMasterName(cv "tphn28hpcpgv18" "PFILLER20A_G" "layout" "filler_R270_6_1" list(0 470) "R270")
dbCreateParamInstByMasterName(cv "tphn28hpcpgv18" "PFILLER20A_G" "layout" "filler_R270_6_2" list(0 490) "R270")
dbCreateParamInstByMasterName(cv "tphn28hpcpgv18" "PFILLER20A_G" "layout" "filler_R270_7_1" list(0 530) "R270")
dbCreateParamInstByMasterName(cv "tphn28hpcpgv18" "PFILLER20A_G" "layout" "filler_R270_7_2" list(0 550) "R270")
dbCreateParamInstByMasterName(cv "tphn28hpcpgv18" "PFILLER20A_G" "layout" "filler_R270_8_1" list(0 590) "R270")
dbCreateParamInstByMasterName(cv "tphn28hpcpgv18" "PFILLER20A_G" "layout" "filler_R270_8_2" list(0 610) "R270")
dbCreateParamInstByMasterName(cv "tphn28hpcpgv18" "PFILLER20A_G" "layout" "filler_R270_9_1" list(0 650) "R270")
dbCreateParamInstByMasterName(cv "tphn28hpcpgv18" "PFILLER20A_G" "layout" "filler_R270_9_2" list(0 670) "R270")
dbCreateParamInstByMasterName(cv "tphn28hpcpgv18" "PFILLER20A_G" "layout" "filler_R270_10_1" list(0 710) "R270")
dbCreateParamInstByMasterName(cv "tphn28hpcpgv18" "PFILLER20A_G" "layout" "filler_R270_10_2" list(0 730) "R270")
dbCreateParamInstByMasterName(cv "tphn28hpcpgv18" "PFILLER20A_G" "layout" "filler_R270_11_1" list(0 770) "R270")
dbCreateParamInstByMasterName(cv "tphn28hpcpgv18" "PFILLER20A_G" "layout" "filler_R270_11_2" list(0 790) "R270")

; ==================== Digital IO Features (with Inner Pad Support) ====================
dbCreatePath(cv list("M3" "drawing") list(list(1189.5 250) list(1189.5 810)) 0.2)
dbCreatePath(cv list("M3" "drawing") list(list(1190.76 250) list(1190.76 810)) 0.2)
dbCreatePath(cv list("M3" "drawing") list(list(370 829.5) list(1170 829.5)) 0.2)
dbCreatePath(cv list("M3" "drawing") list(list(370 830.76) list(1170 830.76)) 0.2)
dbCreatePath(cv list("M3" "drawing") list(list(1170 829.5) list(1189.5 829.5)) 0.2 "extendExtend")
dbCreatePath(cv list("M3" "drawing") list(list(1189.5 829.5) list(1189.5 810)) 0.2 "extendExtend")
dbCreatePath(cv list("M3" "drawing") list(list(1170 830.76) list(1190.76 830.76)) 0.2 "extendExtend")
dbCreatePath(cv list("M3" "drawing") list(list(1190.76 830.76) list(1190.76 810)) 0.2 "extendExtend")
dbCreatePath(cv list("M3" "drawing") list(list(507.655 829.88) list(507.655 829.5)) 0.2)
tech = techGetTechFile(cv)
viaParams = list(list("cutRows" 2) list("cutColumns" 4))
viaDefId = techFindViaDefByName(tech "M3_M2")
newVia = dbCreateVia(cv viaDefId list(507.655 829.88) "R180" viaParams)
dbCreatePath(cv list("M3" "drawing") list(list(387.61 829.88) list(387.61 830.76)) 0.2)
tech = techGetTechFile(cv)
viaParams = list(list("cutRows" 2) list("cutColumns" 4))
viaDefId = techFindViaDefByName(tech "M3_M2")
newVia = dbCreateVia(cv viaDefId list(387.61 829.88) "R180" viaParams)
dbCreatePath(cv list("M3" "drawing") list(list(1189.5 260.2) list(1190.125 260.2)) 0.26)
dbCreatePath(cv list("M3" "drawing") list(list(1190.76 255.9) list(1190.125 255.9)) 0.26)
dbCreateLabel(cv list("M4" "pin") list(1190.125 251.725) "D1_CORE" "centerRight" "R0" "roman" 2)
dbCreatePath(cv list("M3" "drawing") list(list(1189.5 320.2) list(1190.125 320.2)) 0.26)
dbCreatePath(cv list("M3" "drawing") list(list(1190.76 315.9) list(1190.125 315.9)) 0.26)
dbCreateLabel(cv list("M4" "pin") list(1190.125 311.725) "D2_CORE" "centerRight" "R0" "roman" 2)
dbCreatePath(cv list("M3" "drawing") list(list(1189.5 380.2) list(1190.125 380.2)) 0.26)
dbCreatePath(cv list("M3" "drawing") list(list(1190.76 375.9) list(1190.125 375.9)) 0.26)
dbCreateLabel(cv list("M4" "pin") list(1190.125 371.725) "D3_CORE" "centerRight" "R0" "roman" 2)
dbCreatePath(cv list("M3" "drawing") list(list(1189.5 440.2) list(1190.125 440.2)) 0.26)
dbCreatePath(cv list("M3" "drawing") list(list(1190.76 435.9) list(1190.125 435.9)) 0.26)
dbCreateLabel(cv list("M4" "pin") list(1190.125 431.725) "D4_CORE" "centerRight" "R0" "roman" 2)
dbCreatePath(cv list("M3" "drawing") list(list(1189.5 500.2) list(1190.125 500.2)) 0.26)
dbCreatePath(cv list("M3" "drawing") list(list(1190.76 495.9) list(1190.125 495.9)) 0.26)
dbCreateLabel(cv list("M4" "pin") list(1190.125 491.725) "D5_CORE" "centerRight" "R0" "roman" 2)
dbCreatePath(cv list("M3" "drawing") list(list(1189.5 560.2) list(1190.125 560.2)) 0.26)
dbCreatePath(cv list("M3" "drawing") list(list(1190.76 555.9) list(1190.125 555.9)) 0.26)
dbCreateLabel(cv list("M4" "pin") list(1190.125 551.725) "D6_CORE" "centerRight" "R0" "roman" 2)
dbCreatePath(cv list("M3" "drawing") list(list(1189.5 620.2) list(1190.125 620.2)) 0.26)
dbCreatePath(cv list("M3" "drawing") list(list(1190.76 615.9) list(1190.125 615.9)) 0.26)
dbCreateLabel(cv list("M4" "pin") list(1190.125 611.725) "D7_CORE" "centerRight" "R0" "roman" 2)
dbCreatePath(cv list("M3" "drawing") list(list(1189.5 680.2) list(1190.125 680.2)) 0.26)
dbCreatePath(cv list("M3" "drawing") list(list(1190.76 675.9) list(1190.125 675.9)) 0.26)
dbCreateLabel(cv list("M4" "pin") list(1190.125 671.725) "D8_CORE" "centerRight" "R0" "roman" 2)
dbCreatePath(cv list("M3" "drawing") list(list(1189.5 740.2) list(1190.125 740.2)) 0.26)
dbCreatePath(cv list("M3" "drawing") list(list(1190.76 735.9) list(1190.125 735.9)) 0.26)
dbCreateLabel(cv list("M4" "pin") list(1190.125 731.725) "D9_CORE" "centerRight" "R0" "roman" 2)
dbCreatePath(cv list("M3" "drawing") list(list(1189.5 800.2) list(1190.125 800.2)) 0.26)
dbCreatePath(cv list("M3" "drawing") list(list(1190.76 795.9) list(1190.125 795.9)) 0.26)
dbCreateLabel(cv list("M4" "pin") list(1190.125 791.725) "D10_CORE" "centerRight" "R0" "roman" 2)
dbCreatePath(cv list("M3" "drawing") list(list(1159.8 830.125) list(1159.8 829.5)) 0.26)
dbCreatePath(cv list("M3" "drawing") list(list(1164.1 830.125) list(1164.1 830.76)) 0.26)
dbCreateLabel(cv list("M4" "pin") list(1168.275 830.125) "D11_CORE" "centerRight" "R90" "roman" 2)
dbCreatePath(cv list("M3" "drawing") list(list(1099.8 830.125) list(1099.8 829.5)) 0.26)
dbCreatePath(cv list("M3" "drawing") list(list(1104.1 830.125) list(1104.1 830.76)) 0.26)
dbCreateLabel(cv list("M4" "pin") list(1108.275 830.125) "D12_CORE" "centerRight" "R90" "roman" 2)
dbCreatePath(cv list("M3" "drawing") list(list(1039.8 830.125) list(1039.8 829.5)) 0.26)
dbCreatePath(cv list("M3" "drawing") list(list(1044.1 830.125) list(1044.1 830.76)) 0.26)
dbCreateLabel(cv list("M4" "pin") list(1048.275 830.125) "D14_CORE" "centerRight" "R90" "roman" 2)
dbCreatePath(cv list("M3" "drawing") list(list(979.8 830.125) list(979.8 829.5)) 0.26)
dbCreatePath(cv list("M3" "drawing") list(list(984.1 830.125) list(984.1 830.76)) 0.26)
dbCreateLabel(cv list("M4" "pin") list(988.275 830.125) "D13_CORE" "centerRight" "R90" "roman" 2)
dbCreatePath(cv list("M3" "drawing") list(list(919.8 830.125) list(919.8 829.5)) 0.26)
dbCreatePath(cv list("M3" "drawing") list(list(924.1 830.125) list(924.1 830.76)) 0.26)
dbCreateLabel(cv list("M4" "pin") list(928.275 830.125) "CLKO_CORE" "centerRight" "R90" "roman" 2)
dbCreatePath(cv list("M3" "drawing") list(list(859.8 830.125) list(859.8 830.76)) 0.26)
dbCreatePath(cv list("M3" "drawing") list(list(868.275 830.125) list(868.275 830.76)) 0.26)
dbCreatePath(cv list("M3" "drawing") list(list(864.1 830.125) list(864.1 829.5)) 0.26)
dbCreateLabel(cv list("M4" "pin") list(855.67 830.125) "SLP_CORE" "centerRight" "R90" "roman" 2)
dbCreatePath(cv list("M3" "drawing") list(list(799.8 830.125) list(799.8 830.76)) 0.26)
dbCreatePath(cv list("M3" "drawing") list(list(808.275 830.125) list(808.275 830.76)) 0.26)
dbCreatePath(cv list("M3" "drawing") list(list(804.1 830.125) list(804.1 829.5)) 0.26)
dbCreateLabel(cv list("M4" "pin") list(795.67 830.125) "RST_CORE" "centerRight" "R90" "roman" 2)
dbCreatePath(cv list("M3" "drawing") list(list(739.8 830.125) list(739.8 830.76)) 0.26)
dbCreatePath(cv list("M3" "drawing") list(list(748.275 830.125) list(748.275 830.76)) 0.26)
dbCreatePath(cv list("M3" "drawing") list(list(744.1 830.125) list(744.1 829.5)) 0.26)
dbCreateLabel(cv list("M4" "pin") list(735.67 830.125) "SCK_CORE" "centerRight" "R90" "roman" 2)
dbCreatePath(cv list("M3" "drawing") list(list(679.8 830.125) list(679.8 830.76)) 0.26)
dbCreatePath(cv list("M3" "drawing") list(list(688.275 830.125) list(688.275 830.76)) 0.26)
dbCreatePath(cv list("M3" "drawing") list(list(684.1 830.125) list(684.1 829.5)) 0.26)
dbCreateLabel(cv list("M4" "pin") list(675.67 830.125) "SDI_CORE" "centerRight" "R90" "roman" 2)
dbCreatePath(cv list("M3" "drawing") list(list(619.8 830.125) list(619.8 829.5)) 0.26)
dbCreatePath(cv list("M3" "drawing") list(list(624.1 830.125) list(624.1 830.76)) 0.26)
dbCreateLabel(cv list("M4" "pin") list(628.275 830.125) "SDO_CORE" "centerRight" "R90" "roman" 2)

; ==================== Pin Labels (with Inner Pad Support) ====================
dbCreateLabel(cv list("AP" "pin") list(-11 800) "IB0" "centerRight" "R0" "roman" 10)
dbCreateLabel(cv list("AP" "pin") list(-11 740) "IB1" "centerRight" "R0" "roman" 10)
dbCreateLabel(cv list("AP" "pin") list(-11 680) "IB2" "centerRight" "R0" "roman" 10)
dbCreateLabel(cv list("AP" "pin") list(-11 620) "IB3" "centerRight" "R0" "roman" 10)
dbCreateLabel(cv list("AP" "pin") list(-11 560) "IB4" "centerRight" "R0" "roman" 10)
dbCreateLabel(cv list("AP" "pin") list(-11 500) "IB5" "centerRight" "R0" "roman" 10)
dbCreateLabel(cv list("AP" "pin") list(-11 440) "IB6" "centerRight" "R0" "roman" 10)
dbCreateLabel(cv list("AP" "pin") list(-11 380) "IB7" "centerRight" "R0" "roman" 10)
dbCreateLabel(cv list("AP" "pin") list(-11 320) "IB8" "centerRight" "R0" "roman" 10)
dbCreateLabel(cv list("AP" "pin") list(-11 260) "IB9" "centerRight" "R0" "roman" 10)
dbCreateLabel(cv list("AP" "pin") list(-11 200) "IB10" "centerRight" "R0" "roman" 10)
dbCreateLabel(cv list("AP" "pin") list(-11 140) "IB11" "centerRight" "R0" "roman" 10)
dbCreateLabel(cv list("AP" "pin") list(140 -11) "IB12" "centerRight" "R90" "roman" 10)
dbCreateLabel(cv list("AP" "pin") list(200 -11) "IB13" "centerRight" "R90" "roman" 10)
dbCreateLabel(cv list("AP" "pin") list(260 -11) "IB14" "centerRight" "R90" "roman" 10)
dbCreateLabel(cv list("AP" "pin") list(320 -11) "IB15" "centerRight" "R90" "roman" 10)
dbCreateLabel(cv list("AP" "pin") list(380 -11) "IB16" "centerRight" "R90" "roman" 10)
dbCreateLabel(cv list("AP" "pin") list(440 -11) "IB17" "centerRight" "R90" "roman" 10)
dbCreateLabel(cv list("AP" "pin") list(500 -11) "IB18" "centerRight" "R90" "roman" 10)
dbCreateLabel(cv list("AP" "pin") list(560 -11) "IB19" "centerRight" "R90" "roman" 10)
dbCreateLabel(cv list("AP" "pin") list(620 -11) "VDDGM" "centerRight" "R90" "roman" 10)
dbCreateLabel(cv list("M2" "pin") list(620 109.9) "VDDGM_CORE" "centerLeft" "R90" "roman" 2)
dbCreateLabel(cv list("AP" "pin") list(680 -11) "VSSGM" "centerRight" "R90" "roman" 10)
dbCreateLabel(cv list("M2" "pin") list(680 109.9) "VSSGM_CORE" "centerLeft" "R90" "roman" 2)
dbCreateLabel(cv list("AP" "pin") list(740 -11) "VCMGM" "centerRight" "R90" "roman" 10)
dbCreateLabel(cv list("AP" "pin") list(800 -11) "VDDA09" "centerRight" "R90" "roman" 10)
dbCreateLabel(cv list("AP" "pin") list(860 -11) "VSSA" "centerRight" "R90" "roman" 10)
dbCreateLabel(cv list("AP" "pin") list(920 -11) "VDDA18" "centerRight" "R90" "roman" 10)
dbCreateLabel(cv list("AP" "pin") list(980 -11) "VCM" "centerRight" "R90" "roman" 10)
dbCreateLabel(cv list("AP" "pin") list(1040 -11) "GND" "centerRight" "R90" "roman" 10)
dbCreateLabel(cv list("AP" "pin") list(1100 -11) "VIP" "centerRight" "R90" "roman" 10)
dbCreateLabel(cv list("AP" "pin") list(1160 -11) "VIN" "centerRight" "R90" "roman" 10)
dbCreateLabel(cv list("AP" "pin") list(1311 140) "GND" "centerLeft" "R0" "roman" 10)
dbCreateLabel(cv list("AP" "pin") list(1311 200) "VCM09" "centerLeft" "R0" "roman" 10)
dbCreateLabel(cv list("AP" "pin") list(1311 260) "D1" "centerLeft" "R0" "roman" 10)
dbCreateLabel(cv list("AP" "pin") list(1311 320) "D2" "centerLeft" "R0" "roman" 10)
dbCreateLabel(cv list("AP" "pin") list(1311 380) "D3" "centerLeft" "R0" "roman" 10)
dbCreateLabel(cv list("AP" "pin") list(1311 440) "D4" "centerLeft" "R0" "roman" 10)
dbCreateLabel(cv list("AP" "pin") list(1311 500) "D5" "centerLeft" "R0" "roman" 10)
dbCreateLabel(cv list("AP" "pin") list(1311 560) "D6" "centerLeft" "R0" "roman" 10)
dbCreateLabel(cv list("AP" "pin") list(1311 620) "D7" "centerLeft" "R0" "roman" 10)
dbCreateLabel(cv list("AP" "pin") list(1311 680) "D8" "centerLeft" "R0" "roman" 10)
dbCreateLabel(cv list("AP" "pin") list(1311 740) "D9" "centerLeft" "R0" "roman" 10)
dbCreateLabel(cv list("AP" "pin") list(1311 800) "D10" "centerLeft" "R0" "roman" 10)
dbCreateLabel(cv list("AP" "pin") list(1160 951) "D11" "centerLeft" "R90" "roman" 10)
dbCreateLabel(cv list("AP" "pin") list(1100 951) "D12" "centerLeft" "R90" "roman" 10)
dbCreateLabel(cv list("AP" "pin") list(1040 951) "D14" "centerLeft" "R90" "roman" 10)
dbCreateLabel(cv list("AP" "pin") list(980 951) "D13" "centerLeft" "R90" "roman" 10)
dbCreateLabel(cv list("AP" "pin") list(920 951) "CLKO" "centerLeft" "R90" "roman" 10)
dbCreateLabel(cv list("AP" "pin") list(860 951) "SLP" "centerLeft" "R90" "roman" 10)
dbCreateLabel(cv list("AP" "pin") list(800 951) "RST" "centerLeft" "R90" "roman" 10)
dbCreateLabel(cv list("AP" "pin") list(740 951) "SCK" "centerLeft" "R90" "roman" 10)
dbCreateLabel(cv list("AP" "pin") list(680 951) "SDI" "centerLeft" "R90" "roman" 10)
dbCreateLabel(cv list("AP" "pin") list(620 951) "SDO" "centerLeft" "R90" "roman" 10)
dbCreateLabel(cv list("AP" "pin") list(560 951) "VIOH" "centerLeft" "R90" "roman" 10)
dbCreateLabel(cv list("AP" "pin") list(500 951) "VIOL" "centerLeft" "R90" "roman" 10)
dbCreateLabel(cv list("AP" "pin") list(440 951) "GIOH" "centerLeft" "R90" "roman" 10)
dbCreateLabel(cv list("AP" "pin") list(380 951) "GIOL" "centerLeft" "R90" "roman" 10)
dbCreateLabel(cv list("AP" "pin") list(320 951) "VAMP" "centerLeft" "R90" "roman" 10)
dbCreateLabel(cv list("AP" "pin") list(260 951) "IBIAS" "centerLeft" "R90" "roman" 10)
dbCreateLabel(cv list("AP" "pin") list(200 951) "IBIAS2" "centerLeft" "R90" "roman" 10)
dbCreateLabel(cv list("AP" "pin") list(140 951) "VREFIB" "centerLeft" "R90" "roman" 10)

dbSave(cv)
t
