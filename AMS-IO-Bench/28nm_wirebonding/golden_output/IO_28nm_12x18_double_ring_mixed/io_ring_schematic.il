pdb3ac_h_gMaster = dbOpenCellView("tphn28hpcpgv18" "PDB3AC_H_G" "symbol")
dbCreateInst(cv pdb3ac_h_gMaster "IB0_left0" '(0 24.8125) "R270")
schCreateWire(cv "route" "full" '((0.000 25.000) (-0.750 25.000)) 0 0 0 nil nil)
schCreateWireLabel(cv nil '(-0.250 25.000) "IB0" "lowerRight" "R0" "stick" 0.0625 nil)
schCreatePin(cv nil "IB0" "inputOutput" nil '(-0.750 25.000) "R0")
schCreateWire(cv "route" "full" '((0.875 25.062) (1.625 25.062)) 0 0 0 nil nil)
schCreateWireLabel(cv nil '(1.125 25.062) "VSSGM" "lowerLeft" "R0" "stick" 0.0625 nil)
schCreateWire(cv "route" "full" '((0.875 24.688) (1.625 24.688)) 0 0 0 nil nil)
schCreateWireLabel(cv nil '(1.125 24.688) "GIOL" "lowerLeft" "R0" "stick" 0.0625 nil)
schCreateWire(cv "route" "full" '((0.875 25.438) (1.625 25.438)) 0 0 0 nil nil)
schCreateWireLabel(cv nil '(1.125 25.438) "VDDGM" "lowerLeft" "R0" "stick" 0.0625 nil)
dbCreateInst(cv pdb3ac_h_gMaster "IB1_left1" '(0 22.8125) "R270")
schCreateWire(cv "route" "full" '((0.000 23.000) (-0.750 23.000)) 0 0 0 nil nil)
schCreateWireLabel(cv nil '(-0.250 23.000) "IB1" "lowerRight" "R0" "stick" 0.0625 nil)
schCreatePin(cv nil "IB1" "inputOutput" nil '(-0.750 23.000) "R0")
schCreateWire(cv "route" "full" '((0.875 23.062) (1.625 23.062)) 0 0 0 nil nil)
schCreateWireLabel(cv nil '(1.125 23.062) "VSSGM" "lowerLeft" "R0" "stick" 0.0625 nil)
schCreateWire(cv "route" "full" '((0.875 22.688) (1.625 22.688)) 0 0 0 nil nil)
schCreateWireLabel(cv nil '(1.125 22.688) "GIOL" "lowerLeft" "R0" "stick" 0.0625 nil)
schCreateWire(cv "route" "full" '((0.875 23.438) (1.625 23.438)) 0 0 0 nil nil)
schCreateWireLabel(cv nil '(1.125 23.438) "VDDGM" "lowerLeft" "R0" "stick" 0.0625 nil)
dbCreateInst(cv pdb3ac_h_gMaster "IB2_left2" '(0 20.8125) "R270")
schCreateWire(cv "route" "full" '((0.000 21.000) (-0.750 21.000)) 0 0 0 nil nil)
schCreateWireLabel(cv nil '(-0.250 21.000) "IB2" "lowerRight" "R0" "stick" 0.0625 nil)
schCreatePin(cv nil "IB2" "inputOutput" nil '(-0.750 21.000) "R0")
schCreateWire(cv "route" "full" '((0.875 21.062) (1.625 21.062)) 0 0 0 nil nil)
schCreateWireLabel(cv nil '(1.125 21.062) "VSSGM" "lowerLeft" "R0" "stick" 0.0625 nil)
schCreateWire(cv "route" "full" '((0.875 20.688) (1.625 20.688)) 0 0 0 nil nil)
schCreateWireLabel(cv nil '(1.125 20.688) "GIOL" "lowerLeft" "R0" "stick" 0.0625 nil)
schCreateWire(cv "route" "full" '((0.875 21.438) (1.625 21.438)) 0 0 0 nil nil)
schCreateWireLabel(cv nil '(1.125 21.438) "VDDGM" "lowerLeft" "R0" "stick" 0.0625 nil)
dbCreateInst(cv pdb3ac_h_gMaster "IB3_left3" '(0 18.8125) "R270")
schCreateWire(cv "route" "full" '((0.000 19.000) (-0.750 19.000)) 0 0 0 nil nil)
schCreateWireLabel(cv nil '(-0.250 19.000) "IB3" "lowerRight" "R0" "stick" 0.0625 nil)
schCreatePin(cv nil "IB3" "inputOutput" nil '(-0.750 19.000) "R0")
schCreateWire(cv "route" "full" '((0.875 19.062) (1.625 19.062)) 0 0 0 nil nil)
schCreateWireLabel(cv nil '(1.125 19.062) "VSSGM" "lowerLeft" "R0" "stick" 0.0625 nil)
schCreateWire(cv "route" "full" '((0.875 18.688) (1.625 18.688)) 0 0 0 nil nil)
schCreateWireLabel(cv nil '(1.125 18.688) "GIOL" "lowerLeft" "R0" "stick" 0.0625 nil)
schCreateWire(cv "route" "full" '((0.875 19.438) (1.625 19.438)) 0 0 0 nil nil)
schCreateWireLabel(cv nil '(1.125 19.438) "VDDGM" "lowerLeft" "R0" "stick" 0.0625 nil)
dbCreateInst(cv pdb3ac_h_gMaster "IB4_left4" '(0 16.8125) "R270")
schCreateWire(cv "route" "full" '((0.000 17.000) (-0.750 17.000)) 0 0 0 nil nil)
schCreateWireLabel(cv nil '(-0.250 17.000) "IB4" "lowerRight" "R0" "stick" 0.0625 nil)
schCreatePin(cv nil "IB4" "inputOutput" nil '(-0.750 17.000) "R0")
schCreateWire(cv "route" "full" '((0.875 17.062) (1.625 17.062)) 0 0 0 nil nil)
schCreateWireLabel(cv nil '(1.125 17.062) "VSSGM" "lowerLeft" "R0" "stick" 0.0625 nil)
schCreateWire(cv "route" "full" '((0.875 16.688) (1.625 16.688)) 0 0 0 nil nil)
schCreateWireLabel(cv nil '(1.125 16.688) "GIOL" "lowerLeft" "R0" "stick" 0.0625 nil)
schCreateWire(cv "route" "full" '((0.875 17.438) (1.625 17.438)) 0 0 0 nil nil)
schCreateWireLabel(cv nil '(1.125 17.438) "VDDGM" "lowerLeft" "R0" "stick" 0.0625 nil)
dbCreateInst(cv pdb3ac_h_gMaster "IB5_left5" '(0 14.8125) "R270")
schCreateWire(cv "route" "full" '((0.000 15.001) (-0.750 15.001)) 0 0 0 nil nil)
schCreateWireLabel(cv nil '(-0.250 15.001) "IB5" "lowerRight" "R0" "stick" 0.0625 nil)
schCreatePin(cv nil "IB5" "inputOutput" nil '(-0.750 15.001) "R0")
schCreateWire(cv "route" "full" '((0.875 15.062) (1.625 15.062)) 0 0 0 nil nil)
schCreateWireLabel(cv nil '(1.125 15.062) "VSSGM" "lowerLeft" "R0" "stick" 0.0625 nil)
schCreateWire(cv "route" "full" '((0.875 14.688) (1.625 14.688)) 0 0 0 nil nil)
schCreateWireLabel(cv nil '(1.125 14.688) "GIOL" "lowerLeft" "R0" "stick" 0.0625 nil)
schCreateWire(cv "route" "full" '((0.875 15.438) (1.625 15.438)) 0 0 0 nil nil)
schCreateWireLabel(cv nil '(1.125 15.438) "VDDGM" "lowerLeft" "R0" "stick" 0.0625 nil)
dbCreateInst(cv pdb3ac_h_gMaster "IB6_left6" '(0 12.8125) "R270")
schCreateWire(cv "route" "full" '((0.000 13.001) (-0.750 13.001)) 0 0 0 nil nil)
schCreateWireLabel(cv nil '(-0.250 13.001) "IB6" "lowerRight" "R0" "stick" 0.0625 nil)
schCreatePin(cv nil "IB6" "inputOutput" nil '(-0.750 13.001) "R0")
schCreateWire(cv "route" "full" '((0.875 13.062) (1.625 13.062)) 0 0 0 nil nil)
schCreateWireLabel(cv nil '(1.125 13.062) "VSSGM" "lowerLeft" "R0" "stick" 0.0625 nil)
schCreateWire(cv "route" "full" '((0.875 12.688) (1.625 12.688)) 0 0 0 nil nil)
schCreateWireLabel(cv nil '(1.125 12.688) "GIOL" "lowerLeft" "R0" "stick" 0.0625 nil)
schCreateWire(cv "route" "full" '((0.875 13.438) (1.625 13.438)) 0 0 0 nil nil)
schCreateWireLabel(cv nil '(1.125 13.438) "VDDGM" "lowerLeft" "R0" "stick" 0.0625 nil)
dbCreateInst(cv pdb3ac_h_gMaster "IB7_left7" '(0 10.8125) "R270")
schCreateWire(cv "route" "full" '((0.000 11.001) (-0.750 11.001)) 0 0 0 nil nil)
schCreateWireLabel(cv nil '(-0.250 11.001) "IB7" "lowerRight" "R0" "stick" 0.0625 nil)
schCreatePin(cv nil "IB7" "inputOutput" nil '(-0.750 11.001) "R0")
schCreateWire(cv "route" "full" '((0.875 11.062) (1.625 11.062)) 0 0 0 nil nil)
schCreateWireLabel(cv nil '(1.125 11.062) "VSSGM" "lowerLeft" "R0" "stick" 0.0625 nil)
schCreateWire(cv "route" "full" '((0.875 10.688) (1.625 10.688)) 0 0 0 nil nil)
schCreateWireLabel(cv nil '(1.125 10.688) "GIOL" "lowerLeft" "R0" "stick" 0.0625 nil)
schCreateWire(cv "route" "full" '((0.875 11.438) (1.625 11.438)) 0 0 0 nil nil)
schCreateWireLabel(cv nil '(1.125 11.438) "VDDGM" "lowerLeft" "R0" "stick" 0.0625 nil)
dbCreateInst(cv pdb3ac_h_gMaster "IB8_left8" '(0 8.8125) "R270")
schCreateWire(cv "route" "full" '((0.000 9.001) (-0.750 9.001)) 0 0 0 nil nil)
schCreateWireLabel(cv nil '(-0.250 9.001) "IB8" "lowerRight" "R0" "stick" 0.0625 nil)
schCreatePin(cv nil "IB8" "inputOutput" nil '(-0.750 9.001) "R0")
schCreateWire(cv "route" "full" '((0.875 9.062) (1.625 9.062)) 0 0 0 nil nil)
schCreateWireLabel(cv nil '(1.125 9.062) "VSSGM" "lowerLeft" "R0" "stick" 0.0625 nil)
schCreateWire(cv "route" "full" '((0.875 8.688) (1.625 8.688)) 0 0 0 nil nil)
schCreateWireLabel(cv nil '(1.125 8.688) "GIOL" "lowerLeft" "R0" "stick" 0.0625 nil)
schCreateWire(cv "route" "full" '((0.875 9.438) (1.625 9.438)) 0 0 0 nil nil)
schCreateWireLabel(cv nil '(1.125 9.438) "VDDGM" "lowerLeft" "R0" "stick" 0.0625 nil)
dbCreateInst(cv pdb3ac_h_gMaster "IB9_left9" '(0 6.8125) "R270")
schCreateWire(cv "route" "full" '((0.000 7.000) (-0.750 7.000)) 0 0 0 nil nil)
schCreateWireLabel(cv nil '(-0.250 7.000) "IB9" "lowerRight" "R0" "stick" 0.0625 nil)
schCreatePin(cv nil "IB9" "inputOutput" nil '(-0.750 7.000) "R0")
schCreateWire(cv "route" "full" '((0.875 7.062) (1.625 7.062)) 0 0 0 nil nil)
schCreateWireLabel(cv nil '(1.125 7.062) "VSSGM" "lowerLeft" "R0" "stick" 0.0625 nil)
schCreateWire(cv "route" "full" '((0.875 6.688) (1.625 6.688)) 0 0 0 nil nil)
schCreateWireLabel(cv nil '(1.125 6.688) "GIOL" "lowerLeft" "R0" "stick" 0.0625 nil)
schCreateWire(cv "route" "full" '((0.875 7.438) (1.625 7.438)) 0 0 0 nil nil)
schCreateWireLabel(cv nil '(1.125 7.438) "VDDGM" "lowerLeft" "R0" "stick" 0.0625 nil)
dbCreateInst(cv pdb3ac_h_gMaster "IB10_left10" '(0 4.8125) "R270")
schCreateWire(cv "route" "full" '((0.000 5.000) (-0.750 5.000)) 0 0 0 nil nil)
schCreateWireLabel(cv nil '(-0.250 5.000) "IB10" "lowerRight" "R0" "stick" 0.0625 nil)
schCreatePin(cv nil "IB10" "inputOutput" nil '(-0.750 5.000) "R0")
schCreateWire(cv "route" "full" '((0.875 5.062) (1.625 5.062)) 0 0 0 nil nil)
schCreateWireLabel(cv nil '(1.125 5.062) "VSSGM" "lowerLeft" "R0" "stick" 0.0625 nil)
schCreateWire(cv "route" "full" '((0.875 4.688) (1.625 4.688)) 0 0 0 nil nil)
schCreateWireLabel(cv nil '(1.125 4.688) "GIOL" "lowerLeft" "R0" "stick" 0.0625 nil)
schCreateWire(cv "route" "full" '((0.875 5.438) (1.625 5.438)) 0 0 0 nil nil)
schCreateWireLabel(cv nil '(1.125 5.438) "VDDGM" "lowerLeft" "R0" "stick" 0.0625 nil)
dbCreateInst(cv pdb3ac_h_gMaster "IB11_left11" '(0 2.8125) "R270")
schCreateWire(cv "route" "full" '((0.000 3.001) (-0.750 3.001)) 0 0 0 nil nil)
schCreateWireLabel(cv nil '(-0.250 3.001) "IB11" "lowerRight" "R0" "stick" 0.0625 nil)
schCreatePin(cv nil "IB11" "inputOutput" nil '(-0.750 3.001) "R0")
schCreateWire(cv "route" "full" '((0.875 3.062) (1.625 3.062)) 0 0 0 nil nil)
schCreateWireLabel(cv nil '(1.125 3.062) "VSSGM" "lowerLeft" "R0" "stick" 0.0625 nil)
schCreateWire(cv "route" "full" '((0.875 2.688) (1.625 2.688)) 0 0 0 nil nil)
schCreateWireLabel(cv nil '(1.125 2.688) "GIOL" "lowerLeft" "R0" "stick" 0.0625 nil)
schCreateWire(cv "route" "full" '((0.875 3.438) (1.625 3.438)) 0 0 0 nil nil)
schCreateWireLabel(cv nil '(1.125 3.438) "VDDGM" "lowerLeft" "R0" "stick" 0.0625 nil)
pdb3ac_v_gMaster = dbOpenCellView("tphn28hpcpgv18" "PDB3AC_V_G" "symbol")
dbCreateInst(cv pdb3ac_v_gMaster "IB12_bottom0" '(3.1875 0) "R0")
schCreateWire(cv "route" "full" '((2.999 0.000) (2.999 -0.750)) 0 0 0 nil nil)
schCreateWireLabel(cv nil '(2.999 -0.250) "IB12" "lowerRight" "R90" "stick" 0.0625 nil)
schCreatePin(cv nil "IB12" "inputOutput" nil '(2.999 -0.750) "R90")
schCreateWire(cv "route" "full" '((2.938 0.875) (2.938 1.625)) 0 0 0 nil nil)
schCreateWireLabel(cv nil '(2.938 1.125) "VSSGM" "lowerLeft" "R90" "stick" 0.0625 nil)
schCreateWire(cv "route" "full" '((3.312 0.875) (3.312 1.625)) 0 0 0 nil nil)
schCreateWireLabel(cv nil '(3.312 1.125) "GIOL" "lowerLeft" "R90" "stick" 0.0625 nil)
schCreateWire(cv "route" "full" '((2.562 0.875) (2.562 1.625)) 0 0 0 nil nil)
schCreateWireLabel(cv nil '(2.562 1.125) "VDDGM" "lowerLeft" "R90" "stick" 0.0625 nil)
dbCreateInst(cv pdb3ac_v_gMaster "IB13_bottom1" '(5.1875 0) "R0")
schCreateWire(cv "route" "full" '((5.000 0.000) (5.000 -0.750)) 0 0 0 nil nil)
schCreateWireLabel(cv nil '(5.000 -0.250) "IB13" "lowerRight" "R90" "stick" 0.0625 nil)
schCreatePin(cv nil "IB13" "inputOutput" nil '(5.000 -0.750) "R90")
schCreateWire(cv "route" "full" '((4.938 0.875) (4.938 1.625)) 0 0 0 nil nil)
schCreateWireLabel(cv nil '(4.938 1.125) "VSSGM" "lowerLeft" "R90" "stick" 0.0625 nil)
schCreateWire(cv "route" "full" '((5.312 0.875) (5.312 1.625)) 0 0 0 nil nil)
schCreateWireLabel(cv nil '(5.312 1.125) "GIOL" "lowerLeft" "R90" "stick" 0.0625 nil)
schCreateWire(cv "route" "full" '((4.562 0.875) (4.562 1.625)) 0 0 0 nil nil)
schCreateWireLabel(cv nil '(4.562 1.125) "VDDGM" "lowerLeft" "R90" "stick" 0.0625 nil)
dbCreateInst(cv pdb3ac_v_gMaster "IB14_bottom2" '(7.1875 0) "R0")
schCreateWire(cv "route" "full" '((7.000 0.000) (7.000 -0.750)) 0 0 0 nil nil)
schCreateWireLabel(cv nil '(7.000 -0.250) "IB14" "lowerRight" "R90" "stick" 0.0625 nil)
schCreatePin(cv nil "IB14" "inputOutput" nil '(7.000 -0.750) "R90")
schCreateWire(cv "route" "full" '((6.938 0.875) (6.938 1.625)) 0 0 0 nil nil)
schCreateWireLabel(cv nil '(6.938 1.125) "VSSGM" "lowerLeft" "R90" "stick" 0.0625 nil)
schCreateWire(cv "route" "full" '((7.312 0.875) (7.312 1.625)) 0 0 0 nil nil)
schCreateWireLabel(cv nil '(7.312 1.125) "GIOL" "lowerLeft" "R90" "stick" 0.0625 nil)
schCreateWire(cv "route" "full" '((6.562 0.875) (6.562 1.625)) 0 0 0 nil nil)
schCreateWireLabel(cv nil '(6.562 1.125) "VDDGM" "lowerLeft" "R90" "stick" 0.0625 nil)
dbCreateInst(cv pdb3ac_v_gMaster "IB15_bottom3" '(9.1875 0) "R0")
schCreateWire(cv "route" "full" '((8.999 0.000) (8.999 -0.750)) 0 0 0 nil nil)
schCreateWireLabel(cv nil '(8.999 -0.250) "IB15" "lowerRight" "R90" "stick" 0.0625 nil)
schCreatePin(cv nil "IB15" "inputOutput" nil '(8.999 -0.750) "R90")
schCreateWire(cv "route" "full" '((8.938 0.875) (8.938 1.625)) 0 0 0 nil nil)
schCreateWireLabel(cv nil '(8.938 1.125) "VSSGM" "lowerLeft" "R90" "stick" 0.0625 nil)
schCreateWire(cv "route" "full" '((9.312 0.875) (9.312 1.625)) 0 0 0 nil nil)
schCreateWireLabel(cv nil '(9.312 1.125) "GIOL" "lowerLeft" "R90" "stick" 0.0625 nil)
schCreateWire(cv "route" "full" '((8.562 0.875) (8.562 1.625)) 0 0 0 nil nil)
schCreateWireLabel(cv nil '(8.562 1.125) "VDDGM" "lowerLeft" "R90" "stick" 0.0625 nil)
dbCreateInst(cv pdb3ac_v_gMaster "IB16_bottom4" '(11.1875 0) "R0")
schCreateWire(cv "route" "full" '((10.999 0.000) (10.999 -0.750)) 0 0 0 nil nil)
schCreateWireLabel(cv nil '(10.999 -0.250) "IB16" "lowerRight" "R90" "stick" 0.0625 nil)
schCreatePin(cv nil "IB16" "inputOutput" nil '(10.999 -0.750) "R90")
schCreateWire(cv "route" "full" '((10.938 0.875) (10.938 1.625)) 0 0 0 nil nil)
schCreateWireLabel(cv nil '(10.938 1.125) "VSSGM" "lowerLeft" "R90" "stick" 0.0625 nil)
schCreateWire(cv "route" "full" '((11.312 0.875) (11.312 1.625)) 0 0 0 nil nil)
schCreateWireLabel(cv nil '(11.312 1.125) "GIOL" "lowerLeft" "R90" "stick" 0.0625 nil)
schCreateWire(cv "route" "full" '((10.562 0.875) (10.562 1.625)) 0 0 0 nil nil)
schCreateWireLabel(cv nil '(10.562 1.125) "VDDGM" "lowerLeft" "R90" "stick" 0.0625 nil)
dbCreateInst(cv pdb3ac_v_gMaster "IB17_bottom5" '(13.1875 0) "R0")
schCreateWire(cv "route" "full" '((12.999 0.000) (12.999 -0.750)) 0 0 0 nil nil)
schCreateWireLabel(cv nil '(12.999 -0.250) "IB17" "lowerRight" "R90" "stick" 0.0625 nil)
schCreatePin(cv nil "IB17" "inputOutput" nil '(12.999 -0.750) "R90")
schCreateWire(cv "route" "full" '((12.938 0.875) (12.938 1.625)) 0 0 0 nil nil)
schCreateWireLabel(cv nil '(12.938 1.125) "VSSGM" "lowerLeft" "R90" "stick" 0.0625 nil)
schCreateWire(cv "route" "full" '((13.312 0.875) (13.312 1.625)) 0 0 0 nil nil)
schCreateWireLabel(cv nil '(13.312 1.125) "GIOL" "lowerLeft" "R90" "stick" 0.0625 nil)
schCreateWire(cv "route" "full" '((12.562 0.875) (12.562 1.625)) 0 0 0 nil nil)
schCreateWireLabel(cv nil '(12.562 1.125) "VDDGM" "lowerLeft" "R90" "stick" 0.0625 nil)
dbCreateInst(cv pdb3ac_v_gMaster "IB18_bottom6" '(15.1875 0) "R0")
schCreateWire(cv "route" "full" '((14.999 0.000) (14.999 -0.750)) 0 0 0 nil nil)
schCreateWireLabel(cv nil '(14.999 -0.250) "IB18" "lowerRight" "R90" "stick" 0.0625 nil)
schCreatePin(cv nil "IB18" "inputOutput" nil '(14.999 -0.750) "R90")
schCreateWire(cv "route" "full" '((14.938 0.875) (14.938 1.625)) 0 0 0 nil nil)
schCreateWireLabel(cv nil '(14.938 1.125) "VSSGM" "lowerLeft" "R90" "stick" 0.0625 nil)
schCreateWire(cv "route" "full" '((15.312 0.875) (15.312 1.625)) 0 0 0 nil nil)
schCreateWireLabel(cv nil '(15.312 1.125) "GIOL" "lowerLeft" "R90" "stick" 0.0625 nil)
schCreateWire(cv "route" "full" '((14.562 0.875) (14.562 1.625)) 0 0 0 nil nil)
schCreateWireLabel(cv nil '(14.562 1.125) "VDDGM" "lowerLeft" "R90" "stick" 0.0625 nil)
dbCreateInst(cv pdb3ac_v_gMaster "IB19_bottom7" '(17.1875 0) "R0")
schCreateWire(cv "route" "full" '((17.000 0.000) (17.000 -0.750)) 0 0 0 nil nil)
schCreateWireLabel(cv nil '(17.000 -0.250) "IB19" "lowerRight" "R90" "stick" 0.0625 nil)
schCreatePin(cv nil "IB19" "inputOutput" nil '(17.000 -0.750) "R90")
schCreateWire(cv "route" "full" '((16.938 0.875) (16.938 1.625)) 0 0 0 nil nil)
schCreateWireLabel(cv nil '(16.938 1.125) "VSSGM" "lowerLeft" "R90" "stick" 0.0625 nil)
schCreateWire(cv "route" "full" '((17.312 0.875) (17.312 1.625)) 0 0 0 nil nil)
schCreateWireLabel(cv nil '(17.312 1.125) "GIOL" "lowerLeft" "R90" "stick" 0.0625 nil)
schCreateWire(cv "route" "full" '((16.562 0.875) (16.562 1.625)) 0 0 0 nil nil)
schCreateWireLabel(cv nil '(16.562 1.125) "VDDGM" "lowerLeft" "R90" "stick" 0.0625 nil)
pvdd3ac_v_gMaster = dbOpenCellView("tphn28hpcpgv18" "PVDD3AC_V_G" "symbol")
dbCreateInst(cv pvdd3ac_v_gMaster "VDDGM_bottom8" '(19.1875 0) "R0")
schCreateWire(cv "route" "full" '((18.562 0.875) (18.562 1.625)) 0 0 0 nil nil)
schCreateWireLabel(cv nil '(18.562 1.125) "VDDGM_CORE" "lowerLeft" "R90" "stick" 0.0625 nil)
schCreatePin(cv nil "VDDGM_CORE" "inputOutput" nil '(18.562 1.625) "R270")
schCreateWire(cv "route" "full" '((18.938 0.875) (18.938 1.625)) 0 0 0 nil nil)
schCreateWireLabel(cv nil '(18.938 1.125) "VSSGM" "lowerLeft" "R90" "stick" 0.0625 nil)
schCreateWire(cv "route" "full" '((19.312 0.875) (19.312 1.625)) 0 0 0 nil nil)
schCreateWireLabel(cv nil '(19.312 1.125) "GIOL" "lowerLeft" "R90" "stick" 0.0625 nil)
schCreateWire(cv "route" "full" '((19.000 0.000) (19.000 -0.750)) 0 0 0 nil nil)
schCreateWireLabel(cv nil '(19.000 -0.250) "VDDGM" "lowerRight" "R90" "stick" 0.0625 nil)
schCreatePin(cv nil "VDDGM" "inputOutput" nil '(19.000 -0.750) "R90")
pvss3ac_v_gMaster = dbOpenCellView("tphn28hpcpgv18" "PVSS3AC_V_G" "symbol")
dbCreateInst(cv pvss3ac_v_gMaster "VSSGM_bottom9" '(21.1875 0) "R0")
schCreateWire(cv "route" "full" '((21.000 0.000) (21.000 -0.750)) 0 0 0 nil nil)
schCreateWireLabel(cv nil '(21.000 -0.250) "VSSGM" "lowerRight" "R90" "stick" 0.0625 nil)
schCreatePin(cv nil "VSSGM" "inputOutput" nil '(21.000 -0.750) "R90")
schCreateWire(cv "route" "full" '((21.312 0.875) (21.312 1.625)) 0 0 0 nil nil)
schCreateWireLabel(cv nil '(21.312 1.125) "GIOL" "lowerLeft" "R90" "stick" 0.0625 nil)
schCreateWire(cv "route" "full" '((20.562 0.875) (20.562 1.625)) 0 0 0 nil nil)
schCreateWireLabel(cv nil '(20.562 1.125) "VSSGM_CORE" "lowerLeft" "R90" "stick" 0.0625 nil)
schCreatePin(cv nil "VSSGM_CORE" "inputOutput" nil '(20.562 1.625) "R270")
schCreateWire(cv "route" "full" '((20.938 0.875) (20.938 1.625)) 0 0 0 nil nil)
schCreateWireLabel(cv nil '(20.938 1.125) "VDDGM" "lowerLeft" "R90" "stick" 0.0625 nil)
dbCreateInst(cv pdb3ac_v_gMaster "VCMGM_bottom10" '(23.1875 0) "R0")
schCreateWire(cv "route" "full" '((23.000 0.000) (23.000 -0.750)) 0 0 0 nil nil)
schCreateWireLabel(cv nil '(23.000 -0.250) "VCMGM" "lowerRight" "R90" "stick" 0.0625 nil)
schCreatePin(cv nil "VCMGM" "inputOutput" nil '(23.000 -0.750) "R90")
schCreateWire(cv "route" "full" '((22.938 0.875) (22.938 1.625)) 0 0 0 nil nil)
schCreateWireLabel(cv nil '(22.938 1.125) "VSSGM" "lowerLeft" "R90" "stick" 0.0625 nil)
schCreateWire(cv "route" "full" '((23.312 0.875) (23.312 1.625)) 0 0 0 nil nil)
schCreateWireLabel(cv nil '(23.312 1.125) "GIOL" "lowerLeft" "R90" "stick" 0.0625 nil)
schCreateWire(cv "route" "full" '((22.562 0.875) (22.562 1.625)) 0 0 0 nil nil)
schCreateWireLabel(cv nil '(22.562 1.125) "VDDGM" "lowerLeft" "R90" "stick" 0.0625 nil)
pvdd1ac_v_gMaster = dbOpenCellView("tphn28hpcpgv18" "PVDD1AC_V_G" "symbol")
dbCreateInst(cv pvdd1ac_v_gMaster "VDDA09_bottom11" '(25.1875 0) "R0")
schCreateWire(cv "route" "full" '((24.938 0.875) (24.938 1.625)) 0 0 0 nil nil)
schCreateWireLabel(cv nil '(24.938 1.125) "VSSGM" "lowerLeft" "R90" "stick" 0.0625 nil)
schCreateWire(cv "route" "full" '((25.312 0.875) (25.312 1.625)) 0 0 0 nil nil)
schCreateWireLabel(cv nil '(25.312 1.125) "GIOL" "lowerLeft" "R90" "stick" 0.0625 nil)
schCreateWire(cv "route" "full" '((25.000 0.000) (25.000 -0.750)) 0 0 0 nil nil)
schCreateWireLabel(cv nil '(25.000 -0.250) "VDDA09" "lowerRight" "R90" "stick" 0.0625 nil)
schCreatePin(cv nil "VDDA09" "inputOutput" nil '(25.000 -0.750) "R90")
schCreateWire(cv "route" "full" '((24.562 0.875) (24.562 1.625)) 0 0 0 nil nil)
schCreateWireLabel(cv nil '(24.562 1.125) "VDDGM" "lowerLeft" "R90" "stick" 0.0625 nil)
pvss1ac_v_gMaster = dbOpenCellView("tphn28hpcpgv18" "PVSS1AC_V_G" "symbol")
dbCreateInst(cv pvss1ac_v_gMaster "VSSA_bottom12" '(27.1875 0) "R0")
schCreateWire(cv "route" "full" '((27.000 0.000) (27.000 -0.750)) 0 0 0 nil nil)
schCreateWireLabel(cv nil '(27.000 -0.250) "VSSA" "lowerRight" "R90" "stick" 0.0625 nil)
schCreatePin(cv nil "VSSA" "inputOutput" nil '(27.000 -0.750) "R90")
schCreateWire(cv "route" "full" '((26.938 0.875) (26.938 1.625)) 0 0 0 nil nil)
schCreateWireLabel(cv nil '(26.938 1.125) "VSSGM" "lowerLeft" "R90" "stick" 0.0625 nil)
schCreateWire(cv "route" "full" '((27.312 0.875) (27.312 1.625)) 0 0 0 nil nil)
schCreateWireLabel(cv nil '(27.312 1.125) "GIOL" "lowerLeft" "R90" "stick" 0.0625 nil)
schCreateWire(cv "route" "full" '((26.562 0.875) (26.562 1.625)) 0 0 0 nil nil)
schCreateWireLabel(cv nil '(26.562 1.125) "VDDGM" "lowerLeft" "R90" "stick" 0.0625 nil)
dbCreateInst(cv pvdd1ac_v_gMaster "VDDA18_bottom13" '(29.1875 0) "R0")
schCreateWire(cv "route" "full" '((28.938 0.875) (28.938 1.625)) 0 0 0 nil nil)
schCreateWireLabel(cv nil '(28.938 1.125) "VSSGM" "lowerLeft" "R90" "stick" 0.0625 nil)
schCreateWire(cv "route" "full" '((29.312 0.875) (29.312 1.625)) 0 0 0 nil nil)
schCreateWireLabel(cv nil '(29.312 1.125) "GIOL" "lowerLeft" "R90" "stick" 0.0625 nil)
schCreateWire(cv "route" "full" '((29.000 0.000) (29.000 -0.750)) 0 0 0 nil nil)
schCreateWireLabel(cv nil '(29.000 -0.250) "VDDA18" "lowerRight" "R90" "stick" 0.0625 nil)
schCreatePin(cv nil "VDDA18" "inputOutput" nil '(29.000 -0.750) "R90")
schCreateWire(cv "route" "full" '((28.562 0.875) (28.562 1.625)) 0 0 0 nil nil)
schCreateWireLabel(cv nil '(28.562 1.125) "VDDGM" "lowerLeft" "R90" "stick" 0.0625 nil)
dbCreateInst(cv pdb3ac_v_gMaster "VCM_bottom14" '(31.1875 0) "R0")
schCreateWire(cv "route" "full" '((31.000 0.000) (31.000 -0.750)) 0 0 0 nil nil)
schCreateWireLabel(cv nil '(31.000 -0.250) "VCM" "lowerRight" "R90" "stick" 0.0625 nil)
schCreatePin(cv nil "VCM" "inputOutput" nil '(31.000 -0.750) "R90")
schCreateWire(cv "route" "full" '((30.938 0.875) (30.938 1.625)) 0 0 0 nil nil)
schCreateWireLabel(cv nil '(30.938 1.125) "VSSGM" "lowerLeft" "R90" "stick" 0.0625 nil)
schCreateWire(cv "route" "full" '((31.312 0.875) (31.312 1.625)) 0 0 0 nil nil)
schCreateWireLabel(cv nil '(31.312 1.125) "GIOL" "lowerLeft" "R90" "stick" 0.0625 nil)
schCreateWire(cv "route" "full" '((30.562 0.875) (30.562 1.625)) 0 0 0 nil nil)
schCreateWireLabel(cv nil '(30.562 1.125) "VDDGM" "lowerLeft" "R90" "stick" 0.0625 nil)
dbCreateInst(cv pvss1ac_v_gMaster "GND_bottom15" '(33.1875 0) "R0")
schCreateWire(cv "route" "full" '((32.999 0.000) (32.999 -0.750)) 0 0 0 nil nil)
schCreateWireLabel(cv nil '(32.999 -0.250) "GND" "lowerRight" "R90" "stick" 0.0625 nil)
schCreatePin(cv nil "GND" "inputOutput" nil '(32.999 -0.750) "R90")
schCreateWire(cv "route" "full" '((32.938 0.875) (32.938 1.625)) 0 0 0 nil nil)
schCreateWireLabel(cv nil '(32.938 1.125) "VSSGM" "lowerLeft" "R90" "stick" 0.0625 nil)
schCreateWire(cv "route" "full" '((33.312 0.875) (33.312 1.625)) 0 0 0 nil nil)
schCreateWireLabel(cv nil '(33.312 1.125) "GIOL" "lowerLeft" "R90" "stick" 0.0625 nil)
schCreateWire(cv "route" "full" '((32.562 0.875) (32.562 1.625)) 0 0 0 nil nil)
schCreateWireLabel(cv nil '(32.562 1.125) "VDDGM" "lowerLeft" "R90" "stick" 0.0625 nil)
dbCreateInst(cv pdb3ac_v_gMaster "VIP_bottom16" '(35.1875 0) "R0")
schCreateWire(cv "route" "full" '((34.999 0.000) (34.999 -0.750)) 0 0 0 nil nil)
schCreateWireLabel(cv nil '(34.999 -0.250) "VIP" "lowerRight" "R90" "stick" 0.0625 nil)
schCreatePin(cv nil "VIP" "inputOutput" nil '(34.999 -0.750) "R90")
schCreateWire(cv "route" "full" '((34.938 0.875) (34.938 1.625)) 0 0 0 nil nil)
schCreateWireLabel(cv nil '(34.938 1.125) "VSSGM" "lowerLeft" "R90" "stick" 0.0625 nil)
schCreateWire(cv "route" "full" '((35.312 0.875) (35.312 1.625)) 0 0 0 nil nil)
schCreateWireLabel(cv nil '(35.312 1.125) "GIOL" "lowerLeft" "R90" "stick" 0.0625 nil)
schCreateWire(cv "route" "full" '((34.562 0.875) (34.562 1.625)) 0 0 0 nil nil)
schCreateWireLabel(cv nil '(34.562 1.125) "VDDGM" "lowerLeft" "R90" "stick" 0.0625 nil)
dbCreateInst(cv pdb3ac_v_gMaster "VIN_bottom17" '(37.1875 0) "R0")
schCreateWire(cv "route" "full" '((36.999 0.000) (36.999 -0.750)) 0 0 0 nil nil)
schCreateWireLabel(cv nil '(36.999 -0.250) "VIN" "lowerRight" "R90" "stick" 0.0625 nil)
schCreatePin(cv nil "VIN" "inputOutput" nil '(36.999 -0.750) "R90")
schCreateWire(cv "route" "full" '((36.938 0.875) (36.938 1.625)) 0 0 0 nil nil)
schCreateWireLabel(cv nil '(36.938 1.125) "VSSGM" "lowerLeft" "R90" "stick" 0.0625 nil)
schCreateWire(cv "route" "full" '((37.312 0.875) (37.312 1.625)) 0 0 0 nil nil)
schCreateWireLabel(cv nil '(37.312 1.125) "GIOL" "lowerLeft" "R90" "stick" 0.0625 nil)
schCreateWire(cv "route" "full" '((36.562 0.875) (36.562 1.625)) 0 0 0 nil nil)
schCreateWireLabel(cv nil '(36.562 1.125) "VDDGM" "lowerLeft" "R90" "stick" 0.0625 nil)
pvss1ac_h_gMaster = dbOpenCellView("tphn28hpcpgv18" "PVSS1AC_H_G" "symbol")
dbCreateInst(cv pvss1ac_h_gMaster "GND_right0" '(40.0 3.1875) "R90")
schCreateWire(cv "route" "full" '((40.000 2.999) (40.750 2.999)) 0 0 0 nil nil)
schCreateWireLabel(cv nil '(40.250 2.999) "GND" "lowerLeft" "R0" "stick" 0.0625 nil)
schCreatePin(cv nil "GND" "inputOutput" nil '(40.750 2.999) "R180")
schCreateWire(cv "route" "full" '((39.125 2.938) (38.375 2.938)) 0 0 0 nil nil)
schCreateWireLabel(cv nil '(38.875 2.938) "VSSGM" "lowerRight" "R0" "stick" 0.0625 nil)
schCreateWire(cv "route" "full" '((39.125 3.312) (38.375 3.312)) 0 0 0 nil nil)
schCreateWireLabel(cv nil '(38.875 3.312) "GIOL" "lowerRight" "R0" "stick" 0.0625 nil)
schCreateWire(cv "route" "full" '((39.125 2.562) (38.375 2.562)) 0 0 0 nil nil)
schCreateWireLabel(cv nil '(38.875 2.562) "VDDGM" "lowerRight" "R0" "stick" 0.0625 nil)
dbCreateInst(cv pdb3ac_h_gMaster "VCM09_right1" '(40.0 5.1875) "R90")
schCreateWire(cv "route" "full" '((40.000 5.000) (40.750 5.000)) 0 0 0 nil nil)
schCreateWireLabel(cv nil '(40.250 5.000) "VCM09" "lowerLeft" "R0" "stick" 0.0625 nil)
schCreatePin(cv nil "VCM09" "inputOutput" nil '(40.750 5.000) "R180")
schCreateWire(cv "route" "full" '((39.125 4.938) (38.375 4.938)) 0 0 0 nil nil)
schCreateWireLabel(cv nil '(38.875 4.938) "VSSGM" "lowerRight" "R0" "stick" 0.0625 nil)
schCreateWire(cv "route" "full" '((39.125 5.312) (38.375 5.312)) 0 0 0 nil nil)
schCreateWireLabel(cv nil '(38.875 5.312) "GIOL" "lowerRight" "R0" "stick" 0.0625 nil)
schCreateWire(cv "route" "full" '((39.125 4.562) (38.375 4.562)) 0 0 0 nil nil)
schCreateWireLabel(cv nil '(38.875 4.562) "VDDGM" "lowerRight" "R0" "stick" 0.0625 nil)
pddw16sdgz_h_gMaster = dbOpenCellView("tphn28hpcpgv18" "PDDW16SDGZ_H_G" "symbol")
dbCreateInst(cv pddw16sdgz_h_gMaster "D1_right2" '(40.0 6.3125) "R90")
schCreateWire(cv "route" "full" '((39.000 6.438) (38.250 6.438)) 0 0 0 nil nil)
schCreateWireLabel(cv nil '(38.750 6.438) "VIOL" "lowerRight" "R0" "stick" 0.0625 nil)
noConnMaster = dbOpenCellView("basic" "noConn" "symbol")
schCreateWire(cv "route" "full" '((39.000 6.562) (38.250 6.562)) 0 0 0 nil nil)
dbCreateInst(cv noConnMaster "noConn_D1_right2_C" '(38.250 6.562) "R270")
schCreateWire(cv "route" "full" '((39.000 6.188) (38.250 6.188)) 0 0 0 nil nil)
schCreateWireLabel(cv nil '(38.750 6.188) "GIOL" "lowerRight" "R0" "stick" 0.0625 nil)
schCreateWire(cv "route" "full" '((39.000 6.062) (38.250 6.062)) 0 0 0 nil nil)
schCreateWireLabel(cv nil '(38.750 6.062) "D1_CORE" "lowerRight" "R0" "stick" 0.0625 nil)
schCreatePin(cv nil "D1_CORE" "inputOutput" nil '(38.250 6.062) "R0")
schCreateWire(cv "route" "full" '((40.000 7.000) (40.750 7.000)) 0 0 0 nil nil)
schCreateWireLabel(cv nil '(40.250 7.000) "D1" "lowerLeft" "R0" "stick" 0.0625 nil)
schCreatePin(cv nil "D1" "inputOutput" nil '(40.750 7.000) "R180")
schCreateWire(cv "route" "full" '((39.000 6.688) (38.250 6.688)) 0 0 0 nil nil)
schCreateWireLabel(cv nil '(38.750 6.688) "POC" "lowerRight" "R0" "stick" 0.0625 nil)
schCreateWire(cv "route" "full" '((39.000 6.875) (38.250 6.875)) 0 0 0 nil nil)
schCreateWireLabel(cv nil '(38.750 6.875) "VIOL" "lowerRight" "R0" "stick" 0.0625 nil)
schCreateWire(cv "route" "full" '((39.000 7.062) (38.250 7.062)) 0 0 0 nil nil)
schCreateWireLabel(cv nil '(38.750 7.062) "GIOL" "lowerRight" "R0" "stick" 0.0625 nil)
schCreateWire(cv "route" "full" '((39.000 7.250) (38.250 7.250)) 0 0 0 nil nil)
schCreateWireLabel(cv nil '(38.750 7.250) "VIOH" "lowerRight" "R0" "stick" 0.0625 nil)
schCreateWire(cv "route" "full" '((39.000 7.625) (38.250 7.625)) 0 0 0 nil nil)
schCreateWireLabel(cv nil '(38.750 7.625) "GIOH" "lowerRight" "R0" "stick" 0.0625 nil)
dbCreateInst(cv pddw16sdgz_h_gMaster "D2_right3" '(40.0 8.3125) "R90")
schCreateWire(cv "route" "full" '((39.000 8.438) (38.250 8.438)) 0 0 0 nil nil)
schCreateWireLabel(cv nil '(38.750 8.438) "VIOL" "lowerRight" "R0" "stick" 0.0625 nil)
schCreateWire(cv "route" "full" '((39.000 8.562) (38.250 8.562)) 0 0 0 nil nil)
dbCreateInst(cv noConnMaster "noConn_D2_right3_C" '(38.250 8.562) "R270")
schCreateWire(cv "route" "full" '((39.000 8.188) (38.250 8.188)) 0 0 0 nil nil)
schCreateWireLabel(cv nil '(38.750 8.188) "GIOL" "lowerRight" "R0" "stick" 0.0625 nil)
schCreateWire(cv "route" "full" '((39.000 8.062) (38.250 8.062)) 0 0 0 nil nil)
schCreateWireLabel(cv nil '(38.750 8.062) "D2_CORE" "lowerRight" "R0" "stick" 0.0625 nil)
schCreatePin(cv nil "D2_CORE" "inputOutput" nil '(38.250 8.062) "R0")
schCreateWire(cv "route" "full" '((40.000 9.001) (40.750 9.001)) 0 0 0 nil nil)
schCreateWireLabel(cv nil '(40.250 9.001) "D2" "lowerLeft" "R0" "stick" 0.0625 nil)
schCreatePin(cv nil "D2" "inputOutput" nil '(40.750 9.001) "R180")
schCreateWire(cv "route" "full" '((39.000 8.688) (38.250 8.688)) 0 0 0 nil nil)
schCreateWireLabel(cv nil '(38.750 8.688) "POC" "lowerRight" "R0" "stick" 0.0625 nil)
schCreateWire(cv "route" "full" '((39.000 8.874) (38.250 8.874)) 0 0 0 nil nil)
schCreateWireLabel(cv nil '(38.750 8.874) "VIOL" "lowerRight" "R0" "stick" 0.0625 nil)
schCreateWire(cv "route" "full" '((39.000 9.062) (38.250 9.062)) 0 0 0 nil nil)
schCreateWireLabel(cv nil '(38.750 9.062) "GIOL" "lowerRight" "R0" "stick" 0.0625 nil)
schCreateWire(cv "route" "full" '((39.000 9.251) (38.250 9.251)) 0 0 0 nil nil)
schCreateWireLabel(cv nil '(38.750 9.251) "VIOH" "lowerRight" "R0" "stick" 0.0625 nil)
schCreateWire(cv "route" "full" '((39.000 9.624) (38.250 9.624)) 0 0 0 nil nil)
schCreateWireLabel(cv nil '(38.750 9.624) "GIOH" "lowerRight" "R0" "stick" 0.0625 nil)
dbCreateInst(cv pddw16sdgz_h_gMaster "D3_right4" '(40.0 10.3125) "R90")
schCreateWire(cv "route" "full" '((39.000 10.438) (38.250 10.438)) 0 0 0 nil nil)
schCreateWireLabel(cv nil '(38.750 10.438) "VIOL" "lowerRight" "R0" "stick" 0.0625 nil)
schCreateWire(cv "route" "full" '((39.000 10.562) (38.250 10.562)) 0 0 0 nil nil)
dbCreateInst(cv noConnMaster "noConn_D3_right4_C" '(38.250 10.562) "R270")
schCreateWire(cv "route" "full" '((39.000 10.188) (38.250 10.188)) 0 0 0 nil nil)
schCreateWireLabel(cv nil '(38.750 10.188) "GIOL" "lowerRight" "R0" "stick" 0.0625 nil)
schCreateWire(cv "route" "full" '((39.000 10.062) (38.250 10.062)) 0 0 0 nil nil)
schCreateWireLabel(cv nil '(38.750 10.062) "D3_CORE" "lowerRight" "R0" "stick" 0.0625 nil)
schCreatePin(cv nil "D3_CORE" "inputOutput" nil '(38.250 10.062) "R0")
schCreateWire(cv "route" "full" '((40.000 11.001) (40.750 11.001)) 0 0 0 nil nil)
schCreateWireLabel(cv nil '(40.250 11.001) "D3" "lowerLeft" "R0" "stick" 0.0625 nil)
schCreatePin(cv nil "D3" "inputOutput" nil '(40.750 11.001) "R180")
schCreateWire(cv "route" "full" '((39.000 10.688) (38.250 10.688)) 0 0 0 nil nil)
schCreateWireLabel(cv nil '(38.750 10.688) "POC" "lowerRight" "R0" "stick" 0.0625 nil)
schCreateWire(cv "route" "full" '((39.000 10.874) (38.250 10.874)) 0 0 0 nil nil)
schCreateWireLabel(cv nil '(38.750 10.874) "VIOL" "lowerRight" "R0" "stick" 0.0625 nil)
schCreateWire(cv "route" "full" '((39.000 11.062) (38.250 11.062)) 0 0 0 nil nil)
schCreateWireLabel(cv nil '(38.750 11.062) "GIOL" "lowerRight" "R0" "stick" 0.0625 nil)
schCreateWire(cv "route" "full" '((39.000 11.251) (38.250 11.251)) 0 0 0 nil nil)
schCreateWireLabel(cv nil '(38.750 11.251) "VIOH" "lowerRight" "R0" "stick" 0.0625 nil)
schCreateWire(cv "route" "full" '((39.000 11.624) (38.250 11.624)) 0 0 0 nil nil)
schCreateWireLabel(cv nil '(38.750 11.624) "GIOH" "lowerRight" "R0" "stick" 0.0625 nil)
dbCreateInst(cv pddw16sdgz_h_gMaster "D4_right5" '(40.0 12.3125) "R90")
schCreateWire(cv "route" "full" '((39.000 12.438) (38.250 12.438)) 0 0 0 nil nil)
schCreateWireLabel(cv nil '(38.750 12.438) "VIOL" "lowerRight" "R0" "stick" 0.0625 nil)
schCreateWire(cv "route" "full" '((39.000 12.562) (38.250 12.562)) 0 0 0 nil nil)
dbCreateInst(cv noConnMaster "noConn_D4_right5_C" '(38.250 12.562) "R270")
schCreateWire(cv "route" "full" '((39.000 12.188) (38.250 12.188)) 0 0 0 nil nil)
schCreateWireLabel(cv nil '(38.750 12.188) "GIOL" "lowerRight" "R0" "stick" 0.0625 nil)
schCreateWire(cv "route" "full" '((39.000 12.062) (38.250 12.062)) 0 0 0 nil nil)
schCreateWireLabel(cv nil '(38.750 12.062) "D4_CORE" "lowerRight" "R0" "stick" 0.0625 nil)
schCreatePin(cv nil "D4_CORE" "inputOutput" nil '(38.250 12.062) "R0")
schCreateWire(cv "route" "full" '((40.000 13.001) (40.750 13.001)) 0 0 0 nil nil)
schCreateWireLabel(cv nil '(40.250 13.001) "D4" "lowerLeft" "R0" "stick" 0.0625 nil)
schCreatePin(cv nil "D4" "inputOutput" nil '(40.750 13.001) "R180")
schCreateWire(cv "route" "full" '((39.000 12.688) (38.250 12.688)) 0 0 0 nil nil)
schCreateWireLabel(cv nil '(38.750 12.688) "POC" "lowerRight" "R0" "stick" 0.0625 nil)
schCreateWire(cv "route" "full" '((39.000 12.874) (38.250 12.874)) 0 0 0 nil nil)
schCreateWireLabel(cv nil '(38.750 12.874) "VIOL" "lowerRight" "R0" "stick" 0.0625 nil)
schCreateWire(cv "route" "full" '((39.000 13.062) (38.250 13.062)) 0 0 0 nil nil)
schCreateWireLabel(cv nil '(38.750 13.062) "GIOL" "lowerRight" "R0" "stick" 0.0625 nil)
schCreateWire(cv "route" "full" '((39.000 13.251) (38.250 13.251)) 0 0 0 nil nil)
schCreateWireLabel(cv nil '(38.750 13.251) "VIOH" "lowerRight" "R0" "stick" 0.0625 nil)
schCreateWire(cv "route" "full" '((39.000 13.624) (38.250 13.624)) 0 0 0 nil nil)
schCreateWireLabel(cv nil '(38.750 13.624) "GIOH" "lowerRight" "R0" "stick" 0.0625 nil)
dbCreateInst(cv pddw16sdgz_h_gMaster "D5_right6" '(40.0 14.3125) "R90")
schCreateWire(cv "route" "full" '((39.000 14.438) (38.250 14.438)) 0 0 0 nil nil)
schCreateWireLabel(cv nil '(38.750 14.438) "VIOL" "lowerRight" "R0" "stick" 0.0625 nil)
schCreateWire(cv "route" "full" '((39.000 14.562) (38.250 14.562)) 0 0 0 nil nil)
dbCreateInst(cv noConnMaster "noConn_D5_right6_C" '(38.250 14.562) "R270")
schCreateWire(cv "route" "full" '((39.000 14.188) (38.250 14.188)) 0 0 0 nil nil)
schCreateWireLabel(cv nil '(38.750 14.188) "GIOL" "lowerRight" "R0" "stick" 0.0625 nil)
schCreateWire(cv "route" "full" '((39.000 14.062) (38.250 14.062)) 0 0 0 nil nil)
schCreateWireLabel(cv nil '(38.750 14.062) "D5_CORE" "lowerRight" "R0" "stick" 0.0625 nil)
schCreatePin(cv nil "D5_CORE" "inputOutput" nil '(38.250 14.062) "R0")
schCreateWire(cv "route" "full" '((40.000 15.001) (40.750 15.001)) 0 0 0 nil nil)
schCreateWireLabel(cv nil '(40.250 15.001) "D5" "lowerLeft" "R0" "stick" 0.0625 nil)
schCreatePin(cv nil "D5" "inputOutput" nil '(40.750 15.001) "R180")
schCreateWire(cv "route" "full" '((39.000 14.688) (38.250 14.688)) 0 0 0 nil nil)
schCreateWireLabel(cv nil '(38.750 14.688) "POC" "lowerRight" "R0" "stick" 0.0625 nil)
schCreateWire(cv "route" "full" '((39.000 14.874) (38.250 14.874)) 0 0 0 nil nil)
schCreateWireLabel(cv nil '(38.750 14.874) "VIOL" "lowerRight" "R0" "stick" 0.0625 nil)
schCreateWire(cv "route" "full" '((39.000 15.062) (38.250 15.062)) 0 0 0 nil nil)
schCreateWireLabel(cv nil '(38.750 15.062) "GIOL" "lowerRight" "R0" "stick" 0.0625 nil)
schCreateWire(cv "route" "full" '((39.000 15.251) (38.250 15.251)) 0 0 0 nil nil)
schCreateWireLabel(cv nil '(38.750 15.251) "VIOH" "lowerRight" "R0" "stick" 0.0625 nil)
schCreateWire(cv "route" "full" '((39.000 15.624) (38.250 15.624)) 0 0 0 nil nil)
schCreateWireLabel(cv nil '(38.750 15.624) "GIOH" "lowerRight" "R0" "stick" 0.0625 nil)
dbCreateInst(cv pddw16sdgz_h_gMaster "D6_right7" '(40.0 16.3125) "R90")
schCreateWire(cv "route" "full" '((39.000 16.438) (38.250 16.438)) 0 0 0 nil nil)
schCreateWireLabel(cv nil '(38.750 16.438) "VIOL" "lowerRight" "R0" "stick" 0.0625 nil)
schCreateWire(cv "route" "full" '((39.000 16.562) (38.250 16.562)) 0 0 0 nil nil)
dbCreateInst(cv noConnMaster "noConn_D6_right7_C" '(38.250 16.562) "R270")
schCreateWire(cv "route" "full" '((39.000 16.188) (38.250 16.188)) 0 0 0 nil nil)
schCreateWireLabel(cv nil '(38.750 16.188) "GIOL" "lowerRight" "R0" "stick" 0.0625 nil)
schCreateWire(cv "route" "full" '((39.000 16.062) (38.250 16.062)) 0 0 0 nil nil)
schCreateWireLabel(cv nil '(38.750 16.062) "D6_CORE" "lowerRight" "R0" "stick" 0.0625 nil)
schCreatePin(cv nil "D6_CORE" "inputOutput" nil '(38.250 16.062) "R0")
schCreateWire(cv "route" "full" '((40.000 17.000) (40.750 17.000)) 0 0 0 nil nil)
schCreateWireLabel(cv nil '(40.250 17.000) "D6" "lowerLeft" "R0" "stick" 0.0625 nil)
schCreatePin(cv nil "D6" "inputOutput" nil '(40.750 17.000) "R180")
schCreateWire(cv "route" "full" '((39.000 16.688) (38.250 16.688)) 0 0 0 nil nil)
schCreateWireLabel(cv nil '(38.750 16.688) "POC" "lowerRight" "R0" "stick" 0.0625 nil)
schCreateWire(cv "route" "full" '((39.000 16.875) (38.250 16.875)) 0 0 0 nil nil)
schCreateWireLabel(cv nil '(38.750 16.875) "VIOL" "lowerRight" "R0" "stick" 0.0625 nil)
schCreateWire(cv "route" "full" '((39.000 17.062) (38.250 17.062)) 0 0 0 nil nil)
schCreateWireLabel(cv nil '(38.750 17.062) "GIOL" "lowerRight" "R0" "stick" 0.0625 nil)
schCreateWire(cv "route" "full" '((39.000 17.250) (38.250 17.250)) 0 0 0 nil nil)
schCreateWireLabel(cv nil '(38.750 17.250) "VIOH" "lowerRight" "R0" "stick" 0.0625 nil)
schCreateWire(cv "route" "full" '((39.000 17.625) (38.250 17.625)) 0 0 0 nil nil)
schCreateWireLabel(cv nil '(38.750 17.625) "GIOH" "lowerRight" "R0" "stick" 0.0625 nil)
dbCreateInst(cv pddw16sdgz_h_gMaster "D7_right8" '(40.0 18.3125) "R90")
schCreateWire(cv "route" "full" '((39.000 18.438) (38.250 18.438)) 0 0 0 nil nil)
schCreateWireLabel(cv nil '(38.750 18.438) "VIOL" "lowerRight" "R0" "stick" 0.0625 nil)
schCreateWire(cv "route" "full" '((39.000 18.562) (38.250 18.562)) 0 0 0 nil nil)
dbCreateInst(cv noConnMaster "noConn_D7_right8_C" '(38.250 18.562) "R270")
schCreateWire(cv "route" "full" '((39.000 18.188) (38.250 18.188)) 0 0 0 nil nil)
schCreateWireLabel(cv nil '(38.750 18.188) "GIOL" "lowerRight" "R0" "stick" 0.0625 nil)
schCreateWire(cv "route" "full" '((39.000 18.062) (38.250 18.062)) 0 0 0 nil nil)
schCreateWireLabel(cv nil '(38.750 18.062) "D7_CORE" "lowerRight" "R0" "stick" 0.0625 nil)
schCreatePin(cv nil "D7_CORE" "inputOutput" nil '(38.250 18.062) "R0")
schCreateWire(cv "route" "full" '((40.000 19.000) (40.750 19.000)) 0 0 0 nil nil)
schCreateWireLabel(cv nil '(40.250 19.000) "D7" "lowerLeft" "R0" "stick" 0.0625 nil)
schCreatePin(cv nil "D7" "inputOutput" nil '(40.750 19.000) "R180")
schCreateWire(cv "route" "full" '((39.000 18.688) (38.250 18.688)) 0 0 0 nil nil)
schCreateWireLabel(cv nil '(38.750 18.688) "POC" "lowerRight" "R0" "stick" 0.0625 nil)
schCreateWire(cv "route" "full" '((39.000 18.875) (38.250 18.875)) 0 0 0 nil nil)
schCreateWireLabel(cv nil '(38.750 18.875) "VIOL" "lowerRight" "R0" "stick" 0.0625 nil)
schCreateWire(cv "route" "full" '((39.000 19.062) (38.250 19.062)) 0 0 0 nil nil)
schCreateWireLabel(cv nil '(38.750 19.062) "GIOL" "lowerRight" "R0" "stick" 0.0625 nil)
schCreateWire(cv "route" "full" '((39.000 19.250) (38.250 19.250)) 0 0 0 nil nil)
schCreateWireLabel(cv nil '(38.750 19.250) "VIOH" "lowerRight" "R0" "stick" 0.0625 nil)
schCreateWire(cv "route" "full" '((39.000 19.625) (38.250 19.625)) 0 0 0 nil nil)
schCreateWireLabel(cv nil '(38.750 19.625) "GIOH" "lowerRight" "R0" "stick" 0.0625 nil)
dbCreateInst(cv pddw16sdgz_h_gMaster "D8_right9" '(40.0 20.3125) "R90")
schCreateWire(cv "route" "full" '((39.000 20.438) (38.250 20.438)) 0 0 0 nil nil)
schCreateWireLabel(cv nil '(38.750 20.438) "VIOL" "lowerRight" "R0" "stick" 0.0625 nil)
schCreateWire(cv "route" "full" '((39.000 20.562) (38.250 20.562)) 0 0 0 nil nil)
dbCreateInst(cv noConnMaster "noConn_D8_right9_C" '(38.250 20.562) "R270")
schCreateWire(cv "route" "full" '((39.000 20.188) (38.250 20.188)) 0 0 0 nil nil)
schCreateWireLabel(cv nil '(38.750 20.188) "GIOL" "lowerRight" "R0" "stick" 0.0625 nil)
schCreateWire(cv "route" "full" '((39.000 20.062) (38.250 20.062)) 0 0 0 nil nil)
schCreateWireLabel(cv nil '(38.750 20.062) "D8_CORE" "lowerRight" "R0" "stick" 0.0625 nil)
schCreatePin(cv nil "D8_CORE" "inputOutput" nil '(38.250 20.062) "R0")
schCreateWire(cv "route" "full" '((40.000 21.000) (40.750 21.000)) 0 0 0 nil nil)
schCreateWireLabel(cv nil '(40.250 21.000) "D8" "lowerLeft" "R0" "stick" 0.0625 nil)
schCreatePin(cv nil "D8" "inputOutput" nil '(40.750 21.000) "R180")
schCreateWire(cv "route" "full" '((39.000 20.688) (38.250 20.688)) 0 0 0 nil nil)
schCreateWireLabel(cv nil '(38.750 20.688) "POC" "lowerRight" "R0" "stick" 0.0625 nil)
schCreateWire(cv "route" "full" '((39.000 20.875) (38.250 20.875)) 0 0 0 nil nil)
schCreateWireLabel(cv nil '(38.750 20.875) "VIOL" "lowerRight" "R0" "stick" 0.0625 nil)
schCreateWire(cv "route" "full" '((39.000 21.062) (38.250 21.062)) 0 0 0 nil nil)
schCreateWireLabel(cv nil '(38.750 21.062) "GIOL" "lowerRight" "R0" "stick" 0.0625 nil)
schCreateWire(cv "route" "full" '((39.000 21.250) (38.250 21.250)) 0 0 0 nil nil)
schCreateWireLabel(cv nil '(38.750 21.250) "VIOH" "lowerRight" "R0" "stick" 0.0625 nil)
schCreateWire(cv "route" "full" '((39.000 21.625) (38.250 21.625)) 0 0 0 nil nil)
schCreateWireLabel(cv nil '(38.750 21.625) "GIOH" "lowerRight" "R0" "stick" 0.0625 nil)
dbCreateInst(cv pddw16sdgz_h_gMaster "D9_right10" '(40.0 22.3125) "R90")
schCreateWire(cv "route" "full" '((39.000 22.438) (38.250 22.438)) 0 0 0 nil nil)
schCreateWireLabel(cv nil '(38.750 22.438) "VIOL" "lowerRight" "R0" "stick" 0.0625 nil)
schCreateWire(cv "route" "full" '((39.000 22.562) (38.250 22.562)) 0 0 0 nil nil)
dbCreateInst(cv noConnMaster "noConn_D9_right10_C" '(38.250 22.562) "R270")
schCreateWire(cv "route" "full" '((39.000 22.188) (38.250 22.188)) 0 0 0 nil nil)
schCreateWireLabel(cv nil '(38.750 22.188) "GIOL" "lowerRight" "R0" "stick" 0.0625 nil)
schCreateWire(cv "route" "full" '((39.000 22.062) (38.250 22.062)) 0 0 0 nil nil)
schCreateWireLabel(cv nil '(38.750 22.062) "D9_CORE" "lowerRight" "R0" "stick" 0.0625 nil)
schCreatePin(cv nil "D9_CORE" "inputOutput" nil '(38.250 22.062) "R0")
schCreateWire(cv "route" "full" '((40.000 23.000) (40.750 23.000)) 0 0 0 nil nil)
schCreateWireLabel(cv nil '(40.250 23.000) "D9" "lowerLeft" "R0" "stick" 0.0625 nil)
schCreatePin(cv nil "D9" "inputOutput" nil '(40.750 23.000) "R180")
schCreateWire(cv "route" "full" '((39.000 22.688) (38.250 22.688)) 0 0 0 nil nil)
schCreateWireLabel(cv nil '(38.750 22.688) "POC" "lowerRight" "R0" "stick" 0.0625 nil)
schCreateWire(cv "route" "full" '((39.000 22.875) (38.250 22.875)) 0 0 0 nil nil)
schCreateWireLabel(cv nil '(38.750 22.875) "VIOL" "lowerRight" "R0" "stick" 0.0625 nil)
schCreateWire(cv "route" "full" '((39.000 23.062) (38.250 23.062)) 0 0 0 nil nil)
schCreateWireLabel(cv nil '(38.750 23.062) "GIOL" "lowerRight" "R0" "stick" 0.0625 nil)
schCreateWire(cv "route" "full" '((39.000 23.250) (38.250 23.250)) 0 0 0 nil nil)
schCreateWireLabel(cv nil '(38.750 23.250) "VIOH" "lowerRight" "R0" "stick" 0.0625 nil)
schCreateWire(cv "route" "full" '((39.000 23.625) (38.250 23.625)) 0 0 0 nil nil)
schCreateWireLabel(cv nil '(38.750 23.625) "GIOH" "lowerRight" "R0" "stick" 0.0625 nil)
dbCreateInst(cv pddw16sdgz_h_gMaster "D10_right11" '(40.0 24.3125) "R90")
schCreateWire(cv "route" "full" '((39.000 24.438) (38.250 24.438)) 0 0 0 nil nil)
schCreateWireLabel(cv nil '(38.750 24.438) "VIOL" "lowerRight" "R0" "stick" 0.0625 nil)
schCreateWire(cv "route" "full" '((39.000 24.562) (38.250 24.562)) 0 0 0 nil nil)
dbCreateInst(cv noConnMaster "noConn_D10_right11_C" '(38.250 24.562) "R270")
schCreateWire(cv "route" "full" '((39.000 24.188) (38.250 24.188)) 0 0 0 nil nil)
schCreateWireLabel(cv nil '(38.750 24.188) "GIOL" "lowerRight" "R0" "stick" 0.0625 nil)
schCreateWire(cv "route" "full" '((39.000 24.062) (38.250 24.062)) 0 0 0 nil nil)
schCreateWireLabel(cv nil '(38.750 24.062) "D10_CORE" "lowerRight" "R0" "stick" 0.0625 nil)
schCreatePin(cv nil "D10_CORE" "inputOutput" nil '(38.250 24.062) "R0")
schCreateWire(cv "route" "full" '((40.000 25.000) (40.750 25.000)) 0 0 0 nil nil)
schCreateWireLabel(cv nil '(40.250 25.000) "D10" "lowerLeft" "R0" "stick" 0.0625 nil)
schCreatePin(cv nil "D10" "inputOutput" nil '(40.750 25.000) "R180")
schCreateWire(cv "route" "full" '((39.000 24.688) (38.250 24.688)) 0 0 0 nil nil)
schCreateWireLabel(cv nil '(38.750 24.688) "POC" "lowerRight" "R0" "stick" 0.0625 nil)
schCreateWire(cv "route" "full" '((39.000 24.875) (38.250 24.875)) 0 0 0 nil nil)
schCreateWireLabel(cv nil '(38.750 24.875) "VIOL" "lowerRight" "R0" "stick" 0.0625 nil)
schCreateWire(cv "route" "full" '((39.000 25.062) (38.250 25.062)) 0 0 0 nil nil)
schCreateWireLabel(cv nil '(38.750 25.062) "GIOL" "lowerRight" "R0" "stick" 0.0625 nil)
schCreateWire(cv "route" "full" '((39.000 25.250) (38.250 25.250)) 0 0 0 nil nil)
schCreateWireLabel(cv nil '(38.750 25.250) "VIOH" "lowerRight" "R0" "stick" 0.0625 nil)
schCreateWire(cv "route" "full" '((39.000 25.625) (38.250 25.625)) 0 0 0 nil nil)
schCreateWireLabel(cv nil '(38.750 25.625) "GIOH" "lowerRight" "R0" "stick" 0.0625 nil)
pddw16sdgz_v_gMaster = dbOpenCellView("tphn28hpcpgv18" "PDDW16SDGZ_V_G" "symbol")
dbCreateInst(cv pddw16sdgz_v_gMaster "D11_top0" '(37.6875 28.0) "R180")
schCreateWire(cv "route" "full" '((37.562 27.000) (37.562 26.250)) 0 0 0 nil nil)
schCreateWireLabel(cv nil '(37.562 26.750) "VIOL" "lowerRight" "R90" "stick" 0.0625 nil)
schCreateWire(cv "route" "full" '((37.438 27.000) (37.438 26.250)) 0 0 0 nil nil)
dbCreateInst(cv noConnMaster "noConn_D11_top0_C" '(37.438 26.250) "R0")
schCreateWire(cv "route" "full" '((37.812 27.000) (37.812 26.250)) 0 0 0 nil nil)
schCreateWireLabel(cv nil '(37.812 26.750) "GIOL" "lowerRight" "R90" "stick" 0.0625 nil)
schCreateWire(cv "route" "full" '((37.938 27.000) (37.938 26.250)) 0 0 0 nil nil)
schCreateWireLabel(cv nil '(37.938 26.750) "D11_CORE" "lowerRight" "R90" "stick" 0.0625 nil)
schCreatePin(cv nil "D11_CORE" "inputOutput" nil '(37.938 26.250) "R90")
schCreateWire(cv "route" "full" '((36.999 28.000) (36.999 28.750)) 0 0 0 nil nil)
schCreateWireLabel(cv nil '(36.999 28.250) "D11" "lowerLeft" "R90" "stick" 0.0625 nil)
schCreatePin(cv nil "D11" "inputOutput" nil '(36.999 28.750) "R270")
schCreateWire(cv "route" "full" '((37.312 27.000) (37.312 26.250)) 0 0 0 nil nil)
schCreateWireLabel(cv nil '(37.312 26.750) "POC" "lowerRight" "R90" "stick" 0.0625 nil)
schCreateWire(cv "route" "full" '((37.126 27.000) (37.126 26.250)) 0 0 0 nil nil)
schCreateWireLabel(cv nil '(37.126 26.750) "VIOL" "lowerRight" "R90" "stick" 0.0625 nil)
schCreateWire(cv "route" "full" '((36.938 27.000) (36.938 26.250)) 0 0 0 nil nil)
schCreateWireLabel(cv nil '(36.938 26.750) "GIOL" "lowerRight" "R90" "stick" 0.0625 nil)
schCreateWire(cv "route" "full" '((36.749 27.000) (36.749 26.250)) 0 0 0 nil nil)
schCreateWireLabel(cv nil '(36.749 26.750) "VIOH" "lowerRight" "R90" "stick" 0.0625 nil)
schCreateWire(cv "route" "full" '((36.376 27.000) (36.376 26.250)) 0 0 0 nil nil)
schCreateWireLabel(cv nil '(36.376 26.750) "GIOH" "lowerRight" "R90" "stick" 0.0625 nil)
dbCreateInst(cv pddw16sdgz_v_gMaster "D12_top1" '(35.6875 28.0) "R180")
schCreateWire(cv "route" "full" '((35.562 27.000) (35.562 26.250)) 0 0 0 nil nil)
schCreateWireLabel(cv nil '(35.562 26.750) "VIOL" "lowerRight" "R90" "stick" 0.0625 nil)
schCreateWire(cv "route" "full" '((35.438 27.000) (35.438 26.250)) 0 0 0 nil nil)
dbCreateInst(cv noConnMaster "noConn_D12_top1_C" '(35.438 26.250) "R0")
schCreateWire(cv "route" "full" '((35.812 27.000) (35.812 26.250)) 0 0 0 nil nil)
schCreateWireLabel(cv nil '(35.812 26.750) "GIOL" "lowerRight" "R90" "stick" 0.0625 nil)
schCreateWire(cv "route" "full" '((35.938 27.000) (35.938 26.250)) 0 0 0 nil nil)
schCreateWireLabel(cv nil '(35.938 26.750) "D12_CORE" "lowerRight" "R90" "stick" 0.0625 nil)
schCreatePin(cv nil "D12_CORE" "inputOutput" nil '(35.938 26.250) "R90")
schCreateWire(cv "route" "full" '((34.999 28.000) (34.999 28.750)) 0 0 0 nil nil)
schCreateWireLabel(cv nil '(34.999 28.250) "D12" "lowerLeft" "R90" "stick" 0.0625 nil)
schCreatePin(cv nil "D12" "inputOutput" nil '(34.999 28.750) "R270")
schCreateWire(cv "route" "full" '((35.312 27.000) (35.312 26.250)) 0 0 0 nil nil)
schCreateWireLabel(cv nil '(35.312 26.750) "POC" "lowerRight" "R90" "stick" 0.0625 nil)
schCreateWire(cv "route" "full" '((35.126 27.000) (35.126 26.250)) 0 0 0 nil nil)
schCreateWireLabel(cv nil '(35.126 26.750) "VIOL" "lowerRight" "R90" "stick" 0.0625 nil)
schCreateWire(cv "route" "full" '((34.938 27.000) (34.938 26.250)) 0 0 0 nil nil)
schCreateWireLabel(cv nil '(34.938 26.750) "GIOL" "lowerRight" "R90" "stick" 0.0625 nil)
schCreateWire(cv "route" "full" '((34.749 27.000) (34.749 26.250)) 0 0 0 nil nil)
schCreateWireLabel(cv nil '(34.749 26.750) "VIOH" "lowerRight" "R90" "stick" 0.0625 nil)
schCreateWire(cv "route" "full" '((34.376 27.000) (34.376 26.250)) 0 0 0 nil nil)
schCreateWireLabel(cv nil '(34.376 26.750) "GIOH" "lowerRight" "R90" "stick" 0.0625 nil)
dbCreateInst(cv pddw16sdgz_v_gMaster "D14_top2" '(33.6875 28.0) "R180")
schCreateWire(cv "route" "full" '((33.562 27.000) (33.562 26.250)) 0 0 0 nil nil)
schCreateWireLabel(cv nil '(33.562 26.750) "VIOL" "lowerRight" "R90" "stick" 0.0625 nil)
schCreateWire(cv "route" "full" '((33.438 27.000) (33.438 26.250)) 0 0 0 nil nil)
dbCreateInst(cv noConnMaster "noConn_D14_top2_C" '(33.438 26.250) "R0")
schCreateWire(cv "route" "full" '((33.812 27.000) (33.812 26.250)) 0 0 0 nil nil)
schCreateWireLabel(cv nil '(33.812 26.750) "GIOL" "lowerRight" "R90" "stick" 0.0625 nil)
schCreateWire(cv "route" "full" '((33.938 27.000) (33.938 26.250)) 0 0 0 nil nil)
schCreateWireLabel(cv nil '(33.938 26.750) "D14_CORE" "lowerRight" "R90" "stick" 0.0625 nil)
schCreatePin(cv nil "D14_CORE" "inputOutput" nil '(33.938 26.250) "R90")
schCreateWire(cv "route" "full" '((32.999 28.000) (32.999 28.750)) 0 0 0 nil nil)
schCreateWireLabel(cv nil '(32.999 28.250) "D14" "lowerLeft" "R90" "stick" 0.0625 nil)
schCreatePin(cv nil "D14" "inputOutput" nil '(32.999 28.750) "R270")
schCreateWire(cv "route" "full" '((33.312 27.000) (33.312 26.250)) 0 0 0 nil nil)
schCreateWireLabel(cv nil '(33.312 26.750) "POC" "lowerRight" "R90" "stick" 0.0625 nil)
schCreateWire(cv "route" "full" '((33.126 27.000) (33.126 26.250)) 0 0 0 nil nil)
schCreateWireLabel(cv nil '(33.126 26.750) "VIOL" "lowerRight" "R90" "stick" 0.0625 nil)
schCreateWire(cv "route" "full" '((32.938 27.000) (32.938 26.250)) 0 0 0 nil nil)
schCreateWireLabel(cv nil '(32.938 26.750) "GIOL" "lowerRight" "R90" "stick" 0.0625 nil)
schCreateWire(cv "route" "full" '((32.749 27.000) (32.749 26.250)) 0 0 0 nil nil)
schCreateWireLabel(cv nil '(32.749 26.750) "VIOH" "lowerRight" "R90" "stick" 0.0625 nil)
schCreateWire(cv "route" "full" '((32.376 27.000) (32.376 26.250)) 0 0 0 nil nil)
schCreateWireLabel(cv nil '(32.376 26.750) "GIOH" "lowerRight" "R90" "stick" 0.0625 nil)
dbCreateInst(cv pddw16sdgz_v_gMaster "D13_top3" '(31.6875 28.0) "R180")
schCreateWire(cv "route" "full" '((31.562 27.000) (31.562 26.250)) 0 0 0 nil nil)
schCreateWireLabel(cv nil '(31.562 26.750) "VIOL" "lowerRight" "R90" "stick" 0.0625 nil)
schCreateWire(cv "route" "full" '((31.438 27.000) (31.438 26.250)) 0 0 0 nil nil)
dbCreateInst(cv noConnMaster "noConn_D13_top3_C" '(31.438 26.250) "R0")
schCreateWire(cv "route" "full" '((31.812 27.000) (31.812 26.250)) 0 0 0 nil nil)
schCreateWireLabel(cv nil '(31.812 26.750) "GIOL" "lowerRight" "R90" "stick" 0.0625 nil)
schCreateWire(cv "route" "full" '((31.938 27.000) (31.938 26.250)) 0 0 0 nil nil)
schCreateWireLabel(cv nil '(31.938 26.750) "D13_CORE" "lowerRight" "R90" "stick" 0.0625 nil)
schCreatePin(cv nil "D13_CORE" "inputOutput" nil '(31.938 26.250) "R90")
schCreateWire(cv "route" "full" '((31.000 28.000) (31.000 28.750)) 0 0 0 nil nil)
schCreateWireLabel(cv nil '(31.000 28.250) "D13" "lowerLeft" "R90" "stick" 0.0625 nil)
schCreatePin(cv nil "D13" "inputOutput" nil '(31.000 28.750) "R270")
schCreateWire(cv "route" "full" '((31.312 27.000) (31.312 26.250)) 0 0 0 nil nil)
schCreateWireLabel(cv nil '(31.312 26.750) "POC" "lowerRight" "R90" "stick" 0.0625 nil)
schCreateWire(cv "route" "full" '((31.125 27.000) (31.125 26.250)) 0 0 0 nil nil)
schCreateWireLabel(cv nil '(31.125 26.750) "VIOL" "lowerRight" "R90" "stick" 0.0625 nil)
schCreateWire(cv "route" "full" '((30.938 27.000) (30.938 26.250)) 0 0 0 nil nil)
schCreateWireLabel(cv nil '(30.938 26.750) "GIOL" "lowerRight" "R90" "stick" 0.0625 nil)
schCreateWire(cv "route" "full" '((30.750 27.000) (30.750 26.250)) 0 0 0 nil nil)
schCreateWireLabel(cv nil '(30.750 26.750) "VIOH" "lowerRight" "R90" "stick" 0.0625 nil)
schCreateWire(cv "route" "full" '((30.375 27.000) (30.375 26.250)) 0 0 0 nil nil)
schCreateWireLabel(cv nil '(30.375 26.750) "GIOH" "lowerRight" "R90" "stick" 0.0625 nil)
dbCreateInst(cv pddw16sdgz_v_gMaster "CLKO_top4" '(29.6875 28.0) "R180")
schCreateWire(cv "route" "full" '((29.562 27.000) (29.562 26.250)) 0 0 0 nil nil)
schCreateWireLabel(cv nil '(29.562 26.750) "VIOL" "lowerRight" "R90" "stick" 0.0625 nil)
schCreateWire(cv "route" "full" '((29.438 27.000) (29.438 26.250)) 0 0 0 nil nil)
dbCreateInst(cv noConnMaster "noConn_CLKO_top4_C" '(29.438 26.250) "R0")
schCreateWire(cv "route" "full" '((29.812 27.000) (29.812 26.250)) 0 0 0 nil nil)
schCreateWireLabel(cv nil '(29.812 26.750) "GIOL" "lowerRight" "R90" "stick" 0.0625 nil)
schCreateWire(cv "route" "full" '((29.938 27.000) (29.938 26.250)) 0 0 0 nil nil)
schCreateWireLabel(cv nil '(29.938 26.750) "CLKO_CORE" "lowerRight" "R90" "stick" 0.0625 nil)
schCreatePin(cv nil "CLKO_CORE" "inputOutput" nil '(29.938 26.250) "R90")
schCreateWire(cv "route" "full" '((29.000 28.000) (29.000 28.750)) 0 0 0 nil nil)
schCreateWireLabel(cv nil '(29.000 28.250) "CLKO" "lowerLeft" "R90" "stick" 0.0625 nil)
schCreatePin(cv nil "CLKO" "inputOutput" nil '(29.000 28.750) "R270")
schCreateWire(cv "route" "full" '((29.312 27.000) (29.312 26.250)) 0 0 0 nil nil)
schCreateWireLabel(cv nil '(29.312 26.750) "POC" "lowerRight" "R90" "stick" 0.0625 nil)
schCreateWire(cv "route" "full" '((29.125 27.000) (29.125 26.250)) 0 0 0 nil nil)
schCreateWireLabel(cv nil '(29.125 26.750) "VIOL" "lowerRight" "R90" "stick" 0.0625 nil)
schCreateWire(cv "route" "full" '((28.938 27.000) (28.938 26.250)) 0 0 0 nil nil)
schCreateWireLabel(cv nil '(28.938 26.750) "GIOL" "lowerRight" "R90" "stick" 0.0625 nil)
schCreateWire(cv "route" "full" '((28.750 27.000) (28.750 26.250)) 0 0 0 nil nil)
schCreateWireLabel(cv nil '(28.750 26.750) "VIOH" "lowerRight" "R90" "stick" 0.0625 nil)
schCreateWire(cv "route" "full" '((28.375 27.000) (28.375 26.250)) 0 0 0 nil nil)
schCreateWireLabel(cv nil '(28.375 26.750) "GIOH" "lowerRight" "R90" "stick" 0.0625 nil)
dbCreateInst(cv pddw16sdgz_v_gMaster "SLP_top5" '(27.6875 28.0) "R180")
schCreateWire(cv "route" "full" '((27.562 27.000) (27.562 26.250)) 0 0 0 nil nil)
schCreateWireLabel(cv nil '(27.562 26.750) "GIOL" "lowerRight" "R90" "stick" 0.0625 nil)
schCreateWire(cv "route" "full" '((27.438 27.000) (27.438 26.250)) 0 0 0 nil nil)
schCreateWireLabel(cv nil '(27.438 26.750) "SLP_CORE" "lowerRight" "R90" "stick" 0.0625 nil)
schCreatePin(cv nil "SLP_CORE" "inputOutput" nil '(27.438 26.250) "R90")
schCreateWire(cv "route" "full" '((27.812 27.000) (27.812 26.250)) 0 0 0 nil nil)
schCreateWireLabel(cv nil '(27.812 26.750) "VIOL" "lowerRight" "R90" "stick" 0.0625 nil)
schCreateWire(cv "route" "full" '((27.938 27.000) (27.938 26.250)) 0 0 0 nil nil)
schCreateWireLabel(cv nil '(27.938 26.750) "GIOL" "lowerRight" "R90" "stick" 0.0625 nil)
schCreateWire(cv "route" "full" '((27.000 28.000) (27.000 28.750)) 0 0 0 nil nil)
schCreateWireLabel(cv nil '(27.000 28.250) "SLP" "lowerLeft" "R90" "stick" 0.0625 nil)
schCreatePin(cv nil "SLP" "inputOutput" nil '(27.000 28.750) "R270")
schCreateWire(cv "route" "full" '((27.312 27.000) (27.312 26.250)) 0 0 0 nil nil)
schCreateWireLabel(cv nil '(27.312 26.750) "POC" "lowerRight" "R90" "stick" 0.0625 nil)
schCreateWire(cv "route" "full" '((27.125 27.000) (27.125 26.250)) 0 0 0 nil nil)
schCreateWireLabel(cv nil '(27.125 26.750) "VIOL" "lowerRight" "R90" "stick" 0.0625 nil)
schCreateWire(cv "route" "full" '((26.938 27.000) (26.938 26.250)) 0 0 0 nil nil)
schCreateWireLabel(cv nil '(26.938 26.750) "GIOL" "lowerRight" "R90" "stick" 0.0625 nil)
schCreateWire(cv "route" "full" '((26.750 27.000) (26.750 26.250)) 0 0 0 nil nil)
schCreateWireLabel(cv nil '(26.750 26.750) "VIOH" "lowerRight" "R90" "stick" 0.0625 nil)
schCreateWire(cv "route" "full" '((26.375 27.000) (26.375 26.250)) 0 0 0 nil nil)
schCreateWireLabel(cv nil '(26.375 26.750) "GIOH" "lowerRight" "R90" "stick" 0.0625 nil)
dbCreateInst(cv pddw16sdgz_v_gMaster "RST_top6" '(25.6875 28.0) "R180")
schCreateWire(cv "route" "full" '((25.562 27.000) (25.562 26.250)) 0 0 0 nil nil)
schCreateWireLabel(cv nil '(25.562 26.750) "GIOL" "lowerRight" "R90" "stick" 0.0625 nil)
schCreateWire(cv "route" "full" '((25.438 27.000) (25.438 26.250)) 0 0 0 nil nil)
schCreateWireLabel(cv nil '(25.438 26.750) "RST_CORE" "lowerRight" "R90" "stick" 0.0625 nil)
schCreatePin(cv nil "RST_CORE" "inputOutput" nil '(25.438 26.250) "R90")
schCreateWire(cv "route" "full" '((25.812 27.000) (25.812 26.250)) 0 0 0 nil nil)
schCreateWireLabel(cv nil '(25.812 26.750) "VIOL" "lowerRight" "R90" "stick" 0.0625 nil)
schCreateWire(cv "route" "full" '((25.938 27.000) (25.938 26.250)) 0 0 0 nil nil)
schCreateWireLabel(cv nil '(25.938 26.750) "GIOL" "lowerRight" "R90" "stick" 0.0625 nil)
schCreateWire(cv "route" "full" '((25.000 28.000) (25.000 28.750)) 0 0 0 nil nil)
schCreateWireLabel(cv nil '(25.000 28.250) "RST" "lowerLeft" "R90" "stick" 0.0625 nil)
schCreatePin(cv nil "RST" "inputOutput" nil '(25.000 28.750) "R270")
schCreateWire(cv "route" "full" '((25.312 27.000) (25.312 26.250)) 0 0 0 nil nil)
schCreateWireLabel(cv nil '(25.312 26.750) "POC" "lowerRight" "R90" "stick" 0.0625 nil)
schCreateWire(cv "route" "full" '((25.125 27.000) (25.125 26.250)) 0 0 0 nil nil)
schCreateWireLabel(cv nil '(25.125 26.750) "VIOL" "lowerRight" "R90" "stick" 0.0625 nil)
schCreateWire(cv "route" "full" '((24.938 27.000) (24.938 26.250)) 0 0 0 nil nil)
schCreateWireLabel(cv nil '(24.938 26.750) "GIOL" "lowerRight" "R90" "stick" 0.0625 nil)
schCreateWire(cv "route" "full" '((24.750 27.000) (24.750 26.250)) 0 0 0 nil nil)
schCreateWireLabel(cv nil '(24.750 26.750) "VIOH" "lowerRight" "R90" "stick" 0.0625 nil)
schCreateWire(cv "route" "full" '((24.375 27.000) (24.375 26.250)) 0 0 0 nil nil)
schCreateWireLabel(cv nil '(24.375 26.750) "GIOH" "lowerRight" "R90" "stick" 0.0625 nil)
dbCreateInst(cv pddw16sdgz_v_gMaster "SCK_top7" '(23.6875 28.0) "R180")
schCreateWire(cv "route" "full" '((23.562 27.000) (23.562 26.250)) 0 0 0 nil nil)
schCreateWireLabel(cv nil '(23.562 26.750) "GIOL" "lowerRight" "R90" "stick" 0.0625 nil)
schCreateWire(cv "route" "full" '((23.438 27.000) (23.438 26.250)) 0 0 0 nil nil)
schCreateWireLabel(cv nil '(23.438 26.750) "SCK_CORE" "lowerRight" "R90" "stick" 0.0625 nil)
schCreatePin(cv nil "SCK_CORE" "inputOutput" nil '(23.438 26.250) "R90")
schCreateWire(cv "route" "full" '((23.812 27.000) (23.812 26.250)) 0 0 0 nil nil)
schCreateWireLabel(cv nil '(23.812 26.750) "VIOL" "lowerRight" "R90" "stick" 0.0625 nil)
schCreateWire(cv "route" "full" '((23.938 27.000) (23.938 26.250)) 0 0 0 nil nil)
schCreateWireLabel(cv nil '(23.938 26.750) "GIOL" "lowerRight" "R90" "stick" 0.0625 nil)
schCreateWire(cv "route" "full" '((23.000 28.000) (23.000 28.750)) 0 0 0 nil nil)
schCreateWireLabel(cv nil '(23.000 28.250) "SCK" "lowerLeft" "R90" "stick" 0.0625 nil)
schCreatePin(cv nil "SCK" "inputOutput" nil '(23.000 28.750) "R270")
schCreateWire(cv "route" "full" '((23.312 27.000) (23.312 26.250)) 0 0 0 nil nil)
schCreateWireLabel(cv nil '(23.312 26.750) "POC" "lowerRight" "R90" "stick" 0.0625 nil)
schCreateWire(cv "route" "full" '((23.125 27.000) (23.125 26.250)) 0 0 0 nil nil)
schCreateWireLabel(cv nil '(23.125 26.750) "VIOL" "lowerRight" "R90" "stick" 0.0625 nil)
schCreateWire(cv "route" "full" '((22.938 27.000) (22.938 26.250)) 0 0 0 nil nil)
schCreateWireLabel(cv nil '(22.938 26.750) "GIOL" "lowerRight" "R90" "stick" 0.0625 nil)
schCreateWire(cv "route" "full" '((22.750 27.000) (22.750 26.250)) 0 0 0 nil nil)
schCreateWireLabel(cv nil '(22.750 26.750) "VIOH" "lowerRight" "R90" "stick" 0.0625 nil)
schCreateWire(cv "route" "full" '((22.375 27.000) (22.375 26.250)) 0 0 0 nil nil)
schCreateWireLabel(cv nil '(22.375 26.750) "GIOH" "lowerRight" "R90" "stick" 0.0625 nil)
dbCreateInst(cv pddw16sdgz_v_gMaster "SDI_top8" '(21.6875 28.0) "R180")
schCreateWire(cv "route" "full" '((21.562 27.000) (21.562 26.250)) 0 0 0 nil nil)
schCreateWireLabel(cv nil '(21.562 26.750) "GIOL" "lowerRight" "R90" "stick" 0.0625 nil)
schCreateWire(cv "route" "full" '((21.438 27.000) (21.438 26.250)) 0 0 0 nil nil)
schCreateWireLabel(cv nil '(21.438 26.750) "SDI_CORE" "lowerRight" "R90" "stick" 0.0625 nil)
schCreatePin(cv nil "SDI_CORE" "inputOutput" nil '(21.438 26.250) "R90")
schCreateWire(cv "route" "full" '((21.812 27.000) (21.812 26.250)) 0 0 0 nil nil)
schCreateWireLabel(cv nil '(21.812 26.750) "VIOL" "lowerRight" "R90" "stick" 0.0625 nil)
schCreateWire(cv "route" "full" '((21.938 27.000) (21.938 26.250)) 0 0 0 nil nil)
schCreateWireLabel(cv nil '(21.938 26.750) "GIOL" "lowerRight" "R90" "stick" 0.0625 nil)
schCreateWire(cv "route" "full" '((21.000 28.000) (21.000 28.750)) 0 0 0 nil nil)
schCreateWireLabel(cv nil '(21.000 28.250) "SDI" "lowerLeft" "R90" "stick" 0.0625 nil)
schCreatePin(cv nil "SDI" "inputOutput" nil '(21.000 28.750) "R270")
schCreateWire(cv "route" "full" '((21.312 27.000) (21.312 26.250)) 0 0 0 nil nil)
schCreateWireLabel(cv nil '(21.312 26.750) "POC" "lowerRight" "R90" "stick" 0.0625 nil)
schCreateWire(cv "route" "full" '((21.125 27.000) (21.125 26.250)) 0 0 0 nil nil)
schCreateWireLabel(cv nil '(21.125 26.750) "VIOL" "lowerRight" "R90" "stick" 0.0625 nil)
schCreateWire(cv "route" "full" '((20.938 27.000) (20.938 26.250)) 0 0 0 nil nil)
schCreateWireLabel(cv nil '(20.938 26.750) "GIOL" "lowerRight" "R90" "stick" 0.0625 nil)
schCreateWire(cv "route" "full" '((20.750 27.000) (20.750 26.250)) 0 0 0 nil nil)
schCreateWireLabel(cv nil '(20.750 26.750) "VIOH" "lowerRight" "R90" "stick" 0.0625 nil)
schCreateWire(cv "route" "full" '((20.375 27.000) (20.375 26.250)) 0 0 0 nil nil)
schCreateWireLabel(cv nil '(20.375 26.750) "GIOH" "lowerRight" "R90" "stick" 0.0625 nil)
dbCreateInst(cv pddw16sdgz_v_gMaster "SDO_top9" '(19.6875 28.0) "R180")
schCreateWire(cv "route" "full" '((19.562 27.000) (19.562 26.250)) 0 0 0 nil nil)
schCreateWireLabel(cv nil '(19.562 26.750) "VIOL" "lowerRight" "R90" "stick" 0.0625 nil)
schCreateWire(cv "route" "full" '((19.438 27.000) (19.438 26.250)) 0 0 0 nil nil)
dbCreateInst(cv noConnMaster "noConn_SDO_top9_C" '(19.438 26.250) "R0")
schCreateWire(cv "route" "full" '((19.812 27.000) (19.812 26.250)) 0 0 0 nil nil)
schCreateWireLabel(cv nil '(19.812 26.750) "GIOL" "lowerRight" "R90" "stick" 0.0625 nil)
schCreateWire(cv "route" "full" '((19.938 27.000) (19.938 26.250)) 0 0 0 nil nil)
schCreateWireLabel(cv nil '(19.938 26.750) "SDO_CORE" "lowerRight" "R90" "stick" 0.0625 nil)
schCreatePin(cv nil "SDO_CORE" "inputOutput" nil '(19.938 26.250) "R90")
schCreateWire(cv "route" "full" '((19.000 28.000) (19.000 28.750)) 0 0 0 nil nil)
schCreateWireLabel(cv nil '(19.000 28.250) "SDO" "lowerLeft" "R90" "stick" 0.0625 nil)
schCreatePin(cv nil "SDO" "inputOutput" nil '(19.000 28.750) "R270")
schCreateWire(cv "route" "full" '((19.312 27.000) (19.312 26.250)) 0 0 0 nil nil)
schCreateWireLabel(cv nil '(19.312 26.750) "POC" "lowerRight" "R90" "stick" 0.0625 nil)
schCreateWire(cv "route" "full" '((19.125 27.000) (19.125 26.250)) 0 0 0 nil nil)
schCreateWireLabel(cv nil '(19.125 26.750) "VIOL" "lowerRight" "R90" "stick" 0.0625 nil)
schCreateWire(cv "route" "full" '((18.938 27.000) (18.938 26.250)) 0 0 0 nil nil)
schCreateWireLabel(cv nil '(18.938 26.750) "GIOL" "lowerRight" "R90" "stick" 0.0625 nil)
schCreateWire(cv "route" "full" '((18.750 27.000) (18.750 26.250)) 0 0 0 nil nil)
schCreateWireLabel(cv nil '(18.750 26.750) "VIOH" "lowerRight" "R90" "stick" 0.0625 nil)
schCreateWire(cv "route" "full" '((18.375 27.000) (18.375 26.250)) 0 0 0 nil nil)
schCreateWireLabel(cv nil '(18.375 26.750) "GIOH" "lowerRight" "R90" "stick" 0.0625 nil)
pvdd2poc_v_gMaster = dbOpenCellView("tphn28hpcpgv18" "PVDD2POC_V_G" "symbol")
dbCreateInst(cv pvdd2poc_v_gMaster "VIOH_top10" '(18.0 28.0) "R180")
schCreateWire(cv "route" "full" '((17.625 27.000) (17.625 26.250)) 0 0 0 nil nil)
schCreateWireLabel(cv nil '(17.625 26.750) "POC" "lowerRight" "R90" "stick" 0.0625 nil)
schCreateWire(cv "route" "full" '((17.438 27.000) (17.438 26.250)) 0 0 0 nil nil)
schCreateWireLabel(cv nil '(17.438 26.750) "VIOL" "lowerRight" "R90" "stick" 0.0625 nil)
schCreateWire(cv "route" "full" '((17.250 27.000) (17.250 26.250)) 0 0 0 nil nil)
schCreateWireLabel(cv nil '(17.250 26.750) "GIOL" "lowerRight" "R90" "stick" 0.0625 nil)
schCreateWire(cv "route" "full" '((17.000 28.000) (17.000 28.750)) 0 0 0 nil nil)
schCreateWireLabel(cv nil '(17.000 28.250) "VIOH" "lowerLeft" "R90" "stick" 0.0625 nil)
schCreatePin(cv nil "VIOH" "inputOutput" nil '(17.000 28.750) "R270")
schCreateWire(cv "route" "full" '((16.688 27.000) (16.688 26.250)) 0 0 0 nil nil)
schCreateWireLabel(cv nil '(16.688 26.750) "GIOH" "lowerRight" "R90" "stick" 0.0625 nil)
pvdd1dgz_v_gMaster = dbOpenCellView("tphn28hpcpgv18" "PVDD1DGZ_V_G" "symbol")
dbCreateInst(cv pvdd1dgz_v_gMaster "VIOL_top11" '(16.0 28.0) "R180")
schCreateWire(cv "route" "full" '((15.625 27.000) (15.625 26.250)) 0 0 0 nil nil)
schCreateWireLabel(cv nil '(15.625 26.750) "POC" "lowerRight" "R90" "stick" 0.0625 nil)
schCreateWire(cv "route" "full" '((15.000 28.000) (15.000 28.750)) 0 0 0 nil nil)
schCreateWireLabel(cv nil '(15.000 28.250) "VIOL" "lowerLeft" "R90" "stick" 0.0625 nil)
schCreatePin(cv nil "VIOL" "inputOutput" nil '(15.000 28.750) "R270")
schCreateWire(cv "route" "full" '((15.250 27.000) (15.250 26.250)) 0 0 0 nil nil)
schCreateWireLabel(cv nil '(15.250 26.750) "GIOL" "lowerRight" "R90" "stick" 0.0625 nil)
schCreateWire(cv "route" "full" '((15.062 27.000) (15.062 26.250)) 0 0 0 nil nil)
schCreateWireLabel(cv nil '(15.062 26.750) "VIOH" "lowerRight" "R90" "stick" 0.0625 nil)
schCreateWire(cv "route" "full" '((14.688 27.000) (14.688 26.250)) 0 0 0 nil nil)
schCreateWireLabel(cv nil '(14.688 26.750) "GIOH" "lowerRight" "R90" "stick" 0.0625 nil)
pvss2dgz_v_gMaster = dbOpenCellView("tphn28hpcpgv18" "PVSS2DGZ_V_G" "symbol")
dbCreateInst(cv pvss2dgz_v_gMaster "GIOH_top12" '(14.0 28.0) "R180")
schCreateWire(cv "route" "full" '((13.625 27.000) (13.625 26.250)) 0 0 0 nil nil)
schCreateWireLabel(cv nil '(13.625 26.750) "POC" "lowerRight" "R90" "stick" 0.0625 nil)
schCreateWire(cv "route" "full" '((13.438 27.000) (13.438 26.250)) 0 0 0 nil nil)
schCreateWireLabel(cv nil '(13.438 26.750) "VIOL" "lowerRight" "R90" "stick" 0.0625 nil)
schCreateWire(cv "route" "full" '((13.250 27.000) (13.250 26.250)) 0 0 0 nil nil)
schCreateWireLabel(cv nil '(13.250 26.750) "GIOL" "lowerRight" "R90" "stick" 0.0625 nil)
schCreateWire(cv "route" "full" '((13.062 27.000) (13.062 26.250)) 0 0 0 nil nil)
schCreateWireLabel(cv nil '(13.062 26.750) "VIOH" "lowerRight" "R90" "stick" 0.0625 nil)
schCreateWire(cv "route" "full" '((13.000 28.000) (13.000 28.750)) 0 0 0 nil nil)
schCreateWireLabel(cv nil '(13.000 28.250) "GIOH" "lowerLeft" "R90" "stick" 0.0625 nil)
schCreatePin(cv nil "GIOH" "inputOutput" nil '(13.000 28.750) "R270")
pvss1dgz_v_gMaster = dbOpenCellView("tphn28hpcpgv18" "PVSS1DGZ_V_G" "symbol")
dbCreateInst(cv pvss1dgz_v_gMaster "GIOL_top13" '(12.0 28.0) "R180")
schCreateWire(cv "route" "full" '((11.625 27.000) (11.625 26.250)) 0 0 0 nil nil)
schCreateWireLabel(cv nil '(11.625 26.750) "POC" "lowerRight" "R90" "stick" 0.0625 nil)
schCreateWire(cv "route" "full" '((11.438 27.000) (11.438 26.250)) 0 0 0 nil nil)
schCreateWireLabel(cv nil '(11.438 26.750) "VIOL" "lowerRight" "R90" "stick" 0.0625 nil)
schCreateWire(cv "route" "full" '((11.000 28.000) (11.000 28.750)) 0 0 0 nil nil)
schCreateWireLabel(cv nil '(11.000 28.250) "GIOL" "lowerLeft" "R90" "stick" 0.0625 nil)
schCreatePin(cv nil "GIOL" "inputOutput" nil '(11.000 28.750) "R270")
schCreateWire(cv "route" "full" '((11.062 27.000) (11.062 26.250)) 0 0 0 nil nil)
schCreateWireLabel(cv nil '(11.062 26.750) "VIOH" "lowerRight" "R90" "stick" 0.0625 nil)
schCreateWire(cv "route" "full" '((10.688 27.000) (10.688 26.250)) 0 0 0 nil nil)
schCreateWireLabel(cv nil '(10.688 26.750) "GIOH" "lowerRight" "R90" "stick" 0.0625 nil)
dbCreateInst(cv pdb3ac_v_gMaster "VAMP_top14" '(8.8125 28.0) "R180")
schCreateWire(cv "route" "full" '((9.001 28.000) (9.001 28.750)) 0 0 0 nil nil)
schCreateWireLabel(cv nil '(9.001 28.250) "VAMP" "lowerLeft" "R90" "stick" 0.0625 nil)
schCreatePin(cv nil "VAMP" "inputOutput" nil '(9.001 28.750) "R270")
schCreateWire(cv "route" "full" '((9.062 27.125) (9.062 26.375)) 0 0 0 nil nil)
schCreateWireLabel(cv nil '(9.062 26.875) "VSSGM" "lowerRight" "R90" "stick" 0.0625 nil)
schCreateWire(cv "route" "full" '((8.688 27.125) (8.688 26.375)) 0 0 0 nil nil)
schCreateWireLabel(cv nil '(8.688 26.875) "GIOL" "lowerRight" "R90" "stick" 0.0625 nil)
schCreateWire(cv "route" "full" '((9.438 27.125) (9.438 26.375)) 0 0 0 nil nil)
schCreateWireLabel(cv nil '(9.438 26.875) "VDDGM" "lowerRight" "R90" "stick" 0.0625 nil)
dbCreateInst(cv pdb3ac_v_gMaster "IBIAS_top15" '(6.8125 28.0) "R180")
schCreateWire(cv "route" "full" '((7.000 28.000) (7.000 28.750)) 0 0 0 nil nil)
schCreateWireLabel(cv nil '(7.000 28.250) "IBIAS" "lowerLeft" "R90" "stick" 0.0625 nil)
schCreatePin(cv nil "IBIAS" "inputOutput" nil '(7.000 28.750) "R270")
schCreateWire(cv "route" "full" '((7.062 27.125) (7.062 26.375)) 0 0 0 nil nil)
schCreateWireLabel(cv nil '(7.062 26.875) "VSSGM" "lowerRight" "R90" "stick" 0.0625 nil)
schCreateWire(cv "route" "full" '((6.688 27.125) (6.688 26.375)) 0 0 0 nil nil)
schCreateWireLabel(cv nil '(6.688 26.875) "GIOL" "lowerRight" "R90" "stick" 0.0625 nil)
schCreateWire(cv "route" "full" '((7.438 27.125) (7.438 26.375)) 0 0 0 nil nil)
schCreateWireLabel(cv nil '(7.438 26.875) "VDDGM" "lowerRight" "R90" "stick" 0.0625 nil)
dbCreateInst(cv pdb3ac_v_gMaster "IBIAS2_top16" '(4.8125 28.0) "R180")
schCreateWire(cv "route" "full" '((5.000 28.000) (5.000 28.750)) 0 0 0 nil nil)
schCreateWireLabel(cv nil '(5.000 28.250) "IBIAS2" "lowerLeft" "R90" "stick" 0.0625 nil)
schCreatePin(cv nil "IBIAS2" "inputOutput" nil '(5.000 28.750) "R270")
schCreateWire(cv "route" "full" '((5.062 27.125) (5.062 26.375)) 0 0 0 nil nil)
schCreateWireLabel(cv nil '(5.062 26.875) "VSSGM" "lowerRight" "R90" "stick" 0.0625 nil)
schCreateWire(cv "route" "full" '((4.688 27.125) (4.688 26.375)) 0 0 0 nil nil)
schCreateWireLabel(cv nil '(4.688 26.875) "GIOL" "lowerRight" "R90" "stick" 0.0625 nil)
schCreateWire(cv "route" "full" '((5.438 27.125) (5.438 26.375)) 0 0 0 nil nil)
schCreateWireLabel(cv nil '(5.438 26.875) "VDDGM" "lowerRight" "R90" "stick" 0.0625 nil)
dbCreateInst(cv pdb3ac_v_gMaster "VREFIB_top17" '(2.8125 28.0) "R180")
schCreateWire(cv "route" "full" '((3.001 28.000) (3.001 28.750)) 0 0 0 nil nil)
schCreateWireLabel(cv nil '(3.001 28.250) "VREFIB" "lowerLeft" "R90" "stick" 0.0625 nil)
schCreatePin(cv nil "VREFIB" "inputOutput" nil '(3.001 28.750) "R270")
schCreateWire(cv "route" "full" '((3.062 27.125) (3.062 26.375)) 0 0 0 nil nil)
schCreateWireLabel(cv nil '(3.062 26.875) "VSSGM" "lowerRight" "R90" "stick" 0.0625 nil)
schCreateWire(cv "route" "full" '((2.688 27.125) (2.688 26.375)) 0 0 0 nil nil)
schCreateWireLabel(cv nil '(2.688 26.875) "GIOL" "lowerRight" "R90" "stick" 0.0625 nil)
schCreateWire(cv "route" "full" '((3.438 27.125) (3.438 26.375)) 0 0 0 nil nil)
schCreateWireLabel(cv nil '(3.438 26.875) "VDDGM" "lowerRight" "R90" "stick" 0.0625 nil)
schCheck(cv)
dbSave(cv)
t
